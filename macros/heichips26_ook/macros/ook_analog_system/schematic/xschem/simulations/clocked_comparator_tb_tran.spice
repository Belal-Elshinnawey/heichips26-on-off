** sch_path: /home/belal/HeiChips/heichips26-on-off/macros/heichips26_ook/macros/ook_analog_system/testbenches/xschem/clocked_comparator_tb_tran.sch
**.subckt clocked_comparator_tb_tran vout
*.iopin vout
x1 clk vref VDDL VDD vin vout VSS clocked_comparator_pex
VCLK clk VSS PULSE(0 {VDD} 0 0.5n 0.5n 49n 100n)
VDDSRC VDD VSS {VDD}
VDDLSRC VDDL VSS {VDD/2}
VREF vref VSS {VREF}
VIN vin VSS PWL(0 0 10u {VDD})
**** begin user architecture code

.param VDD=3.3
.param VREF=1.3
.options savecurrents klu reltol=1e-3 abstol=1e-12 vntol=1e-6 gmin=1e-12
.control
save clk vref vin vout VDD VDDL
tran 10n 10u
write clocked_comparator_tb_tran\.raw
meas tran vout_hi MAX v(vout)
meas tran vout_lo MIN v(vout)
meas tran cross_delay TRIG v(vin) VAL={VREF} RISE=1 TARG v(vout) VAL={VDD/2} CROSS=1
print vout_hi
print vout_lo
print cross_delay
plot vin vref vout
plot clk
.endc

.lib cornerMOSlv.lib mos_tt
.lib cornerMOShv.lib mos_tt
.lib cornerRES.lib res_typ
.lib cornerDIO.lib dio_tt
.lib cornerCAP.lib cap_typ
.include /home/belal/HeiChips/heichips26-on-off/macros/heichips26_ook/macros/ook_analog_system/netlist/pex/clocked_comparator_magic_pex_3.spice

**** end user architecture code
**.ends
.GLOBAL VDD
.GLOBAL VDDL
.GLOBAL VSS
.end
