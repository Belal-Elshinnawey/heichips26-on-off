** sch_path: /home/belal/HeiChips/heichips26-on-off/macros/heichips26_ook/macros/ook_analog_system/testbenches/xschem/level_up_shifter_tb_tran.sch
**.subckt level_up_shifter_tb_tran
x1 VDD2 A B VSS VDD1 level_up_shifter_pex
VA A VSS PULSE(0 {VDD/2} 0 0.5n 0.5n 49n 100n)
VDD2SRC VDD2 VSS {VDD}
VDD1SRC VDD1 VSS {VDD/2}
**** begin user architecture code

.param VDD=3.3
.options savecurrents klu reltol=1e-3 abstol=1e-12 vntol=1e-6 gmin=1e-12
.control
save A B VDD1 VDD2
tran 0.5n 1u
write level_up_shifter_tb_tran\.raw
meas tran a_hi MAX v(A)
meas tran a_lo MIN v(A)
meas tran b_hi MAX v(B)
meas tran b_lo MIN v(B)
print a_hi
print a_lo
print b_hi
print b_lo
plot A B
.endc

.lib cornerMOSlv.lib mos_tt
.lib cornerMOShv.lib mos_tt
.lib cornerRES.lib res_typ
.lib cornerDIO.lib dio_tt
.lib cornerCAP.lib cap_typ
.include /home/belal/HeiChips/heichips26-on-off/macros/heichips26_ook/macros/ook_analog_system/netlist/pex/level_up_shifter_magic_pex_3.spice

**** end user architecture code
**.ends
.GLOBAL VDD2
.GLOBAL VDD1
.GLOBAL VSS
.end
