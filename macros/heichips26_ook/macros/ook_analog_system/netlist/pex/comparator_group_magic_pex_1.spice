* PEX produced on Mon Sep 14 04:19:54 CEST 2026 using scripts/sak-pex.sh with m=1 and s=1
* NGSPICE file created from comparator_group_pex.ext - technology: ihp-sg13cmos5l

.subckt comparator_group_pex VDDL VDD vin q3 VSS q2 q1 q0 clk_h vref_1 vref_2
+ vref_3 vref_4
X0 VSS VSS VSS VSS sg13_hv_nmos ad=0.34p pd=2.68u as=0.89749n ps=2.23642m w=1u l=0.5u
X1 GROUP10_2.pmosHV$1_priv4_0.D GROUP10_2.pmosHV$1_priv4_0.D GROUP10_2.pmosHV$1_priv4_0.D VSS sg13_hv_nmos ad=0.34p pd=2.68u as=45.658p ps=0.23585m w=1u l=0.5u
X2 VDDL GROUP20_0.G GROUP16_0.pmosHV$2_priv10_0.D VDDL sg13_hv_pmos ad=1.36p pd=8.68u as=1.36p ps=8.68u w=4u l=0.5u
X3 GROUP22_0.G VDD clk_h VSS sg13_hv_nmos ad=0.38p pd=2.38u as=0.38p ps=2.38u w=2u l=0.5u
X4 GROUP22_3.G VDD clk_h VSS sg13_hv_nmos ad=0.38p pd=2.38u as=0.38p ps=2.38u w=2u l=0.5u
X5 clk_h VDD GROUP22_2.G VSS sg13_hv_nmos ad=0.38p pd=2.38u as=0.38p ps=2.38u w=2u l=0.5u
X6 GROUP22_0.G VSS clk_h VDD sg13_hv_pmos ad=0.38p pd=2.38u as=0.38p ps=2.38u w=2u l=0.5u
X7 GROUP20_0.G GROUP10_0.pmosHV$1_priv4_0.D VSS VSS sg13_hv_nmos ad=0.34p pd=2.68u as=0.34p ps=2.68u w=1u l=0.5u
X8 q0 q0 q0 VSS sg13_hv_nmos ad=0.34p pd=2.68u as=24.1098p ps=0.13178m w=1u l=0.5u
X9 clk_h VDD GROUP22_3.G VSS sg13_hv_nmos ad=0.38p pd=2.38u as=0.38p ps=2.38u w=2u l=0.5u
X10 GROUP22_2.G VDD clk_h VSS sg13_hv_nmos ad=0.38p pd=2.38u as=0.38p ps=2.38u w=2u l=0.5u
X11 VDDL GROUP12_3.nmosHV_priv10_0.S GROUP15_2.pmosHV$2_priv7_0.D VDDL sg13_hv_pmos ad=1.36p pd=8.68u as=1.36p ps=8.68u w=4u l=0.5u
X12 GROUP8_2.nmosHV_priv1_0.S GROUP8_2.nmosHV_priv1_0.S GROUP8_2.nmosHV_priv1_0.S VDD sg13_hv_pmos ad=1.7p pd=10.68u as=13.2594p ps=51.74u w=5u l=0.5u
X13 VDD GROUP22_2.G GROUP6_2.pmosHV_priv16_0.S VDD sg13_hv_pmos ad=1.7p pd=10.68u as=1.7p ps=10.68u w=5u l=0.5u
X14 GROUP13_1.pmosHV$2_priv1_0.D q1 GROUP19_0.G VDDL sg13_hv_pmos ad=1.36p pd=8.68u as=1.36p ps=8.68u w=4u l=0.5u
X15 clk_h VDD GROUP22_3.G VSS sg13_hv_nmos ad=0.38p pd=2.38u as=0.38p ps=2.38u w=2u l=0.5u
X16 GROUP22_2.G VDD clk_h VSS sg13_hv_nmos ad=0.68p pd=4.68u as=0.38p ps=2.38u w=2u l=0.5u
X17 GROUP8_1.nmosHV_priv1_0.S GROUP10_0.pmosHV$1_priv4_0.D GROUP20_0.G VDD sg13_hv_pmos ad=0.68p pd=4.68u as=0.68p ps=4.68u w=2u l=0.5u
X18 clk_h VSS GROUP22_2.G VDD sg13_hv_pmos ad=0.38p pd=2.38u as=0.68p ps=4.68u w=2u l=0.5u
X19 VDDL VDDL VDDL VDDL sg13_hv_pmos ad=1.36p pd=8.68u as=58.2984p ps=0.21976m w=4u l=0.5u
X20 GROUP10_1.pmosHV$1_priv4_0.S GROUP10_1.pmosHV$1_priv4_0.S GROUP10_1.pmosHV$1_priv4_0.S VSS sg13_hv_nmos ad=0.34p pd=2.68u as=13.2594p ps=51.74u w=1u l=0.5u
X21 GROUP10_2.pmosHV$1_priv4_0.S GROUP22_2.G VSS VSS sg13_hv_nmos ad=0.34p pd=2.68u as=0.34p ps=2.68u w=1u l=0.5u
X22 GROUP10_0.pmosHV$1_priv4_0.S GROUP10_0.pmosHV$1_priv4_0.S GROUP10_0.pmosHV$1_priv4_0.S VDD sg13_hv_pmos ad=1.7p pd=10.68u as=13.2594p ps=51.74u w=5u l=0.5u
X23 GROUP12_1.nmosHV_priv10_0.S GROUP12_1.nmosHV_priv10_0.S GROUP12_1.nmosHV_priv10_0.S VDD sg13_hv_pmos ad=0.68p pd=4.68u as=45.658p ps=0.23585m w=2u l=0.5u
X24 clk_h clk_h clk_h VSS sg13_hv_nmos ad=0.68p pd=4.68u as=45.4488p ps=0.33232m w=2u l=0.5u
X25 GROUP6_2.pmosHV_priv16_0.S GROUP6_2.pmosHV_priv16_0.S GROUP6_2.pmosHV_priv16_0.S VDD sg13_hv_pmos ad=1.7p pd=10.68u as=21.6594p ps=79.74u w=5u l=0.5u
X26 GROUP10_0.pmosHV$1_priv4_0.D GROUP20_0.G VSS VSS sg13_hv_nmos ad=0.34p pd=2.68u as=0.34p ps=2.68u w=1u l=0.5u
X27 GROUP22_1.G VDD clk_h VSS sg13_hv_nmos ad=0.68p pd=4.68u as=0.38p ps=2.38u w=2u l=0.5u
X28 q0 GROUP20_1.G VSS VSS sg13_hv_nmos ad=0.34p pd=2.68u as=0.34p ps=2.68u w=1u l=0.5u
X29 GROUP20_0.G GROUP20_0.G GROUP20_0.G VDD sg13_hv_pmos ad=0.68p pd=4.68u as=45.5261p ps=0.23483m w=2u l=0.5u
X30 VSS VSS VSS VSS sg13_hv_nmos ad=0.34p pd=2.68u as=0 ps=0 w=1u l=0.5u
X31 clk_h VSS GROUP22_1.G VDD sg13_hv_pmos ad=0.38p pd=2.38u as=0.68p ps=4.68u w=2u l=0.5u
X32 GROUP19_3.G GROUP19_3.G GROUP19_3.G VDDL sg13_hv_pmos ad=1.36p pd=8.68u as=24.5292p ps=0.13411m w=4u l=0.5u
X33 clk_h VSS GROUP22_1.G VDD sg13_hv_pmos ad=0.38p pd=2.38u as=0.38p ps=2.38u w=2u l=0.5u
X34 VSS VSS VSS VSS sg13_hv_nmos ad=0.34p pd=2.68u as=0 ps=0 w=1u l=0.5u
X35 GROUP19_0.G GROUP19_0.G GROUP19_0.G VSS sg13_hv_nmos ad=0.34p pd=2.68u as=24.5292p ps=0.13411m w=1u l=0.5u
X36 GROUP8_3.nmosHV_priv1_0.S GROUP8_3.nmosHV_priv1_0.S GROUP8_3.nmosHV_priv1_0.S VDD sg13_hv_pmos ad=0.68p pd=4.68u as=13.2594p ps=51.74u w=2u l=0.5u
X37 GROUP8_0.nmosHV_priv1_0.S GROUP22_1.G VSS VSS sg13_hv_nmos ad=0.34p pd=2.68u as=0.34p ps=2.68u w=1u l=0.5u
X38 VDD VDD VDD VDD sg13_hv_pmos ad=1.7p pd=10.68u as=0.23354n ps=0.73308m w=5u l=0.5u
X39 VSS VSS VSS VSS sg13_hv_nmos ad=0.34p pd=2.68u as=0 ps=0 w=1u l=0.5u
X40 GROUP22_1.G VSS clk_h VDD sg13_hv_pmos ad=0.38p pd=2.38u as=0.38p ps=2.38u w=2u l=0.5u
X41 GROUP22_0.G VSS clk_h VDD sg13_hv_pmos ad=0.38p pd=2.38u as=0.38p ps=2.38u w=2u l=0.5u
X42 GROUP22_0.G VSS clk_h VDD sg13_hv_pmos ad=0.38p pd=2.38u as=0.38p ps=2.38u w=2u l=0.5u
X43 GROUP8_0.nmosHV_priv1_0.S GROUP12_1.nmosHV_priv10_0.S GROUP20_1.G VDD sg13_hv_pmos ad=0.68p pd=4.68u as=0.68p ps=4.68u w=2u l=0.5u
X44 VDDL GROUP20_2.G GROUP14_2.pmosHV$2_priv4_0.S VDDL sg13_hv_pmos ad=1.36p pd=8.68u as=1.36p ps=8.68u w=4u l=0.5u
X45 clk_h VDD GROUP22_0.G VSS sg13_hv_nmos ad=0.38p pd=2.38u as=0.38p ps=2.38u w=2u l=0.5u
X46 clk_h VDD GROUP22_3.G VSS sg13_hv_nmos ad=0.38p pd=2.38u as=0.38p ps=2.38u w=2u l=0.5u
X47 GROUP22_2.G VDD clk_h VSS sg13_hv_nmos ad=0.38p pd=2.38u as=0.38p ps=2.38u w=2u l=0.5u
X48 clk_h VDD GROUP22_2.G VSS sg13_hv_nmos ad=0.38p pd=2.38u as=0.38p ps=2.38u w=2u l=0.5u
X49 GROUP22_2.G VSS clk_h VDD sg13_hv_pmos ad=0.38p pd=2.38u as=0.38p ps=2.38u w=2u l=0.5u
X50 GROUP10_1.pmosHV$1_priv4_0.S GROUP10_1.pmosHV$1_priv4_0.S GROUP10_1.pmosHV$1_priv4_0.S VDD sg13_hv_pmos ad=1.7p pd=10.68u as=0 ps=0 w=5u l=0.5u
X51 GROUP22_3.G VDD clk_h VSS sg13_hv_nmos ad=0.38p pd=2.38u as=0.38p ps=2.38u w=2u l=0.5u
X52 clk_h VDD GROUP22_2.G VSS sg13_hv_nmos ad=0.38p pd=2.38u as=0.38p ps=2.38u w=2u l=0.5u
X53 GROUP15_0.pmosHV$2_priv7_0.D GROUP15_0.pmosHV$2_priv7_0.D GROUP15_0.pmosHV$2_priv7_0.D VDDL sg13_hv_pmos ad=1.36p pd=8.68u as=12.0396p ps=45.16u w=4u l=0.5u
X54 GROUP13_3.pmosHV$2_priv1_0.D q3 GROUP19_2.G VDDL sg13_hv_pmos ad=1.36p pd=8.68u as=1.36p ps=8.68u w=4u l=0.5u
X55 VDD GROUP22_3.G GROUP6_3.pmosHV_priv16_0.S VDD sg13_hv_pmos ad=1.7p pd=10.68u as=1.7p ps=10.68u w=5u l=0.5u
X56 GROUP10_0.pmosHV$1_priv4_0.S GROUP20_0.G GROUP10_0.pmosHV$1_priv4_0.D VDD sg13_hv_pmos ad=0.68p pd=4.68u as=0.68p ps=4.68u w=2u l=0.5u
X57 GROUP22_3.G VDD clk_h VSS sg13_hv_nmos ad=0.68p pd=4.68u as=0.38p ps=2.38u w=2u l=0.5u
X58 q1 q1 q1 VSS sg13_hv_nmos ad=0.34p pd=2.68u as=24.1098p ps=0.13178m w=1u l=0.5u
X59 GROUP19_2.G GROUP10_2.pmosHV$1_priv4_0.D VSS VSS sg13_hv_nmos ad=0.34p pd=2.68u as=0.34p ps=2.68u w=1u l=0.5u
X60 clk_h VSS GROUP22_3.G VDD sg13_hv_pmos ad=0.38p pd=2.38u as=0.68p ps=4.68u w=2u l=0.5u
X61 GROUP6_0.pmosHV_priv16_0.S vin GROUP8_1.nmosHV_priv1_0.S VDD sg13_hv_pmos ad=1.7p pd=10.68u as=1.7p ps=10.68u w=5u l=0.5u
X62 GROUP8_3.nmosHV_priv1_0.S GROUP22_3.G VSS VSS sg13_hv_nmos ad=0.34p pd=2.68u as=0.34p ps=2.68u w=1u l=0.5u
X63 GROUP22_1.G VDD clk_h VSS sg13_hv_nmos ad=0.38p pd=2.38u as=0.38p ps=2.38u w=2u l=0.5u
X64 clk_h clk_h clk_h VSS sg13_hv_nmos ad=0.68p pd=4.68u as=0 ps=0 w=2u l=0.5u
X65 VSS VSS VSS VSS sg13_hv_nmos ad=0.34p pd=2.68u as=0 ps=0 w=1u l=0.5u
X66 GROUP13_1.pmosHV$2_priv1_0.D GROUP13_1.pmosHV$2_priv1_0.D GROUP13_1.pmosHV$2_priv1_0.D VDDL sg13_hv_pmos ad=1.36p pd=8.68u as=12.0396p ps=45.16u w=4u l=0.5u
X67 q2 GROUP22_3.nmosHV_priv28_0.D VSS VSS sg13_hv_nmos ad=0.34p pd=2.68u as=0.34p ps=2.68u w=1u l=0.5u
X68 VSS VSS VSS VSS sg13_hv_nmos ad=0.34p pd=2.68u as=0 ps=0 w=1u l=0.5u
X69 GROUP10_0.pmosHV$1_priv4_0.S GROUP10_0.pmosHV$1_priv4_0.S GROUP10_0.pmosHV$1_priv4_0.S VSS sg13_hv_nmos ad=0.34p pd=2.68u as=0 ps=0 w=1u l=0.5u
X70 GROUP6_0.pmosHV_priv16_0.S GROUP6_0.pmosHV_priv16_0.S GROUP6_0.pmosHV_priv16_0.S VDD sg13_hv_pmos ad=1.7p pd=10.68u as=21.6594p ps=79.74u w=5u l=0.5u
X71 GROUP22_2.G GROUP22_2.G GROUP22_2.G VDD sg13_hv_pmos ad=0.68p pd=4.68u as=71.9421p ps=0.3071m w=2u l=0.5u
X72 VSS VSS VSS VSS sg13_hv_nmos ad=0.34p pd=2.68u as=0 ps=0 w=1u l=0.5u
X73 GROUP15_0.pmosHV$2_priv7_0.D q0 GROUP16_1.G VDDL sg13_hv_pmos ad=1.36p pd=8.68u as=1.36p ps=8.68u w=4u l=0.5u
X74 VDDL VDDL VDDL VDDL sg13_hv_pmos ad=1.36p pd=8.68u as=0 ps=0 w=4u l=0.5u
X75 GROUP6_2.pmosHV_priv16_0.S vin GROUP8_2.nmosHV_priv1_0.S VDD sg13_hv_pmos ad=1.7p pd=10.68u as=1.7p ps=10.68u w=5u l=0.5u
X76 GROUP20_0.G GROUP22_0.G VSS VSS sg13_hv_nmos ad=0.34p pd=2.68u as=0.34p ps=2.68u w=1u l=0.5u
X77 GROUP10_0.pmosHV$1_priv4_0.D GROUP10_0.pmosHV$1_priv4_0.D GROUP10_0.pmosHV$1_priv4_0.D VDD sg13_hv_pmos ad=0.68p pd=4.68u as=45.658p ps=0.23585m w=2u l=0.5u
X78 GROUP16_1.G GROUP12_1.nmosHV_priv10_0.S VSS VSS sg13_hv_nmos ad=0.34p pd=2.68u as=0.34p ps=2.68u w=1u l=0.5u
X79 GROUP20_0.G GROUP20_0.G GROUP20_0.G VSS sg13_hv_nmos ad=0.34p pd=2.68u as=0 ps=0 w=1u l=0.5u
X80 q3 q3 q3 VDDL sg13_hv_pmos ad=1.36p pd=8.68u as=24.1098p ps=0.13178m w=4u l=0.5u
X81 GROUP10_3.pmosHV$1_priv4_0.S GROUP10_3.pmosHV$1_priv4_0.S GROUP10_3.pmosHV$1_priv4_0.S VDD sg13_hv_pmos ad=0.68p pd=4.68u as=13.2594p ps=51.74u w=2u l=0.5u
X82 VSS VSS VSS VSS sg13_hv_nmos ad=0.34p pd=2.68u as=0 ps=0 w=1u l=0.5u
X83 GROUP20_2.G GROUP20_2.G GROUP20_2.G VDD sg13_hv_pmos ad=0.68p pd=4.68u as=45.5261p ps=0.23483m w=2u l=0.5u
X84 GROUP10_2.pmosHV$1_priv4_0.S GROUP10_2.pmosHV$1_priv4_0.S GROUP10_2.pmosHV$1_priv4_0.S VSS sg13_hv_nmos ad=0.34p pd=2.68u as=13.2594p ps=51.74u w=1u l=0.5u
X85 VDD VDD VDD VDD sg13_hv_pmos ad=1.7p pd=10.68u as=0 ps=0 w=5u l=0.5u
X86 GROUP22_1.G VSS clk_h VDD sg13_hv_pmos ad=0.38p pd=2.38u as=0.38p ps=2.38u w=2u l=0.5u
X87 clk_h VSS GROUP22_1.G VDD sg13_hv_pmos ad=0.38p pd=2.38u as=0.38p ps=2.38u w=2u l=0.5u
X88 VSS VSS VSS VSS sg13_hv_nmos ad=0.34p pd=2.68u as=0 ps=0 w=1u l=0.5u
X89 clk_h VSS GROUP22_1.G VDD sg13_hv_pmos ad=0.38p pd=2.38u as=0.38p ps=2.38u w=2u l=0.5u
X90 GROUP10_1.pmosHV$1_priv4_0.S GROUP20_1.G GROUP12_1.nmosHV_priv10_0.S VDD sg13_hv_pmos ad=0.68p pd=4.68u as=0.68p ps=4.68u w=2u l=0.5u
X91 clk_h VDD GROUP22_0.G VSS sg13_hv_nmos ad=0.38p pd=2.38u as=0.68p ps=4.68u w=2u l=0.5u
X92 clk_h VSS GROUP22_0.G VDD sg13_hv_pmos ad=0.38p pd=2.38u as=0.38p ps=2.38u w=2u l=0.5u
X93 GROUP8_3.nmosHV_priv1_0.S GROUP8_3.nmosHV_priv1_0.S GROUP8_3.nmosHV_priv1_0.S VDD sg13_hv_pmos ad=1.7p pd=10.68u as=0 ps=0 w=5u l=0.5u
X94 VSS VSS VSS VSS sg13_hv_nmos ad=0.34p pd=2.68u as=0 ps=0 w=1u l=0.5u
X95 GROUP22_3.G VDD clk_h VSS sg13_hv_nmos ad=0.38p pd=2.38u as=0.38p ps=2.38u w=2u l=0.5u
X96 clk_h VDD GROUP22_2.G VSS sg13_hv_nmos ad=0.38p pd=2.38u as=0.38p ps=2.38u w=2u l=0.5u
X97 VSS VSS VSS VSS sg13_hv_nmos ad=0.34p pd=2.68u as=0 ps=0 w=1u l=0.5u
X98 GROUP22_1.G GROUP22_1.G GROUP22_1.G VSS sg13_hv_nmos ad=0.68p pd=4.68u as=71.9421p ps=0.3071m w=2u l=0.5u
X99 clk_h VSS GROUP22_0.G VDD sg13_hv_pmos ad=0.38p pd=2.38u as=0.38p ps=2.38u w=2u l=0.5u
X100 GROUP22_0.G VSS clk_h VDD sg13_hv_pmos ad=0.38p pd=2.38u as=0.38p ps=2.38u w=2u l=0.5u
X101 VDDL GROUP22_3.nmosHV_priv28_0.D GROUP16_3.pmosHV$2_priv10_0.D VDDL sg13_hv_pmos ad=1.36p pd=8.68u as=1.36p ps=8.68u w=4u l=0.5u
X102 GROUP10_0.pmosHV$1_priv4_0.D GROUP10_0.pmosHV$1_priv4_0.D GROUP10_0.pmosHV$1_priv4_0.D VSS sg13_hv_nmos ad=0.34p pd=2.68u as=0 ps=0 w=1u l=0.5u
X103 GROUP22_3.G VDD clk_h VSS sg13_hv_nmos ad=0.38p pd=2.38u as=0.38p ps=2.38u w=2u l=0.5u
X104 clk_h VDD GROUP22_2.G VSS sg13_hv_nmos ad=0.38p pd=2.38u as=0.38p ps=2.38u w=2u l=0.5u
X105 GROUP22_0.G VSS clk_h VDD sg13_hv_pmos ad=0.68p pd=4.68u as=0.38p ps=2.38u w=2u l=0.5u
X106 GROUP22_3.G VSS clk_h VDD sg13_hv_pmos ad=0.38p pd=2.38u as=0.38p ps=2.38u w=2u l=0.5u
X107 GROUP22_3.nmosHV_priv28_0.D GROUP12_3.nmosHV_priv10_0.S VSS VSS sg13_hv_nmos ad=0.34p pd=2.68u as=0.34p ps=2.68u w=1u l=0.5u
X108 VSS VSS VSS VSS sg13_hv_nmos ad=0.34p pd=2.68u as=0 ps=0 w=1u l=0.5u
X109 GROUP16_0.pmosHV$2_priv10_0.D GROUP19_0.G q1 VDDL sg13_hv_pmos ad=1.36p pd=8.68u as=1.36p ps=8.68u w=4u l=0.5u
X110 clk_h clk_h clk_h VDD sg13_hv_pmos ad=0.68p pd=4.68u as=0 ps=0 w=2u l=0.5u
X111 GROUP15_2.pmosHV$2_priv7_0.D q2 GROUP19_3.G VDDL sg13_hv_pmos ad=1.36p pd=8.68u as=1.36p ps=8.68u w=4u l=0.5u
X112 GROUP19_3.G GROUP12_3.nmosHV_priv10_0.S VSS VSS sg13_hv_nmos ad=0.34p pd=2.68u as=0.34p ps=2.68u w=1u l=0.5u
X113 GROUP8_0.nmosHV_priv1_0.S GROUP8_0.nmosHV_priv1_0.S GROUP8_0.nmosHV_priv1_0.S VSS sg13_hv_nmos ad=0.34p pd=2.68u as=13.2594p ps=51.74u w=1u l=0.5u
X114 GROUP20_1.G GROUP20_1.G GROUP20_1.G VSS sg13_hv_nmos ad=0.34p pd=2.68u as=45.5261p ps=0.23483m w=1u l=0.5u
X115 GROUP13_1.pmosHV$2_priv1_0.D GROUP13_1.pmosHV$2_priv1_0.D GROUP13_1.pmosHV$2_priv1_0.D VDDL sg13_hv_pmos ad=1.36p pd=8.68u as=0 ps=0 w=4u l=0.5u
X116 GROUP8_2.nmosHV_priv1_0.S GROUP22_2.G VSS VSS sg13_hv_nmos ad=0.34p pd=2.68u as=0.34p ps=2.68u w=1u l=0.5u
X117 GROUP6_1.pmosHV_priv16_0.S GROUP6_1.pmosHV_priv16_0.S GROUP6_1.pmosHV_priv16_0.S VDD sg13_hv_pmos ad=1.7p pd=10.68u as=21.6594p ps=79.74u w=5u l=0.5u
X118 clk_h VDD GROUP22_1.G VSS sg13_hv_nmos ad=0.38p pd=2.38u as=0.38p ps=2.38u w=2u l=0.5u
X119 VDDL VDDL VDDL VDDL sg13_hv_pmos ad=1.36p pd=8.68u as=0 ps=0 w=4u l=0.5u
X120 clk_h clk_h clk_h VSS sg13_hv_nmos ad=0.68p pd=4.68u as=0 ps=0 w=2u l=0.5u
X121 VSS VSS VSS VSS sg13_hv_nmos ad=0.34p pd=2.68u as=0 ps=0 w=1u l=0.5u
X122 GROUP10_2.pmosHV$1_priv4_0.S GROUP10_2.pmosHV$1_priv4_0.S GROUP10_2.pmosHV$1_priv4_0.S VDD sg13_hv_pmos ad=1.7p pd=10.68u as=0 ps=0 w=5u l=0.5u
X123 GROUP20_2.G GROUP22_2.G VSS VSS sg13_hv_nmos ad=0.34p pd=2.68u as=0.34p ps=2.68u w=1u l=0.5u
X124 GROUP10_2.pmosHV$1_priv4_0.D GROUP10_2.pmosHV$1_priv4_0.D GROUP10_2.pmosHV$1_priv4_0.D VDD sg13_hv_pmos ad=0.68p pd=4.68u as=0 ps=0 w=2u l=0.5u
X125 GROUP12_3.nmosHV_priv10_0.S GROUP22_3.nmosHV_priv28_0.D VSS VSS sg13_hv_nmos ad=0.34p pd=2.68u as=0.34p ps=2.68u w=1u l=0.5u
X126 GROUP22_3.G GROUP22_3.G GROUP22_3.G VDD sg13_hv_pmos ad=0.68p pd=4.68u as=71.9421p ps=0.3071m w=2u l=0.5u
X127 GROUP20_2.G GROUP20_2.G GROUP20_2.G VSS sg13_hv_nmos ad=0.34p pd=2.68u as=0 ps=0 w=1u l=0.5u
X128 q2 q2 q2 VDDL sg13_hv_pmos ad=1.36p pd=8.68u as=24.1098p ps=0.13178m w=4u l=0.5u
X129 GROUP22_0.G VDD clk_h VSS sg13_hv_nmos ad=0.38p pd=2.38u as=0.38p ps=2.38u w=2u l=0.5u
X130 VSS VSS VSS VSS sg13_hv_nmos ad=0.34p pd=2.68u as=0 ps=0 w=1u l=0.5u
X131 GROUP22_3.nmosHV_priv28_0.D GROUP22_3.nmosHV_priv28_0.D GROUP22_3.nmosHV_priv28_0.D VDD sg13_hv_pmos ad=0.68p pd=4.68u as=45.5261p ps=0.23483m w=2u l=0.5u
X132 clk_h VSS GROUP22_1.G VDD sg13_hv_pmos ad=0.38p pd=2.38u as=0.38p ps=2.38u w=2u l=0.5u
X133 GROUP6_1.pmosHV_priv16_0.S vin GROUP8_0.nmosHV_priv1_0.S VDD sg13_hv_pmos ad=1.7p pd=10.68u as=1.7p ps=10.68u w=5u l=0.5u
X134 GROUP19_3.G GROUP19_3.G GROUP19_3.G VSS sg13_hv_nmos ad=0.34p pd=2.68u as=0 ps=0 w=1u l=0.5u
X135 GROUP15_0.pmosHV$2_priv7_0.D GROUP15_0.pmosHV$2_priv7_0.D GROUP15_0.pmosHV$2_priv7_0.D VDDL sg13_hv_pmos ad=1.36p pd=8.68u as=0 ps=0 w=4u l=0.5u
X136 GROUP22_3.G VSS clk_h VDD sg13_hv_pmos ad=0.38p pd=2.38u as=0.38p ps=2.38u w=2u l=0.5u
X137 clk_h VSS GROUP22_2.G VDD sg13_hv_pmos ad=0.38p pd=2.38u as=0.38p ps=2.38u w=2u l=0.5u
X138 GROUP10_0.pmosHV$1_priv4_0.D GROUP22_0.G VSS VSS sg13_hv_nmos ad=0.34p pd=2.68u as=0.34p ps=2.68u w=1u l=0.5u
X139 GROUP20_1.G GROUP20_1.G GROUP20_1.G VSS sg13_hv_nmos ad=0.34p pd=2.68u as=0 ps=0 w=1u l=0.5u
X140 q2 q2 q2 VSS sg13_hv_nmos ad=0.34p pd=2.68u as=0 ps=0 w=1u l=0.5u
X141 q1 GROUP20_0.G VSS VSS sg13_hv_nmos ad=0.34p pd=2.68u as=0.34p ps=2.68u w=1u l=0.5u
X142 VSS VSS VSS VSS sg13_hv_nmos ad=0.34p pd=2.68u as=0 ps=0 w=1u l=0.5u
X143 clk_h VDD GROUP22_3.G VSS sg13_hv_nmos ad=0.38p pd=2.38u as=0.38p ps=2.38u w=2u l=0.5u
X144 GROUP22_2.G VDD clk_h VSS sg13_hv_nmos ad=0.38p pd=2.38u as=0.38p ps=2.38u w=2u l=0.5u
X145 VSS VSS VSS VSS sg13_hv_nmos ad=0.34p pd=2.68u as=0 ps=0 w=1u l=0.5u
X146 clk_h VSS GROUP22_0.G VDD sg13_hv_pmos ad=0.38p pd=2.38u as=0.38p ps=2.38u w=2u l=0.5u
X147 GROUP20_2.G GROUP10_2.pmosHV$1_priv4_0.D VSS VSS sg13_hv_nmos ad=0.34p pd=2.68u as=0.34p ps=2.68u w=1u l=0.5u
X148 clk_h VDD GROUP22_3.G VSS sg13_hv_nmos ad=0.38p pd=2.38u as=0.38p ps=2.38u w=2u l=0.5u
X149 GROUP16_1.G GROUP16_1.G GROUP16_1.G VSS sg13_hv_nmos ad=0.34p pd=2.68u as=24.5292p ps=0.13411m w=1u l=0.5u
X150 GROUP10_2.pmosHV$1_priv4_0.D GROUP10_2.pmosHV$1_priv4_0.D GROUP10_2.pmosHV$1_priv4_0.D VSS sg13_hv_nmos ad=0.34p pd=2.68u as=0 ps=0 w=1u l=0.5u
X151 GROUP16_1.pmosHV$2_priv10_0.D GROUP16_1.pmosHV$2_priv10_0.D GROUP16_1.pmosHV$2_priv10_0.D VDDL sg13_hv_pmos ad=1.36p pd=8.68u as=12.0396p ps=45.16u w=4u l=0.5u
X152 GROUP22_3.nmosHV_priv28_0.D GROUP22_3.nmosHV_priv28_0.D GROUP22_3.nmosHV_priv28_0.D VSS sg13_hv_nmos ad=0.34p pd=2.68u as=0 ps=0 w=1u l=0.5u
X153 GROUP14_2.pmosHV$2_priv4_0.S GROUP19_2.G q3 VDDL sg13_hv_pmos ad=1.36p pd=8.68u as=1.36p ps=8.68u w=4u l=0.5u
X154 VSS VSS VSS VSS sg13_hv_nmos ad=0.34p pd=2.68u as=0 ps=0 w=1u l=0.5u
X155 GROUP22_0.G GROUP22_0.G GROUP22_0.G VSS sg13_hv_nmos ad=0.68p pd=4.68u as=71.9421p ps=0.3071m w=2u l=0.5u
X156 GROUP8_2.nmosHV_priv1_0.S GROUP10_2.pmosHV$1_priv4_0.D GROUP20_2.G VDD sg13_hv_pmos ad=0.68p pd=4.68u as=0.68p ps=4.68u w=2u l=0.5u
X157 q2 q2 q2 VSS sg13_hv_nmos ad=0.34p pd=2.68u as=0 ps=0 w=1u l=0.5u
X158 clk_h VDD GROUP22_1.G VSS sg13_hv_nmos ad=0.38p pd=2.38u as=0.68p ps=4.68u w=2u l=0.5u
X159 clk_h clk_h clk_h VDD sg13_hv_pmos ad=0.68p pd=4.68u as=0 ps=0 w=2u l=0.5u
X160 GROUP16_0.pmosHV$2_priv10_0.D GROUP16_0.pmosHV$2_priv10_0.D GROUP16_0.pmosHV$2_priv10_0.D VDDL sg13_hv_pmos ad=1.36p pd=8.68u as=12.0396p ps=45.16u w=4u l=0.5u
X161 GROUP6_3.pmosHV_priv16_0.S vin GROUP8_3.nmosHV_priv1_0.S VDD sg13_hv_pmos ad=1.7p pd=10.68u as=1.7p ps=10.68u w=5u l=0.5u
X162 GROUP8_1.nmosHV_priv1_0.S GROUP8_1.nmosHV_priv1_0.S GROUP8_1.nmosHV_priv1_0.S VSS sg13_hv_nmos ad=0.34p pd=2.68u as=13.2594p ps=51.74u w=1u l=0.5u
X163 VSS VSS VSS VSS sg13_hv_nmos ad=0.34p pd=2.68u as=0 ps=0 w=1u l=0.5u
X164 GROUP12_1.nmosHV_priv10_0.S GROUP12_1.nmosHV_priv10_0.S GROUP12_1.nmosHV_priv10_0.S VSS sg13_hv_nmos ad=0.34p pd=2.68u as=0 ps=0 w=1u l=0.5u
X165 GROUP22_1.G VDD clk_h VSS sg13_hv_nmos ad=0.38p pd=2.38u as=0.38p ps=2.38u w=2u l=0.5u
X166 GROUP22_1.G VSS clk_h VDD sg13_hv_pmos ad=0.68p pd=4.68u as=0.38p ps=2.38u w=2u l=0.5u
X167 VSS VSS VSS VSS sg13_hv_nmos ad=0.34p pd=2.68u as=0 ps=0 w=1u l=0.5u
X168 GROUP6_0.pmosHV_priv16_0.S GROUP6_0.pmosHV_priv16_0.S GROUP6_0.pmosHV_priv16_0.S VDD sg13_hv_pmos ad=1.7p pd=10.68u as=0 ps=0 w=5u l=0.5u
X169 GROUP15_2.pmosHV$2_priv7_0.D GROUP15_2.pmosHV$2_priv7_0.D GROUP15_2.pmosHV$2_priv7_0.D VDDL sg13_hv_pmos ad=1.36p pd=8.68u as=12.0396p ps=45.16u w=4u l=0.5u
X170 GROUP10_3.pmosHV$1_priv4_0.S GROUP10_3.pmosHV$1_priv4_0.S GROUP10_3.pmosHV$1_priv4_0.S VSS sg13_hv_nmos ad=0.34p pd=2.68u as=0 ps=0 w=1u l=0.5u
X171 GROUP10_2.pmosHV$1_priv4_0.D GROUP20_2.G VSS VSS sg13_hv_nmos ad=0.34p pd=2.68u as=0.34p ps=2.68u w=1u l=0.5u
X172 VDDL VDDL VDDL VDDL sg13_hv_pmos ad=1.36p pd=8.68u as=0 ps=0 w=4u l=0.5u
X173 GROUP16_1.pmosHV$2_priv10_0.D GROUP16_1.G q0 VDDL sg13_hv_pmos ad=1.36p pd=8.68u as=1.36p ps=8.68u w=4u l=0.5u
X174 GROUP8_2.nmosHV_priv1_0.S GROUP8_2.nmosHV_priv1_0.S GROUP8_2.nmosHV_priv1_0.S VSS sg13_hv_nmos ad=0.34p pd=2.68u as=0 ps=0 w=1u l=0.5u
X175 GROUP6_2.pmosHV_priv16_0.S GROUP6_2.pmosHV_priv16_0.S GROUP6_2.pmosHV_priv16_0.S VDD sg13_hv_pmos ad=1.7p pd=10.68u as=0 ps=0 w=5u l=0.5u
X176 GROUP12_3.nmosHV_priv10_0.S GROUP12_3.nmosHV_priv10_0.S GROUP12_3.nmosHV_priv10_0.S VDD sg13_hv_pmos ad=0.68p pd=4.68u as=45.658p ps=0.23585m w=2u l=0.5u
X177 clk_h VDD GROUP22_0.G VSS sg13_hv_nmos ad=0.38p pd=2.38u as=0.38p ps=2.38u w=2u l=0.5u
X178 GROUP22_3.nmosHV_priv28_0.D GROUP22_3.nmosHV_priv28_0.D GROUP22_3.nmosHV_priv28_0.D VSS sg13_hv_nmos ad=0.34p pd=2.68u as=0 ps=0 w=1u l=0.5u
X179 VSS VSS VSS VSS sg13_hv_nmos ad=0.34p pd=2.68u as=0 ps=0 w=1u l=0.5u
X180 GROUP19_2.G GROUP19_2.G GROUP19_2.G VSS sg13_hv_nmos ad=0.34p pd=2.68u as=24.5292p ps=0.13411m w=1u l=0.5u
X181 GROUP6_0.pmosHV_priv16_0.S vref_2 GROUP10_0.pmosHV$1_priv4_0.S VDD sg13_hv_pmos ad=1.7p pd=10.68u as=1.7p ps=10.68u w=5u l=0.5u
X182 GROUP22_2.G VSS clk_h VDD sg13_hv_pmos ad=0.38p pd=2.38u as=0.38p ps=2.38u w=2u l=0.5u
X183 VSS VSS VSS VSS sg13_hv_nmos ad=0.34p pd=2.68u as=0 ps=0 w=1u l=0.5u
X184 clk_h VDD GROUP22_3.G VSS sg13_hv_nmos ad=0.38p pd=2.38u as=0.68p ps=4.68u w=2u l=0.5u
X185 clk_h VSS GROUP22_0.G VDD sg13_hv_pmos ad=0.38p pd=2.38u as=0.38p ps=2.38u w=2u l=0.5u
X186 clk_h VSS GROUP22_3.G VDD sg13_hv_pmos ad=0.38p pd=2.38u as=0.38p ps=2.38u w=2u l=0.5u
X187 GROUP22_2.G VSS clk_h VDD sg13_hv_pmos ad=0.38p pd=2.38u as=0.38p ps=2.38u w=2u l=0.5u
X188 clk_h VSS GROUP22_2.G VDD sg13_hv_pmos ad=0.38p pd=2.38u as=0.38p ps=2.38u w=2u l=0.5u
X189 GROUP6_2.pmosHV_priv16_0.S vref_4 GROUP10_2.pmosHV$1_priv4_0.S VDD sg13_hv_pmos ad=1.7p pd=10.68u as=1.7p ps=10.68u w=5u l=0.5u
X190 clk_h VSS GROUP22_2.G VDD sg13_hv_pmos ad=0.38p pd=2.38u as=0.38p ps=2.38u w=2u l=0.5u
X191 q0 q0 q0 VSS sg13_hv_nmos ad=0.34p pd=2.68u as=0 ps=0 w=1u l=0.5u
X192 GROUP22_3.G VSS clk_h VDD sg13_hv_pmos ad=0.38p pd=2.38u as=0.38p ps=2.38u w=2u l=0.5u
X193 GROUP20_1.G GROUP22_1.G VSS VSS sg13_hv_nmos ad=0.34p pd=2.68u as=0.34p ps=2.68u w=1u l=0.5u
X194 GROUP10_2.pmosHV$1_priv4_0.S GROUP20_2.G GROUP10_2.pmosHV$1_priv4_0.D VDD sg13_hv_pmos ad=0.68p pd=4.68u as=0.68p ps=4.68u w=2u l=0.5u
X195 GROUP12_3.nmosHV_priv10_0.S GROUP12_3.nmosHV_priv10_0.S GROUP12_3.nmosHV_priv10_0.S VSS sg13_hv_nmos ad=0.34p pd=2.68u as=0 ps=0 w=1u l=0.5u
X196 GROUP22_3.G VSS clk_h VDD sg13_hv_pmos ad=0.68p pd=4.68u as=0.38p ps=2.38u w=2u l=0.5u
X197 GROUP8_3.nmosHV_priv1_0.S GROUP12_3.nmosHV_priv10_0.S GROUP22_3.nmosHV_priv28_0.D VDD sg13_hv_pmos ad=0.68p pd=4.68u as=0.68p ps=4.68u w=2u l=0.5u
X198 VSS VSS VSS VSS sg13_hv_nmos ad=0.34p pd=2.68u as=0 ps=0 w=1u l=0.5u
X199 q3 q3 q3 VSS sg13_hv_nmos ad=0.34p pd=2.68u as=0 ps=0 w=1u l=0.5u
X200 GROUP16_3.pmosHV$2_priv10_0.D GROUP19_3.G q2 VDDL sg13_hv_pmos ad=1.36p pd=8.68u as=1.36p ps=8.68u w=4u l=0.5u
X201 GROUP19_0.G GROUP19_0.G GROUP19_0.G VSS sg13_hv_nmos ad=0.34p pd=2.68u as=0 ps=0 w=1u l=0.5u
X202 GROUP19_0.G q1 VSS VSS sg13_hv_nmos ad=0.34p pd=2.68u as=0.34p ps=2.68u w=1u l=0.5u
X203 GROUP19_0.G GROUP19_0.G GROUP19_0.G VDDL sg13_hv_pmos ad=1.36p pd=8.68u as=0 ps=0 w=4u l=0.5u
X204 q3 GROUP20_2.G VSS VSS sg13_hv_nmos ad=0.34p pd=2.68u as=0.34p ps=2.68u w=1u l=0.5u
X205 GROUP16_0.pmosHV$2_priv10_0.D GROUP16_0.pmosHV$2_priv10_0.D GROUP16_0.pmosHV$2_priv10_0.D VDDL sg13_hv_pmos ad=1.36p pd=8.68u as=0 ps=0 w=4u l=0.5u
X206 GROUP22_1.G VDD clk_h VSS sg13_hv_nmos ad=0.38p pd=2.38u as=0.38p ps=2.38u w=2u l=0.5u
X207 GROUP15_2.pmosHV$2_priv7_0.D GROUP15_2.pmosHV$2_priv7_0.D GROUP15_2.pmosHV$2_priv7_0.D VDDL sg13_hv_pmos ad=1.36p pd=8.68u as=0 ps=0 w=4u l=0.5u
X208 GROUP10_3.pmosHV$1_priv4_0.S GROUP10_3.pmosHV$1_priv4_0.S GROUP10_3.pmosHV$1_priv4_0.S VDD sg13_hv_pmos ad=1.7p pd=10.68u as=0 ps=0 w=5u l=0.5u
X209 VSS VSS VSS VSS sg13_hv_nmos ad=0.34p pd=2.68u as=0 ps=0 w=1u l=0.5u
X210 VDDL GROUP12_1.nmosHV_priv10_0.S GROUP15_0.pmosHV$2_priv7_0.D VDDL sg13_hv_pmos ad=1.36p pd=8.68u as=1.36p ps=8.68u w=4u l=0.5u
X211 clk_h VDD GROUP22_1.G VSS sg13_hv_nmos ad=0.38p pd=2.38u as=0.38p ps=2.38u w=2u l=0.5u
X212 GROUP10_0.pmosHV$1_priv4_0.D GROUP10_0.pmosHV$1_priv4_0.D GROUP10_0.pmosHV$1_priv4_0.D VSS sg13_hv_nmos ad=0.34p pd=2.68u as=0 ps=0 w=1u l=0.5u
X213 GROUP13_3.pmosHV$2_priv1_0.D GROUP13_3.pmosHV$2_priv1_0.D GROUP13_3.pmosHV$2_priv1_0.D VDDL sg13_hv_pmos ad=1.36p pd=8.68u as=12.0396p ps=45.16u w=4u l=0.5u
X214 VDDL VDDL VDDL VDDL sg13_hv_pmos ad=1.36p pd=8.68u as=0 ps=0 w=4u l=0.5u
X215 clk_h VDD GROUP22_1.G VSS sg13_hv_nmos ad=0.38p pd=2.38u as=0.38p ps=2.38u w=2u l=0.5u
X216 clk_h VDD GROUP22_0.G VSS sg13_hv_nmos ad=0.38p pd=2.38u as=0.38p ps=2.38u w=2u l=0.5u
X217 GROUP6_3.pmosHV_priv16_0.S GROUP6_3.pmosHV_priv16_0.S GROUP6_3.pmosHV_priv16_0.S VDD sg13_hv_pmos ad=1.7p pd=10.68u as=21.6594p ps=79.74u w=5u l=0.5u
X218 q1 q1 q1 VSS sg13_hv_nmos ad=0.34p pd=2.68u as=0 ps=0 w=1u l=0.5u
X219 VDD GROUP22_0.G GROUP6_0.pmosHV_priv16_0.S VDD sg13_hv_pmos ad=1.7p pd=10.68u as=1.7p ps=10.68u w=5u l=0.5u
X220 q1 GROUP19_0.G VSS VSS sg13_hv_nmos ad=0.34p pd=2.68u as=0.34p ps=2.68u w=1u l=0.5u
X221 VSS VSS VSS VSS sg13_hv_nmos ad=0.34p pd=2.68u as=0 ps=0 w=1u l=0.5u
X222 GROUP6_3.pmosHV_priv16_0.S GROUP6_3.pmosHV_priv16_0.S GROUP6_3.pmosHV_priv16_0.S VDD sg13_hv_pmos ad=1.7p pd=10.68u as=0 ps=0 w=5u l=0.5u
X223 GROUP20_0.G GROUP20_0.G GROUP20_0.G VSS sg13_hv_nmos ad=0.34p pd=2.68u as=0 ps=0 w=1u l=0.5u
X224 GROUP6_1.pmosHV_priv16_0.S GROUP6_1.pmosHV_priv16_0.S GROUP6_1.pmosHV_priv16_0.S VDD sg13_hv_pmos ad=1.7p pd=10.68u as=0 ps=0 w=5u l=0.5u
X225 GROUP6_1.pmosHV_priv16_0.S GROUP6_1.pmosHV_priv16_0.S GROUP6_1.pmosHV_priv16_0.S VDD sg13_hv_pmos ad=1.7p pd=10.68u as=0 ps=0 w=5u l=0.5u
X226 GROUP16_1.pmosHV$2_priv10_0.D GROUP16_1.pmosHV$2_priv10_0.D GROUP16_1.pmosHV$2_priv10_0.D VDDL sg13_hv_pmos ad=1.36p pd=8.68u as=0 ps=0 w=4u l=0.5u
X227 VSS VSS VSS VSS sg13_hv_nmos ad=0.34p pd=2.68u as=0 ps=0 w=1u l=0.5u
X228 clk_h VDD GROUP22_2.G VSS sg13_hv_nmos ad=0.38p pd=2.38u as=0.68p ps=4.68u w=2u l=0.5u
X229 clk_h VSS GROUP22_0.G VDD sg13_hv_pmos ad=0.38p pd=2.38u as=0.68p ps=4.68u w=2u l=0.5u
X230 GROUP22_0.G VSS clk_h VDD sg13_hv_pmos ad=0.38p pd=2.38u as=0.38p ps=2.38u w=2u l=0.5u
X231 GROUP10_0.pmosHV$1_priv4_0.S GROUP22_0.G VSS VSS sg13_hv_nmos ad=0.34p pd=2.68u as=0.34p ps=2.68u w=1u l=0.5u
X232 GROUP22_3.G VSS clk_h VDD sg13_hv_pmos ad=0.38p pd=2.38u as=0.38p ps=2.38u w=2u l=0.5u
X233 clk_h VSS GROUP22_3.G VDD sg13_hv_pmos ad=0.38p pd=2.38u as=0.38p ps=2.38u w=2u l=0.5u
X234 GROUP22_2.G VSS clk_h VDD sg13_hv_pmos ad=0.38p pd=2.38u as=0.38p ps=2.38u w=2u l=0.5u
X235 GROUP16_1.G GROUP16_1.G GROUP16_1.G VDDL sg13_hv_pmos ad=1.36p pd=8.68u as=0 ps=0 w=4u l=0.5u
X236 VSS VSS VSS VSS sg13_hv_nmos ad=0.34p pd=2.68u as=0 ps=0 w=1u l=0.5u
X237 GROUP8_0.nmosHV_priv1_0.S GROUP8_0.nmosHV_priv1_0.S GROUP8_0.nmosHV_priv1_0.S VDD sg13_hv_pmos ad=0.68p pd=4.68u as=0 ps=0 w=2u l=0.5u
X238 VSS VSS VSS VSS sg13_hv_nmos ad=0.34p pd=2.68u as=0 ps=0 w=1u l=0.5u
X239 clk_h VSS GROUP22_3.G VDD sg13_hv_pmos ad=0.38p pd=2.38u as=0.38p ps=2.38u w=2u l=0.5u
X240 GROUP22_2.G VSS clk_h VDD sg13_hv_pmos ad=0.68p pd=4.68u as=0.38p ps=2.38u w=2u l=0.5u
X241 GROUP10_3.pmosHV$1_priv4_0.S GROUP22_3.nmosHV_priv28_0.D GROUP12_3.nmosHV_priv10_0.S VDD sg13_hv_pmos ad=0.68p pd=4.68u as=0.68p ps=4.68u w=2u l=0.5u
X242 VDDL VDDL VDDL VDDL sg13_hv_pmos ad=1.36p pd=8.68u as=0 ps=0 w=4u l=0.5u
X243 VSS VSS VSS VSS sg13_hv_nmos ad=0.34p pd=2.68u as=0 ps=0 w=1u l=0.5u
X244 GROUP6_1.pmosHV_priv16_0.S vref_1 GROUP10_1.pmosHV$1_priv4_0.S VDD sg13_hv_pmos ad=1.7p pd=10.68u as=1.7p ps=10.68u w=5u l=0.5u
X245 GROUP22_3.G GROUP22_3.G GROUP22_3.G VSS sg13_hv_nmos ad=0.68p pd=4.68u as=0 ps=0 w=2u l=0.5u
X246 GROUP19_2.G q3 VSS VSS sg13_hv_nmos ad=0.34p pd=2.68u as=0.34p ps=2.68u w=1u l=0.5u
X247 GROUP13_3.pmosHV$2_priv1_0.D GROUP13_3.pmosHV$2_priv1_0.D GROUP13_3.pmosHV$2_priv1_0.D VDDL sg13_hv_pmos ad=1.36p pd=8.68u as=0 ps=0 w=4u l=0.5u
X248 clk_h VDD GROUP22_1.G VSS sg13_hv_nmos ad=0.38p pd=2.38u as=0.38p ps=2.38u w=2u l=0.5u
X249 clk_h VSS GROUP22_1.G VDD sg13_hv_pmos ad=0.38p pd=2.38u as=0.38p ps=2.38u w=2u l=0.5u
X250 VSS VSS VSS VSS sg13_hv_nmos ad=0.34p pd=2.68u as=0 ps=0 w=1u l=0.5u
X251 GROUP22_1.G VDD clk_h VSS sg13_hv_nmos ad=0.38p pd=2.38u as=0.38p ps=2.38u w=2u l=0.5u
X252 clk_h clk_h clk_h VDD sg13_hv_pmos ad=0.68p pd=4.68u as=0 ps=0 w=2u l=0.5u
X253 VSS VSS VSS VSS sg13_hv_nmos ad=0.34p pd=2.68u as=0 ps=0 w=1u l=0.5u
X254 GROUP16_3.pmosHV$2_priv10_0.D GROUP16_3.pmosHV$2_priv10_0.D GROUP16_3.pmosHV$2_priv10_0.D VDDL sg13_hv_pmos ad=1.36p pd=8.68u as=12.0396p ps=45.16u w=4u l=0.5u
X255 GROUP22_0.G VDD clk_h VSS sg13_hv_nmos ad=0.38p pd=2.38u as=0.38p ps=2.38u w=2u l=0.5u
X256 GROUP8_1.nmosHV_priv1_0.S GROUP8_1.nmosHV_priv1_0.S GROUP8_1.nmosHV_priv1_0.S VDD sg13_hv_pmos ad=1.7p pd=10.68u as=0 ps=0 w=5u l=0.5u
X257 GROUP8_3.nmosHV_priv1_0.S GROUP8_3.nmosHV_priv1_0.S GROUP8_3.nmosHV_priv1_0.S VSS sg13_hv_nmos ad=0.34p pd=2.68u as=0 ps=0 w=1u l=0.5u
X258 GROUP22_0.G VDD clk_h VSS sg13_hv_nmos ad=0.38p pd=2.38u as=0.38p ps=2.38u w=2u l=0.5u
X259 VDDL GROUP10_0.pmosHV$1_priv4_0.D GROUP13_1.pmosHV$2_priv1_0.D VDDL sg13_hv_pmos ad=1.36p pd=8.68u as=1.36p ps=8.68u w=4u l=0.5u
X260 q3 q3 q3 VSS sg13_hv_nmos ad=0.34p pd=2.68u as=0 ps=0 w=1u l=0.5u
X261 GROUP22_3.nmosHV_priv28_0.D GROUP22_3.G VSS VSS sg13_hv_nmos ad=0.34p pd=2.68u as=0.34p ps=2.68u w=1u l=0.5u
X262 GROUP16_1.G q0 VSS VSS sg13_hv_nmos ad=0.34p pd=2.68u as=0.34p ps=2.68u w=1u l=0.5u
X263 GROUP6_2.pmosHV_priv16_0.S GROUP6_2.pmosHV_priv16_0.S GROUP6_2.pmosHV_priv16_0.S VDD sg13_hv_pmos ad=1.7p pd=10.68u as=0 ps=0 w=5u l=0.5u
X264 clk_h VDD GROUP22_0.G VSS sg13_hv_nmos ad=0.38p pd=2.38u as=0.38p ps=2.38u w=2u l=0.5u
X265 GROUP22_2.G VDD clk_h VSS sg13_hv_nmos ad=0.38p pd=2.38u as=0.38p ps=2.38u w=2u l=0.5u
X266 VSS VSS VSS VSS sg13_hv_nmos ad=0.34p pd=2.68u as=0 ps=0 w=1u l=0.5u
X267 q3 GROUP19_2.G VSS VSS sg13_hv_nmos ad=0.34p pd=2.68u as=0.34p ps=2.68u w=1u l=0.5u
X268 GROUP19_0.G GROUP10_0.pmosHV$1_priv4_0.D VSS VSS sg13_hv_nmos ad=0.34p pd=2.68u as=0.34p ps=2.68u w=1u l=0.5u
X269 GROUP12_1.nmosHV_priv10_0.S GROUP12_1.nmosHV_priv10_0.S GROUP12_1.nmosHV_priv10_0.S VSS sg13_hv_nmos ad=0.34p pd=2.68u as=0 ps=0 w=1u l=0.5u
X270 VDDL VDDL VDDL VDDL sg13_hv_pmos ad=1.36p pd=8.68u as=0 ps=0 w=4u l=0.5u
X271 GROUP6_3.pmosHV_priv16_0.S vref_3 GROUP10_3.pmosHV$1_priv4_0.S VDD sg13_hv_pmos ad=1.7p pd=10.68u as=1.7p ps=10.68u w=5u l=0.5u
X272 GROUP22_2.G VSS clk_h VDD sg13_hv_pmos ad=0.38p pd=2.38u as=0.38p ps=2.38u w=2u l=0.5u
X273 GROUP10_2.pmosHV$1_priv4_0.D GROUP22_2.G VSS VSS sg13_hv_nmos ad=0.34p pd=2.68u as=0.34p ps=2.68u w=1u l=0.5u
X274 VDD VDD VDD VDD sg13_hv_pmos ad=1.7p pd=10.68u as=0 ps=0 w=5u l=0.5u
X275 GROUP6_0.pmosHV_priv16_0.S GROUP6_0.pmosHV_priv16_0.S GROUP6_0.pmosHV_priv16_0.S VDD sg13_hv_pmos ad=1.7p pd=10.68u as=0 ps=0 w=5u l=0.5u
X276 clk_h VSS GROUP22_3.G VDD sg13_hv_pmos ad=0.38p pd=2.38u as=0.38p ps=2.38u w=2u l=0.5u
X277 GROUP10_1.pmosHV$1_priv4_0.S GROUP10_1.pmosHV$1_priv4_0.S GROUP10_1.pmosHV$1_priv4_0.S VDD sg13_hv_pmos ad=0.68p pd=4.68u as=0 ps=0 w=2u l=0.5u
X278 clk_h VSS GROUP22_3.G VDD sg13_hv_pmos ad=0.38p pd=2.38u as=0.38p ps=2.38u w=2u l=0.5u
X279 GROUP20_2.G GROUP20_2.G GROUP20_2.G VSS sg13_hv_nmos ad=0.34p pd=2.68u as=0 ps=0 w=1u l=0.5u
X280 VSS VSS VSS VSS sg13_hv_nmos ad=0.34p pd=2.68u as=0 ps=0 w=1u l=0.5u
X281 q0 GROUP16_1.G VSS VSS sg13_hv_nmos ad=0.34p pd=2.68u as=0.34p ps=2.68u w=1u l=0.5u
X282 VSS VSS VSS VSS sg13_hv_nmos ad=0.34p pd=2.68u as=0 ps=0 w=1u l=0.5u
X283 VSS VSS VSS VSS sg13_hv_nmos ad=0.34p pd=2.68u as=0 ps=0 w=1u l=0.5u
X284 GROUP22_2.G GROUP22_2.G GROUP22_2.G VSS sg13_hv_nmos ad=0.68p pd=4.68u as=0 ps=0 w=2u l=0.5u
X285 VSS VSS VSS VSS sg13_hv_nmos ad=0.34p pd=2.68u as=0 ps=0 w=1u l=0.5u
X286 GROUP22_0.G GROUP22_0.G GROUP22_0.G VDD sg13_hv_pmos ad=0.68p pd=4.68u as=0 ps=0 w=2u l=0.5u
X287 GROUP8_0.nmosHV_priv1_0.S GROUP8_0.nmosHV_priv1_0.S GROUP8_0.nmosHV_priv1_0.S VDD sg13_hv_pmos ad=1.7p pd=10.68u as=0 ps=0 w=5u l=0.5u
X288 GROUP8_1.nmosHV_priv1_0.S GROUP8_1.nmosHV_priv1_0.S GROUP8_1.nmosHV_priv1_0.S VDD sg13_hv_pmos ad=0.68p pd=4.68u as=0 ps=0 w=2u l=0.5u
X289 VDD VDD VDD VDD sg13_hv_pmos ad=1.7p pd=10.68u as=0 ps=0 w=5u l=0.5u
X290 q1 q1 q1 VDDL sg13_hv_pmos ad=1.36p pd=8.68u as=0 ps=0 w=4u l=0.5u
X291 GROUP16_3.pmosHV$2_priv10_0.D GROUP16_3.pmosHV$2_priv10_0.D GROUP16_3.pmosHV$2_priv10_0.D VDDL sg13_hv_pmos ad=1.36p pd=8.68u as=0 ps=0 w=4u l=0.5u
X292 GROUP22_1.G VDD clk_h VSS sg13_hv_nmos ad=0.38p pd=2.38u as=0.38p ps=2.38u w=2u l=0.5u
X293 GROUP22_1.G VSS clk_h VDD sg13_hv_pmos ad=0.38p pd=2.38u as=0.38p ps=2.38u w=2u l=0.5u
X294 clk_h clk_h clk_h VDD sg13_hv_pmos ad=0.68p pd=4.68u as=0 ps=0 w=2u l=0.5u
X295 GROUP19_3.G GROUP19_3.G GROUP19_3.G VSS sg13_hv_nmos ad=0.34p pd=2.68u as=0 ps=0 w=1u l=0.5u
X296 GROUP19_3.G q2 VSS VSS sg13_hv_nmos ad=0.34p pd=2.68u as=0.34p ps=2.68u w=1u l=0.5u
X297 GROUP10_1.pmosHV$1_priv4_0.S GROUP22_1.G VSS VSS sg13_hv_nmos ad=0.34p pd=2.68u as=0.34p ps=2.68u w=1u l=0.5u
X298 VDD GROUP22_1.G GROUP6_1.pmosHV_priv16_0.S VDD sg13_hv_pmos ad=1.7p pd=10.68u as=1.7p ps=10.68u w=5u l=0.5u
X299 VSS VSS VSS VSS sg13_hv_nmos ad=0.34p pd=2.68u as=0 ps=0 w=1u l=0.5u
X300 VDDL GROUP20_1.G GROUP16_1.pmosHV$2_priv10_0.D VDDL sg13_hv_pmos ad=1.36p pd=8.68u as=1.36p ps=8.68u w=4u l=0.5u
X301 GROUP22_1.G VSS clk_h VDD sg13_hv_pmos ad=0.38p pd=2.38u as=0.38p ps=2.38u w=2u l=0.5u
X302 GROUP8_2.nmosHV_priv1_0.S GROUP8_2.nmosHV_priv1_0.S GROUP8_2.nmosHV_priv1_0.S VDD sg13_hv_pmos ad=0.68p pd=4.68u as=0 ps=0 w=2u l=0.5u
X303 VSS VSS VSS VSS sg13_hv_nmos ad=0.34p pd=2.68u as=0 ps=0 w=1u l=0.5u
X304 GROUP14_2.pmosHV$2_priv4_0.S GROUP14_2.pmosHV$2_priv4_0.S GROUP14_2.pmosHV$2_priv4_0.S VDDL sg13_hv_pmos ad=1.36p pd=8.68u as=12.0396p ps=45.16u w=4u l=0.5u
X305 GROUP12_1.nmosHV_priv10_0.S GROUP22_1.G VSS VSS sg13_hv_nmos ad=0.34p pd=2.68u as=0.34p ps=2.68u w=1u l=0.5u
X306 GROUP20_1.G GROUP12_1.nmosHV_priv10_0.S VSS VSS sg13_hv_nmos ad=0.34p pd=2.68u as=0.34p ps=2.68u w=1u l=0.5u
X307 GROUP22_2.G VDD clk_h VSS sg13_hv_nmos ad=0.38p pd=2.38u as=0.38p ps=2.38u w=2u l=0.5u
X308 GROUP12_3.nmosHV_priv10_0.S GROUP12_3.nmosHV_priv10_0.S GROUP12_3.nmosHV_priv10_0.S VSS sg13_hv_nmos ad=0.34p pd=2.68u as=0 ps=0 w=1u l=0.5u
X309 VDDL GROUP10_2.pmosHV$1_priv4_0.D GROUP13_3.pmosHV$2_priv1_0.D VDDL sg13_hv_pmos ad=1.36p pd=8.68u as=1.36p ps=8.68u w=4u l=0.5u
X310 VSS VSS VSS VSS sg13_hv_nmos ad=0.34p pd=2.68u as=0 ps=0 w=1u l=0.5u
X311 clk_h VDD GROUP22_0.G VSS sg13_hv_nmos ad=0.38p pd=2.38u as=0.38p ps=2.38u w=2u l=0.5u
X312 GROUP22_0.G VDD clk_h VSS sg13_hv_nmos ad=0.38p pd=2.38u as=0.38p ps=2.38u w=2u l=0.5u
X313 clk_h VSS GROUP22_0.G VDD sg13_hv_pmos ad=0.38p pd=2.38u as=0.38p ps=2.38u w=2u l=0.5u
X314 GROUP22_3.G VDD clk_h VSS sg13_hv_nmos ad=0.38p pd=2.38u as=0.38p ps=2.38u w=2u l=0.5u
X315 GROUP22_0.G VDD clk_h VSS sg13_hv_nmos ad=0.68p pd=4.68u as=0.38p ps=2.38u w=2u l=0.5u
X316 q2 GROUP19_3.G VSS VSS sg13_hv_nmos ad=0.34p pd=2.68u as=0.34p ps=2.68u w=1u l=0.5u
X317 clk_h clk_h clk_h VSS sg13_hv_nmos ad=0.68p pd=4.68u as=0 ps=0 w=2u l=0.5u
X318 clk_h VSS GROUP22_2.G VDD sg13_hv_pmos ad=0.38p pd=2.38u as=0.38p ps=2.38u w=2u l=0.5u
X319 VSS VSS VSS VSS sg13_hv_nmos ad=0.34p pd=2.68u as=0 ps=0 w=1u l=0.5u
X320 GROUP8_1.nmosHV_priv1_0.S GROUP22_0.G VSS VSS sg13_hv_nmos ad=0.34p pd=2.68u as=0.34p ps=2.68u w=1u l=0.5u
X321 GROUP12_1.nmosHV_priv10_0.S GROUP20_1.G VSS VSS sg13_hv_nmos ad=0.34p pd=2.68u as=0.34p ps=2.68u w=1u l=0.5u
X322 GROUP22_1.G GROUP22_1.G GROUP22_1.G VDD sg13_hv_pmos ad=0.68p pd=4.68u as=0 ps=0 w=2u l=0.5u
X323 GROUP12_3.nmosHV_priv10_0.S GROUP22_3.G VSS VSS sg13_hv_nmos ad=0.34p pd=2.68u as=0.34p ps=2.68u w=1u l=0.5u
X324 q0 q0 q0 VDDL sg13_hv_pmos ad=1.36p pd=8.68u as=0 ps=0 w=4u l=0.5u
X325 GROUP22_3.G VSS clk_h VDD sg13_hv_pmos ad=0.38p pd=2.38u as=0.38p ps=2.38u w=2u l=0.5u
X326 clk_h VSS GROUP22_2.G VDD sg13_hv_pmos ad=0.38p pd=2.38u as=0.38p ps=2.38u w=2u l=0.5u
X327 GROUP10_3.pmosHV$1_priv4_0.S GROUP22_3.G VSS VSS sg13_hv_nmos ad=0.34p pd=2.68u as=0.34p ps=2.68u w=1u l=0.5u
X328 GROUP20_1.G GROUP20_1.G GROUP20_1.G VDD sg13_hv_pmos ad=0.68p pd=4.68u as=0 ps=0 w=2u l=0.5u
X329 VDDL VDDL VDDL VDDL sg13_hv_pmos ad=1.36p pd=8.68u as=0 ps=0 w=4u l=0.5u
X330 GROUP16_1.G GROUP16_1.G GROUP16_1.G VSS sg13_hv_nmos ad=0.34p pd=2.68u as=0 ps=0 w=1u l=0.5u
X331 GROUP6_3.pmosHV_priv16_0.S GROUP6_3.pmosHV_priv16_0.S GROUP6_3.pmosHV_priv16_0.S VDD sg13_hv_pmos ad=1.7p pd=10.68u as=0 ps=0 w=5u l=0.5u
X332 GROUP10_0.pmosHV$1_priv4_0.S GROUP10_0.pmosHV$1_priv4_0.S GROUP10_0.pmosHV$1_priv4_0.S VDD sg13_hv_pmos ad=0.68p pd=4.68u as=0 ps=0 w=2u l=0.5u
X333 GROUP19_2.G GROUP19_2.G GROUP19_2.G VDDL sg13_hv_pmos ad=1.36p pd=8.68u as=0 ps=0 w=4u l=0.5u
X334 GROUP14_2.pmosHV$2_priv4_0.S GROUP14_2.pmosHV$2_priv4_0.S GROUP14_2.pmosHV$2_priv4_0.S VDDL sg13_hv_pmos ad=1.36p pd=8.68u as=0 ps=0 w=4u l=0.5u
X335 GROUP22_1.G VSS clk_h VDD sg13_hv_pmos ad=0.38p pd=2.38u as=0.38p ps=2.38u w=2u l=0.5u
X336 GROUP19_2.G GROUP19_2.G GROUP19_2.G VSS sg13_hv_nmos ad=0.34p pd=2.68u as=0 ps=0 w=1u l=0.5u
X337 GROUP10_2.pmosHV$1_priv4_0.S GROUP10_2.pmosHV$1_priv4_0.S GROUP10_2.pmosHV$1_priv4_0.S VDD sg13_hv_pmos ad=0.68p pd=4.68u as=0 ps=0 w=2u l=0.5u
X338 VSS VSS VSS VSS sg13_hv_nmos ad=0.34p pd=2.68u as=0 ps=0 w=1u l=0.5u
X339 clk_h VDD GROUP22_1.G VSS sg13_hv_nmos ad=0.38p pd=2.38u as=0.38p ps=2.38u w=2u l=0.5u
C0 a_34889_950# VSS 0.22513f ; **FLOATING
C1 a_34524_950# VSS 0.22513f ; **FLOATING
C2 a_33684_950# VSS 0.22513f ; **FLOATING
C3 a_33319_950# VSS 0.22513f ; **FLOATING
C4 a_23885_950# VSS 0.22513f ; **FLOATING
C5 a_23520_950# VSS 0.22513f ; **FLOATING
C6 a_22680_950# VSS 0.22513f ; **FLOATING
C7 a_22315_950# VSS 0.22513f ; **FLOATING
C8 a_12913_950# VSS 0.22513f ; **FLOATING
C9 a_12548_950# VSS 0.22513f ; **FLOATING
C10 a_11708_950# VSS 0.22513f ; **FLOATING
C11 a_11343_950# VSS 0.22513f ; **FLOATING
C12 a_2185_950# VSS 0.22513f ; **FLOATING
C13 a_1820_950# VSS 0.22513f ; **FLOATING
C14 a_980_950# VSS 0.22513f ; **FLOATING
C15 a_615_950# VSS 0.22513f ; **FLOATING
C16 a_41149_1676# VSS 0.75629f ; **FLOATING
C17 a_40784_1676# VSS 0.75629f ; **FLOATING
C18 a_39883_1676# VSS 0.35792f ; **FLOATING
C19 a_39518_1676# VSS 0.35792f ; **FLOATING
C20 a_38623_1674# VSS 0.22513f ; **FLOATING
C21 a_38258_1674# VSS 0.22513f ; **FLOATING
C22 a_37410_1674# VSS 0.6235f ; **FLOATING
C23 a_37045_1674# VSS 0.6235f ; **FLOATING
C24 a_36150_1674# VSS 0.6235f ; **FLOATING
C25 a_35785_1674# VSS 0.6235f ; **FLOATING
C26 a_34890_1674# VSS 0.22513f ; **FLOATING
C27 a_34525_1674# VSS 0.22513f ; **FLOATING
C28 a_30145_1676# VSS 0.75629f ; **FLOATING
C29 a_29780_1676# VSS 0.75629f ; **FLOATING
C30 a_28879_1676# VSS 0.35792f ; **FLOATING
C31 a_28514_1676# VSS 0.35792f ; **FLOATING
C32 a_27619_1674# VSS 0.22513f ; **FLOATING
C33 a_27254_1674# VSS 0.22513f ; **FLOATING
C34 a_26406_1674# VSS 0.6235f ; **FLOATING
C35 a_26041_1674# VSS 0.6235f ; **FLOATING
C36 a_25146_1674# VSS 0.6235f ; **FLOATING
C37 a_24781_1674# VSS 0.6235f ; **FLOATING
C38 a_23886_1674# VSS 0.22513f ; **FLOATING
C39 a_23521_1674# VSS 0.22513f ; **FLOATING
C40 a_19173_1676# VSS 0.75629f ; **FLOATING
C41 a_18808_1676# VSS 0.75629f ; **FLOATING
C42 a_17907_1676# VSS 0.35792f ; **FLOATING
C43 a_17542_1676# VSS 0.35792f ; **FLOATING
C44 a_16647_1674# VSS 0.22513f ; **FLOATING
C45 a_16282_1674# VSS 0.22513f ; **FLOATING
C46 a_15434_1674# VSS 0.6235f ; **FLOATING
C47 a_15069_1674# VSS 0.6235f ; **FLOATING
C48 a_14174_1674# VSS 0.6235f ; **FLOATING
C49 a_13809_1674# VSS 0.6235f ; **FLOATING
C50 a_12914_1674# VSS 0.22513f ; **FLOATING
C51 a_12549_1674# VSS 0.22513f ; **FLOATING
C52 a_8445_1676# VSS 0.75629f ; **FLOATING
C53 a_8080_1676# VSS 0.75629f ; **FLOATING
C54 a_7179_1676# VSS 0.35792f ; **FLOATING
C55 a_6814_1676# VSS 0.35792f ; **FLOATING
C56 a_5919_1674# VSS 0.22513f ; **FLOATING
C57 a_5554_1674# VSS 0.22513f ; **FLOATING
C58 a_4706_1674# VSS 0.6235f ; **FLOATING
C59 a_4341_1674# VSS 0.6235f ; **FLOATING
C60 a_3446_1674# VSS 0.6235f ; **FLOATING
C61 a_3081_1674# VSS 0.6235f ; **FLOATING
C62 a_2186_1674# VSS 0.22513f ; **FLOATING
C63 a_1821_1674# VSS 0.22513f ; **FLOATING
C64 a_42348_3200# VSS 0.75629f ; **FLOATING
C65 a_41983_3200# VSS 0.75629f ; **FLOATING
C66 a_39935_3198# VSS 0.22513f ; **FLOATING
C67 a_39570_3198# VSS 0.22513f ; **FLOATING
C68 a_39935_4000# VSS 0.22513f ; **FLOATING
C69 a_39570_4000# VSS 0.22513f ; **FLOATING
C70 a_31344_3200# VSS 0.75629f ; **FLOATING
C71 a_30979_3200# VSS 0.75629f ; **FLOATING
C72 a_28931_3198# VSS 0.22513f ; **FLOATING
C73 GROUP10_3.pmosHV$1_priv4_0.S VSS 1.8946f
C74 a_28566_3198# VSS 0.22513f ; **FLOATING
C75 a_28931_4000# VSS 0.22513f ; **FLOATING
C76 a_28566_4000# VSS 0.22513f ; **FLOATING
C77 a_20372_3200# VSS 0.75629f ; **FLOATING
C78 a_20007_3200# VSS 0.75629f ; **FLOATING
C79 a_17959_3198# VSS 0.22513f ; **FLOATING
C80 a_17594_3198# VSS 0.22513f ; **FLOATING
C81 a_17959_4000# VSS 0.22513f ; **FLOATING
C82 a_17594_4000# VSS 0.22513f ; **FLOATING
C83 a_9644_3200# VSS 0.75629f ; **FLOATING
C84 a_9279_3200# VSS 0.75629f ; **FLOATING
C85 a_7231_3198# VSS 0.22513f ; **FLOATING
C86 a_6866_3198# VSS 0.22513f ; **FLOATING
C87 a_7231_4000# VSS 0.22513f ; **FLOATING
C88 a_6866_4000# VSS 0.22513f ; **FLOATING
C89 a_41149_4724# VSS 0.75629f ; **FLOATING
C90 a_40784_4724# VSS 0.75629f ; **FLOATING
C91 a_39883_5324# VSS 0.35792f ; **FLOATING
C92 a_39518_5324# VSS 0.35792f ; **FLOATING
C93 a_38623_5524# VSS 0.22513f ; **FLOATING
C94 a_38258_5524# VSS 0.22513f ; **FLOATING
C95 a_37409_4924# VSS 0.6235f ; **FLOATING
C96 a_37044_4924# VSS 0.6235f ; **FLOATING
C97 a_36150_4924# VSS 0.6235f ; **FLOATING
C98 a_35785_4924# VSS 0.6235f ; **FLOATING
C99 a_34890_5524# VSS 0.22513f ; **FLOATING
C100 a_34525_5524# VSS 0.22513f ; **FLOATING
C101 a_30145_4724# VSS 0.75629f ; **FLOATING
C102 a_29780_4724# VSS 0.75629f ; **FLOATING
C103 a_28879_5324# VSS 0.35792f ; **FLOATING
C104 a_28514_5324# VSS 0.35792f ; **FLOATING
C105 a_27619_5524# VSS 0.22513f ; **FLOATING
C106 a_27254_5524# VSS 0.22513f ; **FLOATING
C107 a_26405_4924# VSS 0.6235f ; **FLOATING
C108 a_26040_4924# VSS 0.6235f ; **FLOATING
C109 a_25146_4924# VSS 0.6235f ; **FLOATING
C110 a_24781_4924# VSS 0.6235f ; **FLOATING
C111 a_23886_5524# VSS 0.22513f ; **FLOATING
C112 a_23521_5524# VSS 0.22513f ; **FLOATING
C113 a_19173_4724# VSS 0.75629f ; **FLOATING
C114 a_18808_4724# VSS 0.75629f ; **FLOATING
C115 a_17907_5324# VSS 0.35792f ; **FLOATING
C116 a_17542_5324# VSS 0.35792f ; **FLOATING
C117 a_16647_5524# VSS 0.22513f ; **FLOATING
C118 a_16282_5524# VSS 0.22513f ; **FLOATING
C119 a_15433_4924# VSS 0.6235f ; **FLOATING
C120 a_15068_4924# VSS 0.6235f ; **FLOATING
C121 a_14174_4924# VSS 0.6235f ; **FLOATING
C122 a_13809_4924# VSS 0.6235f ; **FLOATING
C123 a_12914_5524# VSS 0.22513f ; **FLOATING
C124 a_12549_5524# VSS 0.22513f ; **FLOATING
C125 a_8445_4724# VSS 0.75629f ; **FLOATING
C126 GROUP6_1.pmosHV_priv16_0.S VSS 1.78665f
C127 a_8080_4724# VSS 0.75629f ; **FLOATING
C128 a_7179_5324# VSS 0.35792f ; **FLOATING
C129 a_6814_5324# VSS 0.35792f ; **FLOATING
C130 a_5919_5524# VSS 0.22513f ; **FLOATING
C131 a_5554_5524# VSS 0.22513f ; **FLOATING
C132 a_4705_4924# VSS 0.6235f ; **FLOATING
C133 a_4340_4924# VSS 0.6235f ; **FLOATING
C134 a_3446_4924# VSS 0.6235f ; **FLOATING
C135 a_3081_4924# VSS 0.6235f ; **FLOATING
C136 a_2186_5524# VSS 0.22513f ; **FLOATING
C137 a_1821_5524# VSS 0.22513f ; **FLOATING
C138 a_34888_6246# VSS 0.22513f ; **FLOATING
C139 a_38995_6684# VSS 0.35792f ; **FLOATING
C140 a_34523_6246# VSS 0.22513f ; **FLOATING
C141 a_33679_6246# VSS 0.22513f ; **FLOATING
C142 a_33314_6246# VSS 0.22513f ; **FLOATING
C143 a_23884_6246# VSS 0.22513f ; **FLOATING
C144 a_36694_6684# VSS 0.35792f ; **FLOATING
C145 a_27991_6684# VSS 0.35792f ; **FLOATING
C146 a_23519_6246# VSS 0.22513f ; **FLOATING
C147 a_22675_6246# VSS 0.22513f ; **FLOATING
C148 a_22310_6246# VSS 0.22513f ; **FLOATING
C149 a_12912_6246# VSS 0.22513f ; **FLOATING
C150 a_25690_6684# VSS 0.35792f ; **FLOATING
C151 a_17019_6684# VSS 0.35792f ; **FLOATING
C152 a_12547_6246# VSS 0.22513f ; **FLOATING
C153 a_11703_6246# VSS 0.22513f ; **FLOATING
C154 a_11338_6246# VSS 0.22513f ; **FLOATING
C155 a_2184_6246# VSS 0.22513f ; **FLOATING
C156 a_14718_6684# VSS 0.35792f ; **FLOATING
C157 a_6291_6684# VSS 0.35792f ; **FLOATING
C158 a_1819_6246# VSS 0.22513f ; **FLOATING
C159 a_975_6246# VSS 0.22513f ; **FLOATING
C160 a_610_6246# VSS 0.22513f ; **FLOATING
C161 a_3990_6684# VSS 0.35792f ; **FLOATING
C162 a_38991_7670# VSS 0.35792f ; **FLOATING
C163 a_36690_7670# VSS 0.35792f ; **FLOATING
C164 a_27987_7670# VSS 0.35792f ; **FLOATING
C165 a_25686_7670# VSS 0.35792f ; **FLOATING
C166 a_17015_7670# VSS 0.35792f ; **FLOATING
C167 a_14714_7670# VSS 0.35792f ; **FLOATING
C168 a_6287_7670# VSS 0.35792f ; **FLOATING
C169 a_3986_7670# VSS 0.35792f ; **FLOATING
Rfixtest a_34889_950# VSS 1e9
Rfix0 a_34524_950# VSS 1e4
Rfix1 a_33684_950# VSS 1e4
Rfix2 a_33319_950# VSS 1e4
Rfix3 a_23885_950# VSS 1e4
Rfix4 a_23520_950# VSS 1e4
Rfix5 a_22680_950# VSS 1e4
Rfix6 a_22315_950# VSS 1e4
Rfix7 a_12913_950# VSS 1e4
Rfix8 a_12548_950# VSS 1e4
Rfix9 a_11708_950# VSS 1e4
Rfix10 a_11343_950# VSS 1e4
Rfix11 a_2185_950# VSS 1e4
Rfix12 a_1820_950# VSS 1e4
Rfix13 a_980_950# VSS 1e4
Rfix14 a_615_950# VSS 1e4
Rfix15 a_41149_1676# VSS 1e4
Rfix16 a_40784_1676# VSS 1e4
Rfix17 a_39883_1676# VSS 1e4
Rfix18 a_39518_1676# VSS 1e4
Rfix19 a_38623_1674# VSS 1e4
Rfix20 a_38258_1674# VSS 1e4
Rfix21 a_37410_1674# VSS 1e4
Rfix22 a_37045_1674# VSS 1e4
Rfix23 a_36150_1674# VSS 1e4
Rfix24 a_35785_1674# VSS 1e4
Rfix25 a_34890_1674# VSS 1e4
Rfix26 a_34525_1674# VSS 1e4
Rfix27 a_30145_1676# VSS 1e4
Rfix28 a_29780_1676# VSS 1e4
Rfix29 a_28879_1676# VSS 1e4
Rfix30 a_28514_1676# VSS 1e4
Rfix31 a_27619_1674# VSS 1e4
Rfix32 a_27254_1674# VSS 1e4
Rfix33 a_26406_1674# VSS 1e4
Rfix34 a_26041_1674# VSS 1e4
Rfix35 a_25146_1674# VSS 1e4
Rfix36 a_24781_1674# VSS 1e4
Rfix37 a_23886_1674# VSS 1e4
Rfix38 a_23521_1674# VSS 1e4
Rfix39 a_19173_1676# VSS 1e4
Rfix40 a_18808_1676# VSS 1e4
Rfix41 a_17907_1676# VSS 1e4
Rfix42 a_17542_1676# VSS 1e4
Rfix43 a_16647_1674# VSS 1e4
Rfix44 a_16282_1674# VSS 1e4
Rfix45 a_15434_1674# VSS 1e4
Rfix46 a_15069_1674# VSS 1e4
Rfix47 a_14174_1674# VSS 1e4
Rfix48 a_13809_1674# VSS 1e4
Rfix49 a_12914_1674# VSS 1e4
Rfix50 a_12549_1674# VSS 1e4
Rfix51 a_8445_1676# VSS 1e4
Rfix52 a_8080_1676# VSS 1e4
Rfix53 a_7179_1676# VSS 1e4
Rfix54 a_6814_1676# VSS 1e4
Rfix55 a_5919_1674# VSS 1e4
Rfix56 a_5554_1674# VSS 1e4
Rfix57 a_4706_1674# VSS 1e4
Rfix58 a_4341_1674# VSS 1e4
Rfix59 a_3446_1674# VSS 1e4
Rfix60 a_3081_1674# VSS 1e4
Rfix61 a_2186_1674# VSS 1e4
Rfix62 a_1821_1674# VSS 1e4
Rfix63 a_42348_3200# VSS 1e4
Rfix64 a_41983_3200# VSS 1e4
Rfix65 a_39935_3198# VSS 1e4
Rfix66 a_39570_3198# VSS 1e4
Rfix67 a_39935_4000# VSS 1e4
Rfix68 a_39570_4000# VSS 1e4
Rfix69 a_31344_3200# VSS 1e4
Rfix70 a_30979_3200# VSS 1e4
Rfix71 a_28931_3198# VSS 1e4
Rfix72 a_28566_3198# VSS 1e4
Rfix73 a_28931_4000# VSS 1e4
Rfix74 a_28566_4000# VSS 1e4
Rfix75 a_20372_3200# VSS 1e4
Rfix76 a_20007_3200# VSS 1e4
Rfix77 a_17959_3198# VSS 1e4
Rfix78 a_17594_3198# VSS 1e4
Rfix79 a_17959_4000# VSS 1e4
Rfix80 a_17594_4000# VSS 1e4
Rfix81 a_9644_3200# VSS 1e4
Rfix82 a_9279_3200# VSS 1e4
Rfix83 a_7231_3198# VSS 1e4
Rfix84 a_6866_3198# VSS 1e4
Rfix85 a_7231_4000# VSS 1e4
Rfix86 a_6866_4000# VSS 1e4
Rfix87 a_41149_4724# VSS 1e4
Rfix88 a_40784_4724# VSS 1e4
Rfix89 a_39883_5324# VSS 1e4
Rfix90 a_39518_5324# VSS 1e4
Rfix91 a_38623_5524# VSS 1e4
Rfix92 a_38258_5524# VSS 1e4
Rfix93 a_37409_4924# VSS 1e4
Rfix94 a_37044_4924# VSS 1e4
Rfix95 a_36150_4924# VSS 1e4
Rfix96 a_35785_4924# VSS 1e4
Rfix97 a_34890_5524# VSS 1e4
Rfix98 a_34525_5524# VSS 1e4
Rfix99 a_30145_4724# VSS 1e4
Rfix100 a_29780_4724# VSS 1e4
Rfix101 a_28879_5324# VSS 1e4
Rfix102 a_28514_5324# VSS 1e4
Rfix103 a_27619_5524# VSS 1e4
Rfix104 a_27254_5524# VSS 1e4
Rfix105 a_26405_4924# VSS 1e4
Rfix106 a_26040_4924# VSS 1e4
Rfix107 a_25146_4924# VSS 1e4
Rfix108 a_24781_4924# VSS 1e4
Rfix109 a_23886_5524# VSS 1e4
Rfix110 a_23521_5524# VSS 1e4
Rfix111 a_19173_4724# VSS 1e4
Rfix112 a_18808_4724# VSS 1e4
Rfix113 a_17907_5324# VSS 1e4
Rfix114 a_17542_5324# VSS 1e4
Rfix115 a_16647_5524# VSS 1e4
Rfix116 a_16282_5524# VSS 1e4
Rfix117 a_15433_4924# VSS 1e4
Rfix118 a_15068_4924# VSS 1e4
Rfix119 a_14174_4924# VSS 1e4
Rfix120 a_13809_4924# VSS 1e4
Rfix121 a_12914_5524# VSS 1e4
Rfix122 a_12549_5524# VSS 1e4
Rfix123 a_8445_4724# VSS 1e4
Rfix124 a_8080_4724# VSS 1e4
Rfix125 a_7179_5324# VSS 1e4
Rfix126 a_6814_5324# VSS 1e4
Rfix127 a_5919_5524# VSS 1e4
Rfix128 a_5554_5524# VSS 1e4
Rfix129 a_4705_4924# VSS 1e4
Rfix130 a_4340_4924# VSS 1e4
Rfix131 a_3446_4924# VSS 1e4
Rfix132 a_3081_4924# VSS 1e4
Rfix133 a_2186_5524# VSS 1e4
Rfix134 a_1821_5524# VSS 1e4
Rfix135 a_34888_6246# VSS 1e4
Rfix136 a_38995_6684# VSS 1e4
Rfix137 a_34523_6246# VSS 1e4
Rfix138 a_33679_6246# VSS 1e4
Rfix139 a_33314_6246# VSS 1e4
Rfix140 a_23884_6246# VSS 1e4
Rfix141 a_36694_6684# VSS 1e4
Rfix142 a_27991_6684# VSS 1e4
Rfix143 a_23519_6246# VSS 1e4
Rfix144 a_22675_6246# VSS 1e4
Rfix145 a_22310_6246# VSS 1e4
Rfix146 a_12912_6246# VSS 1e4
Rfix147 a_25690_6684# VSS 1e4
Rfix148 a_17019_6684# VSS 1e4
Rfix149 a_12547_6246# VSS 1e4
Rfix150 a_11703_6246# VSS 1e4
Rfix151 a_11338_6246# VSS 1e4
Rfix152 a_2184_6246# VSS 1e4
Rfix153 a_14718_6684# VSS 1e4
Rfix154 a_6291_6684# VSS 1e4
Rfix155 a_1819_6246# VSS 1e4
Rfix156 a_975_6246# VSS 1e4
Rfix157 a_610_6246# VSS 1e4
Rfix158 a_3990_6684# VSS 1e4
Rfix159 a_38991_7670# VSS 1e4
Rfix160 a_36690_7670# VSS 1e4
Rfix161 a_27987_7670# VSS 1e4
Rfix162 a_25686_7670# VSS 1e4
Rfix163 a_17015_7670# VSS 1e4
Rfix164 a_14714_7670# VSS 1e4
Rfix165 a_6287_7670# VSS 1e4
Rfix166 a_3986_7670# VSS 1e4
.ends
