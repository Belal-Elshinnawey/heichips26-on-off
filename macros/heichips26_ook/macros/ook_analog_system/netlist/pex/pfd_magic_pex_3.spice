* PEX produced on Wed Sep  9 06:20:29 CEST 2026 using scripts/sak-pex.sh with m=3 and s=1 (extresist threshold=10000 mOhm, minres=1000 mOhm, mindelay=1 ps)
* NGSPICE file created from pfd_pex.ext - technology: ihp-sg13cmos5l

.subckt pfd_pex CLK_REF UP DN CLK_FB VDD VSS
X0 a_38_1100# a_843_1222# a_298_1323# VDD sg13_lv_pmos ad=0.1428p pd=1.52u as=79.8f ps=0.8u w=0.42u l=0.13u
X1 a_1583_1177# a_741_1079# a_324_1418# VDD sg13_lv_pmos ad=0.2048p pd=1.63u as=0.34p ps=2.68u w=1u l=0.13u
X2 VDD a_1583_1177# a_1840_1320# VDD sg13_lv_pmos ad=0.2639p pd=1.81u as=79.8f ps=0.8u w=0.42u l=0.13u
X3 VSS.t1 a_1583_1177# a_2420_1398# VSS.t16 sg13_lv_nmos ad=0.1406p pd=1.12u as=0.2516p ps=2.16u w=0.74u l=0.13u
X4 VDD sg13cmos5l_dfrbp_1_0.RESET_B a_652_606# VDD sg13_lv_pmos ad=1.35685p pd=8.78u as=79.8f ps=0.8u w=0.42u l=0.13u
X5 VSS.t3 a_269_132# sg13cmos5l_dfrbp_1_0.Q_N VSS.t25 sg13_lv_nmos ad=0.2516p pd=2.16u as=0.2849p ps=2.25u w=0.74u l=0.13u
X6 a_999_255# a_1151_139# VSS.t3 VSS.t29 sg13_lv_nmos ad=0.2516p pd=2.16u as=2.41177p ps=15.625u w=0.74u l=0.13u
X7 a_910_291# a_652_606# VDD VDD sg13_lv_pmos ad=93.45f pd=0.865u as=1.35685p ps=8.78u w=0.42u l=0.13u
X8 a_550_1113# sg13cmos5l_dfrbp_1_0.RESET_B VSS.t1 VSS.t5 sg13_lv_nmos ad=37.8f pd=0.6u as=0.1701p ps=1.65u w=0.42u l=0.13u
X9 a_1941_215# a_999_255# a_1802_448# VSS.t21 sg13_lv_nmos ad=79.8f pd=0.8u as=0.2373p ps=1.97u w=0.42u l=0.13u
X10 a_741_1079# CLK_REF VDD VDD sg13_lv_pmos ad=0.4088p pd=2.97u as=1.35685p ps=8.78u w=1.12u l=0.13u
X11 VSS.t3 a_150_455# DN VSS.t19 sg13_lv_nmos ad=0.1406p pd=1.12u as=0.2516p ps=2.16u w=0.74u l=0.13u
X12 a_1847_215# VDD a_2594_606# VSS.t7 sg13_lv_nmos ad=0.1428p pd=1.52u as=60.89999f ps=0.71u w=0.42u l=0.13u
X13 a_612_1113# a_843_1222# a_298_1323# VSS.t8 sg13_lv_nmos ad=0.2373p pd=1.97u as=79.8f ps=0.8u w=0.42u l=0.13u
X14 a_741_1079# CLK_REF VSS.t1 VSS.t12 sg13_lv_nmos ad=0.2516p pd=2.16u as=2.41177p ps=15.625u w=0.74u l=0.13u
X15 VDD sg13cmos5l_dfrbp_1_1.Q sg13cmos5l_dfrbp_1_0.RESET_B VDD sg13_lv_pmos ad=0.3808p pd=2.92u as=0.2128p ps=1.5u w=1.12u l=0.13u
X16 VDD sg13cmos5l_dfrbp_1_0.RESET_B a_38_1100# VDD sg13_lv_pmos ad=0.36237p pd=2.605u as=79.8f ps=0.8u w=0.42u l=0.13u
X17 VDD a_1840_1320# a_1785_1415# VDD sg13_lv_pmos ad=1.35685p pd=8.78u as=93.45f ps=0.865u w=0.42u l=0.13u
X18 a_324_1418# a_843_1222# a_1583_1177# VSS.t9 sg13_lv_nmos ad=0.3473p pd=2.71u as=0.12665p ps=1.145u w=0.74u l=0.13u
X19 a_150_455# a_269_132# VSS.t3 VSS.t24 sg13_lv_nmos ad=0.2516p pd=2.16u as=0.1406p ps=1.12u w=0.74u l=0.13u
X20 VDD a_1941_215# a_1020_529# VDD sg13_lv_pmos ad=0.36237p pd=2.605u as=0.34p ps=2.68u w=1u l=0.13u
X21 VSS.t3 sg13cmos5l_dfrbp_1_0.RESET_B a_746_606# VSS.t2 sg13_lv_nmos ad=79.8f pd=0.8u as=37.8f ps=0.6u w=0.42u l=0.13u
X22 a_269_132# a_999_255# a_1020_529# VSS.t20 sg13_lv_nmos ad=0.12665p pd=1.145u as=0.3473p ps=2.71u w=0.74u l=0.13u
X23 a_910_606# a_652_606# VSS.t3 VSS.t27 sg13_lv_nmos ad=0.1428p pd=1.52u as=79.8f ps=0.8u w=0.42u l=0.13u
X24 a_2594_606# sg13cmos5l_dfrbp_1_0.RESET_B VSS.t3 VSS.t7 sg13_lv_nmos ad=60.89999f pd=0.71u as=0.1626p ps=1.415u w=0.42u l=0.13u
X25 VSS.t1 sg13cmos5l_dfrbp_1_0.RESET_B a_132_1100# VSS.t0 sg13_lv_nmos ad=0.1626p pd=1.415u as=60.89999f ps=0.71u w=0.42u l=0.13u
X26 VDD a_1583_1177# a_2420_1398# VDD sg13_lv_pmos ad=0.2128p pd=1.5u as=0.3864p ps=2.93u w=1.12u l=0.13u
X27 a_746_606# a_269_132# a_652_606# VSS.t26 sg13_lv_nmos ad=37.8f pd=0.6u as=0.1428p ps=1.52u w=0.42u l=0.13u
X28 a_910_606# a_1151_139# a_269_132# VSS.t28 sg13_lv_nmos ad=0.1428p pd=1.52u as=0.12665p ps=1.145u w=0.42u l=0.13u
X29 a_324_1418# a_298_1323# VSS.t1 VSS.t10 sg13_lv_nmos ad=0.2516p pd=2.16u as=0.1626p ps=1.415u w=0.74u l=0.13u
X30 VSS.t3 CLK_FB a_1151_139# VSS.t15 sg13_lv_nmos ad=2.41177p pd=15.625u as=0.2516p ps=2.16u w=0.74u l=0.13u
X31 a_269_132# a_999_255# a_910_291# VDD sg13_lv_pmos ad=0.2048p pd=1.63u as=93.45f ps=0.865u w=0.42u l=0.13u
X32 a_132_1100# VDD a_38_1100# VSS.t23 sg13_lv_nmos ad=60.89999f pd=0.71u as=0.1428p ps=1.52u w=0.42u l=0.13u
X33 a_1840_1320# sg13cmos5l_dfrbp_1_0.RESET_B VDD VDD sg13_lv_pmos ad=79.8f pd=0.8u as=1.35685p ps=8.78u w=0.42u l=0.13u
X34 a_2043_215# a_1151_139# a_1941_215# VDD sg13_lv_pmos ad=63f pd=0.72u as=79.8f ps=0.8u w=0.42u l=0.13u
X35 a_1583_1177# a_741_1079# a_1489_1177# VSS.t13 sg13_lv_nmos ad=0.12665p pd=1.145u as=0.1428p ps=1.52u w=0.42u l=0.13u
X36 UP a_1583_1177# VSS.t1 VSS.t16 sg13_lv_nmos ad=0.2849p pd=2.25u as=0.2516p ps=2.16u w=0.74u l=0.13u
X37 a_999_255# a_1151_139# VDD VDD sg13_lv_pmos ad=0.3864p pd=2.93u as=1.35685p ps=8.78u w=1.12u l=0.13u
X38 a_324_1418# a_298_1323# VDD VDD sg13_lv_pmos ad=0.34p pd=2.68u as=0.36237p ps=2.605u w=1u l=0.13u
X39 sg13cmos5l_dfrbp_1_1.Q a_2420_1398# VSS.t1 VSS.t16 sg13_lv_nmos ad=0.2516p pd=2.16u as=0.1406p ps=1.12u w=0.74u l=0.13u
X40 a_1941_215# sg13cmos5l_dfrbp_1_0.RESET_B VDD VDD sg13_lv_pmos ad=0.147p pd=1.54u as=0.1563p ps=1.22u w=0.42u l=0.13u
X41 a_1847_215# sg13cmos5l_dfrbp_1_0.RESET_B VDD VDD sg13_lv_pmos ad=79.8f pd=0.8u as=0.36237p ps=2.605u w=0.42u l=0.13u
X42 a_1306_2410# DN sg13cmos5l_dfrbp_1_0.RESET_B VSS.t32 sg13_lv_nmos ad=0.1406p pd=1.12u as=0.2516p ps=2.16u w=0.74u l=0.13u
X43 VDD VDD a_1847_215# VDD sg13_lv_pmos ad=0.1428p pd=1.52u as=79.8f ps=0.8u w=0.42u l=0.13u
X44 VDD sg13cmos5l_dfrbp_1_0.RESET_B a_298_1323# VDD sg13_lv_pmos ad=0.1563p pd=1.22u as=0.147p ps=1.54u w=0.42u l=0.13u
X45 a_2198_593# a_1020_529# a_1802_448# VSS.t6 sg13_lv_nmos ad=37.8f pd=0.6u as=0.1428p ps=1.52u w=0.42u l=0.13u
X46 a_681_1491# a_324_1418# VDD VDD sg13_lv_pmos ad=63f pd=0.72u as=0.1563p ps=1.22u w=0.42u l=0.13u
X47 a_1941_215# a_999_255# a_1847_215# VDD sg13_lv_pmos ad=79.8f pd=0.8u as=0.1428p ps=1.52u w=0.42u l=0.13u
X48 VSS.t1 a_1840_1320# a_1489_1177# VSS.t4 sg13_lv_nmos ad=79.8f pd=0.8u as=0.1428p ps=1.52u w=0.42u l=0.13u
X49 VDD a_1020_529# a_2043_215# VDD sg13_lv_pmos ad=0.1563p pd=1.22u as=63f ps=0.72u w=0.42u l=0.13u
X50 a_298_1323# a_741_1079# a_681_1491# VDD sg13_lv_pmos ad=79.8f pd=0.8u as=63f ps=0.72u w=0.42u l=0.13u
X51 a_1840_1320# a_1583_1177# a_2002_1100# VSS.t4 sg13_lv_nmos ad=0.1428p pd=1.52u as=37.8f ps=0.6u w=0.42u l=0.13u
X52 VDD a_269_132# sg13cmos5l_dfrbp_1_0.Q_N VDD sg13_lv_pmos ad=0.2639p pd=1.81u as=0.4312p ps=3.01u w=1.12u l=0.13u
X53 VSS.t3 sg13cmos5l_dfrbp_1_0.RESET_B a_2198_593# VSS.t6 sg13_lv_nmos ad=0.1701p pd=1.65u as=37.8f ps=0.6u w=0.42u l=0.13u
X54 a_1785_1415# a_843_1222# a_1583_1177# VDD sg13_lv_pmos ad=93.45f pd=0.865u as=0.2048p ps=1.63u w=0.42u l=0.13u
X55 a_612_1113# a_324_1418# a_550_1113# VSS.t14 sg13_lv_nmos ad=0.1428p pd=1.52u as=37.8f ps=0.6u w=0.42u l=0.13u
X56 a_1020_529# a_1151_139# a_269_132# VDD sg13_lv_pmos ad=0.34p pd=2.68u as=0.2048p ps=1.63u w=1u l=0.13u
X57 VDD CLK_FB a_1151_139# VDD sg13_lv_pmos ad=1.35685p pd=8.78u as=0.4088p ps=2.97u w=1.12u l=0.13u
X58 VDD a_741_1079# a_843_1222# VDD sg13_lv_pmos ad=1.35685p pd=8.78u as=0.3864p ps=2.93u w=1.12u l=0.13u
X59 UP a_1583_1177# VDD VDD sg13_lv_pmos ad=0.4312p pd=3.01u as=0.2639p ps=1.81u w=1.12u l=0.13u
X60 VDD a_150_455# DN VDD sg13_lv_pmos ad=0.2128p pd=1.5u as=0.3808p ps=2.92u w=1.12u l=0.13u
X61 VSS.t34 sg13cmos5l_dfrbp_1_1.Q a_1306_2410# VSS.t33 sg13_lv_nmos ad=0.2516p pd=2.16u as=0.1406p ps=1.12u w=0.74u l=0.13u
X62 VSS.t1 a_741_1079# a_843_1222# VSS.t12 sg13_lv_nmos ad=2.41177p pd=15.625u as=0.2516p ps=2.16u w=0.74u l=0.13u
X63 sg13cmos5l_dfrbp_1_1.Q a_2420_1398# VDD VDD sg13_lv_pmos ad=0.3808p pd=2.92u as=0.2128p ps=1.5u w=1.12u l=0.13u
X64 a_150_455# a_269_132# VDD VDD sg13_lv_pmos ad=0.3864p pd=2.93u as=0.2128p ps=1.5u w=1.12u l=0.13u
X65 a_1847_215# a_1151_139# a_1941_215# VSS.t21 sg13_lv_nmos ad=0.1296p pd=1.52u as=79.8f ps=0.8u w=0.42u l=0.13u
X66 VSS.t3 a_1941_215# a_1020_529# VSS.t30 sg13_lv_nmos ad=0.1626p pd=1.415u as=0.2516p ps=2.16u w=0.74u l=0.13u
X67 sg13cmos5l_dfrbp_1_0.RESET_B DN VDD VDD sg13_lv_pmos ad=0.2128p pd=1.5u as=0.3808p ps=2.92u w=1.12u l=0.13u
X68 a_38_1100# VDD VDD VDD sg13_lv_pmos ad=79.8f pd=0.8u as=0.1428p ps=1.52u w=0.42u l=0.13u
X69 a_298_1323# a_741_1079# a_38_1100# VSS.t11 sg13_lv_nmos ad=79.8f pd=0.8u as=0.1296p ps=1.52u w=0.42u l=0.13u
X70 a_2002_1100# sg13cmos5l_dfrbp_1_0.RESET_B VSS.t1 VSS.t4 sg13_lv_nmos ad=37.8f pd=0.6u as=79.8f ps=0.8u w=0.42u l=0.13u
X71 a_652_606# a_269_132# VDD VDD sg13_lv_pmos ad=79.8f pd=0.8u as=0.2639p ps=1.81u w=0.42u l=0.13u
R0 VSS.n19 VSS.t21 98732.5
R1 VSS.n13 VSS.t28 35952.9
R2 VSS.n20 VSS.t13 35765.6
R3 VSS.n5 VSS.n19 16340.1
R4 VSS.n20 VSS.n3 15846.5
R5 VSS.t20 VSS.n10 2176.9
R6 VSS.t9 VSS.n12 2176.9
R7 VSS.n24 VSS.t15 1922.54
R8 VSS.t29 VSS.n24 985.561
R9 VSS.n23 VSS.n10 974.73
R10 VSS.n12 VSS.n11 974.73
R11 VSS.n24 VSS.t12 652.23
R12 VSS.n19 VSS.n7 527.212
R13 VSS.n5 VSS.t32 29.8863
R14 VSS.n3 VSS.t33 29.8863
R15 VSS.t16 VSS.n20 399.015
R16 VSS.t7 VSS.n18 384.236
R17 VSS.n21 VSS.t4 384.236
R18 VSS.t28 VSS.t20 346.57
R19 VSS.t13 VSS.t9 346.57
R20 VSS.t21 VSS.t30 288.178
R21 VSS.t23 VSS.n7 241.498
R22 VSS.n18 VSS.n11 226.601
R23 VSS.n21 VSS.n11 221.675
R24 VSS.t14 VSS.t5 210.885
R25 VSS.t30 VSS.t6 157.636
R26 VSS.t24 VSS.n8 142.857
R27 VSS.t11 VSS.t2 139.457
R28 VSS.t27 VSS.t8 139.457
R29 VSS.t0 VSS.n8 125.85
R30 VSS.t10 VSS.t24 125.85
R31 VSS.n6 VSS.t19 122.45
R32 VSS.n23 VSS.n22 122.45
R33 VSS.n13 VSS.n9 108.844
R34 VSS.n6 VSS.t23 85.0345
R35 VSS.n17 VSS.t14 85.0345
R36 VSS.t4 VSS.t16 78.8182
R37 VSS.t19 VSS.t0 78.2318
R38 VSS.t26 VSS.t11 71.4291
R39 VSS.t2 VSS.n9 71.4291
R40 VSS.n14 VSS.t27 51.0209
R41 VSS.n15 VSS.t26 44.2182
R42 VSS.n5 VSS.n4 0.97886
R43 VSS.n4 VSS.n3 0.97886
R44 VSS.t6 VSS.t7 32.0202
R45 VSS.t1 VSS.n1 8.66615
R46 VSS.t5 VSS.t25 27.2114
R47 VSS.t8 VSS.n13 27.2114
R48 VSS.n22 VSS.t1 17.0005
R49 VSS.t1 VSS.n14 17.0005
R50 VSS.t1 VSS.n9 17.0005
R51 VSS.t1 VSS.n15 17.0005
R52 VSS.t1 VSS.n17 17.0005
R53 VSS.t1 VSS.n16 17.0005
R54 VSS.t1 VSS.n8 17.0005
R55 VSS.t1 VSS.n6 17.0005
R56 VSS.t1 VSS.n7 17.0005
R57 VSS.t3 VSS.n9 17.0005
R58 VSS.t3 VSS.n1 8.28542
R59 VSS.t3 VSS.n8 17.0005
R60 VSS.t3 VSS.n6 17.0005
R61 VSS.t3 VSS.n7 17.0005
R62 VSS.t3 VSS.t15 17.0005
R63 VSS.n22 VSS.t3 15.3978
R64 VSS.n15 VSS.n0 15.3978
R65 VSS.n16 VSS.t3 15.3978
R66 VSS.n1 VSS.t10 61.9663
R67 VSS.n17 VSS.n0 15.3978
R68 VSS.n14 VSS.t3 15.3978
R69 VSS.n24 VSS.n23 10.8308
R70 VSS.n24 VSS.n11 10.8308
R71 VSS.t3 VSS.t29 5.66778
R72 VSS.t1 VSS.n12 5.66717
R73 VSS.t3 VSS.n10 5.66717
R74 VSS.n4 VSS.t34 4.82352
R75 VSS.t34 VSS.n2 3.82505
R76 VSS.t1 VSS.t12 3.75112
R77 VSS.t25 VSS.n16 3.40186
R78 VSS.n18 VSS.t3 2.34805
R79 VSS.t3 VSS.n2 1.73898
R80 VSS.t3 VSS.n0 1.60469
R81 VSS.t1 VSS.n21 1.54595
R82 VSS.n2 VSS.t1 1.26223
C0 VDD a_269_132# 0.24784f
C1 a_1151_139# a_910_606# 0.01058f
C2 sg13cmos5l_dfrbp_1_0.RESET_B a_1583_1177# 0.28974f
C3 a_38_1100# a_843_1222# 0.11742f
C4 a_612_1113# a_843_1222# 0.15089f
C5 a_741_1079# a_999_255# 0.01131f
C6 a_741_1079# a_324_1418# 0.48921f
C7 VDD a_999_255# 0.20538f
C8 VDD a_324_1418# 0.07206f
C9 a_1802_448# a_999_255# 0.15089f
C10 CLK_REF CLK_FB 0.27875f
C11 VDD a_741_1079# 0.24423f
C12 a_1941_215# a_1151_139# 0.02241f
C13 a_1020_529# CLK_FB 0.07424f
C14 a_1583_1177# a_324_1418# 0.01741f
C15 a_1151_139# a_843_1222# 0.01131f
C16 a_1941_215# a_1847_215# 0.87117f
C17 a_298_1323# sg13cmos5l_dfrbp_1_0.RESET_B 0.35211f
C18 sg13cmos5l_dfrbp_1_0.RESET_B CLK_FB 0.02524f
C19 DN UP 0.016f
C20 VDD a_1583_1177# 0.24784f
C21 sg13cmos5l_dfrbp_1_0.RESET_B sg13cmos5l_dfrbp_1_1.Q 0.60145f
C22 a_38_1100# sg13cmos5l_dfrbp_1_0.RESET_B 0.12379f
C23 a_150_455# a_269_132# 0.1333f
C24 a_269_132# sg13cmos5l_dfrbp_1_0.Q_N 0.04107f
C25 sg13cmos5l_dfrbp_1_0.RESET_B a_652_606# 0.18224f
C26 CLK_REF a_1151_139# 0.07128f
C27 DN a_843_1222# 0.0852f
C28 a_269_132# a_652_606# 0.35645f
C29 a_999_255# CLK_FB 0.03244f
C30 CLK_REF a_1847_215# 0.01259f
C31 a_298_1323# a_324_1418# 0.43042f
C32 a_1151_139# a_1020_529# 0.48921f
C33 a_1847_215# a_1020_529# 0.50066f
C34 VDD a_2420_1398# 0.35178f
C35 a_741_1079# a_298_1323# 0.02241f
C36 a_38_1100# a_324_1418# 0.50066f
C37 a_1151_139# sg13cmos5l_dfrbp_1_0.RESET_B 0.05935f
C38 VDD CLK_FB 0.14615f
C39 VDD a_298_1323# 0.09411f
C40 a_612_1113# a_324_1418# 0.4806f
C41 a_999_255# a_652_606# 0.06778f
C42 VDD sg13cmos5l_dfrbp_1_0.Q_N 0.17778f
C43 VDD a_150_455# 0.35423f
C44 a_1847_215# sg13cmos5l_dfrbp_1_0.RESET_B 0.09669f
C45 CLK_REF DN 0.15529f
C46 a_38_1100# a_741_1079# 0.02453f
C47 VDD sg13cmos5l_dfrbp_1_1.Q 0.79559f
C48 VDD a_38_1100# 1.25224f
C49 a_1020_529# a_910_606# 0.4858f
C50 a_741_1079# a_612_1113# 0.01562f
C51 a_2420_1398# a_1583_1177# 0.1333f
C52 a_1840_1320# UP 0.16675f
C53 VDD a_652_606# 0.14579f
C54 a_1583_1177# sg13cmos5l_dfrbp_1_1.Q 0.01586f
C55 a_1151_139# a_999_255# 0.66105f
C56 DN sg13cmos5l_dfrbp_1_0.RESET_B 2.2731f
C57 a_269_132# a_910_606# 0.32273f
C58 sg13cmos5l_dfrbp_1_0.RESET_B UP 0.1041f
C59 a_1847_215# a_999_255# 0.11742f
C60 CLK_REF a_843_1222# 0.01212f
C61 a_269_132# DN 0.01893f
C62 a_1840_1320# a_843_1222# 0.06778f
C63 VDD a_1151_139# 0.23803f
C64 a_1941_215# a_1020_529# 0.43042f
C65 a_1151_139# a_1802_448# 0.01562f
C66 VDD a_1847_215# 1.23841f
C67 a_1941_215# sg13cmos5l_dfrbp_1_0.RESET_B 0.32328f
C68 a_1847_215# a_1802_448# 0.36169f
C69 sg13cmos5l_dfrbp_1_0.RESET_B a_843_1222# 0.6162f
C70 DN a_324_1418# 0.0769f
C71 a_1840_1320# a_1489_1177# 0.01017f
C72 a_2420_1398# sg13cmos5l_dfrbp_1_1.Q 0.1442f
C73 a_150_455# sg13cmos5l_dfrbp_1_0.Q_N 0.25039f
C74 a_38_1100# a_298_1323# 0.87117f
C75 a_741_1079# DN 0.03873f
C76 VDD DN 1.05406f
C77 CLK_REF a_1020_529# 0.06317f
C78 sg13cmos5l_dfrbp_1_0.Q_N a_652_606# 0.15881f
C79 VDD UP 0.31411f
C80 sg13cmos5l_dfrbp_1_0.RESET_B a_1489_1177# 0.04541f
C81 a_38_1100# a_612_1113# 0.36169f
C82 CLK_REF sg13cmos5l_dfrbp_1_0.RESET_B 0.22845f
C83 a_843_1222# a_324_1418# 0.38902f
C84 sg13cmos5l_dfrbp_1_0.RESET_B a_1840_1320# 0.21347f
C85 UP a_1583_1177# 0.05838f
C86 a_1941_215# VDD 0.09373f
C87 a_1020_529# sg13cmos5l_dfrbp_1_0.RESET_B 0.50996f
C88 a_1151_139# CLK_FB 0.36499f
C89 a_741_1079# a_843_1222# 0.66105f
C90 VDD a_843_1222# 0.20538f
C91 a_269_132# a_1020_529# 0.01741f
C92 a_324_1418# a_1489_1177# 0.4858f
C93 CLK_REF a_999_255# 0.08405f
C94 a_269_132# sg13cmos5l_dfrbp_1_0.RESET_B 0.23316f
C95 CLK_REF a_324_1418# 0.09842f
C96 a_1583_1177# a_843_1222# 0.3087f
C97 a_741_1079# a_1489_1177# 0.01058f
C98 a_999_255# a_1020_529# 0.38902f
C99 CLK_REF a_741_1079# 0.36167f
C100 a_298_1323# DN 0.02054f
C101 CLK_REF VDD 0.15949f
C102 a_2420_1398# UP 0.30888f
C103 a_1306_2410# sg13cmos5l_dfrbp_1_0.RESET_B 0.01752f
C104 CLK_REF a_1802_448# 0.01021f
C105 VDD a_1840_1320# 0.14579f
C106 a_150_455# DN 0.15563f
C107 a_999_255# sg13cmos5l_dfrbp_1_0.RESET_B 0.55453f
C108 sg13cmos5l_dfrbp_1_0.RESET_B a_324_1418# 0.54607f
C109 a_910_606# a_652_606# 0.01017f
C110 DN sg13cmos5l_dfrbp_1_1.Q 0.08082f
C111 a_1583_1177# a_1489_1177# 0.32273f
C112 VDD a_1020_529# 0.07206f
C113 a_38_1100# DN 0.07759f
C114 UP sg13cmos5l_dfrbp_1_1.Q 0.97015f
C115 a_269_132# a_999_255# 0.3087f
C116 a_1802_448# a_1020_529# 0.4806f
C117 a_612_1113# DN 0.02211f
C118 a_1847_215# a_1151_139# 0.02453f
C119 a_741_1079# sg13cmos5l_dfrbp_1_0.RESET_B 0.10208f
C120 a_1840_1320# a_1583_1177# 0.35645f
C121 VDD sg13cmos5l_dfrbp_1_0.RESET_B 3.6759f
C122 UP 0 0.91047f
C123 a_2043_215# 0 0.0309f
C124 a_2594_606# 0 2.22178f
C125 a_910_291# 0 0.5831f
C126 a_1847_215# 0 2.43355f
C127 a_2198_593# 0 0.94441f
C128 a_1802_448# 0 1.19658f
C129 a_910_606# 0 0.11471f
C130 sg13cmos5l_dfrbp_1_0.Q_N 0 0.31062f
C131 a_1020_529# 0 0.01545f
C132 a_1489_1177# 0 0.21052f
C133 a_612_1113# 0 0.03666f
C134 a_1785_1415# 0 0.29738f
C135 a_132_1100# 0 0.45947f
C136 a_681_1491# 0 1.03054f
C137 a_38_1100# 0 1.64049f
C138 a_298_1323# 0 0.42116f
C139 a_1306_2410# 0 0.92955f
C140 VSS.t3 0 0.67299f
C141 VSS.t1 0 0.29622f
C142 VSS.t34 0 0.07758f
.ends
