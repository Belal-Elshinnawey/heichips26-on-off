* PEX produced on Sun Sep 20 10:42:50 CEST 2026 using scripts/sak-pex.sh with m=3 and s=1 (extresist threshold=10000 mOhm, minres=1000 mOhm, mindelay=1 ps)
* NGSPICE file created from ook_receiver_pex.ext - technology: ihp-sg13cmos5l

.subckt ook_receiver_pex VDD1_5 opm q0 vref0 q1 vref1 ACC_CAP q2 vref2 vref3 q3
+ VDD3_3 Cap_M11 Cap_M21 Cap_M1 Cap_M2 vin VSS lnaf
X0 VDD3_3.t6 M22_1/pmosHV$1_priv2_0.D M22_1/pmosHV$1_priv2_0.D VDD3_3.t0 sg13_hv_pmos ad=0.38p pd=2.38u as=0.38p ps=2.38u w=2u l=0.5u
X1 M23_0/pmosHV$1_priv3_0.D M22_0/pmosHV$1_priv2_0.D VDD3_3.t211 VDD3_3.t21 sg13_hv_pmos ad=0.38p pd=2.38u as=0.68p ps=4.68u w=2u l=0.5u
X2 M15_1/nmosHV$1_priv1_0.D M15_1/nmosHV$1_priv1_0.D M15_1/nmosHV$1_priv1_0.D VSS.t327 sg13_hv_nmos ad=0.34p pd=2.68u as=6.9973p ps=50.28u w=1u l=0.5u
X3 lnaf lnaf lnaf VSS.t255 sg13_hv_nmos ad=0.34p pd=2.68u as=16.0372p ps=91.63999u w=1u l=0.5u
X4 pmosHV_priv26_3.S ACC_CAP nmosHV_priv13_3.D VDD3_3.t49 sg13_hv_pmos ad=1.36p pd=8.68u as=1.36p ps=8.68u w=4u l=0.5u
X5 VDD3_3.t90 M24_1/pmosHV$1_priv4_0.D lnaf VDD3_3.t0 sg13_hv_pmos ad=0.38p pd=2.38u as=0.38p ps=2.38u w=2u l=0.5u
X6 VDD1_5 VDD1_5 VDD1_5 VDD1_5 sg13_hv_pmos ad=0.68p pd=4.68u as=76.7627p ps=0.16453m w=2u l=4u
X7 M23_0/pmosHV$1_priv3_0.D M22_0/pmosHV$1_priv2_0.D VDD3_3.t219 VDD3_3.t21 sg13_hv_pmos ad=0.38p pd=2.38u as=0.38p ps=2.38u w=2u l=0.5u
X8 VDD1_5 VDD1_5 VDD1_5 VDD1_5 sg13_hv_pmos ad=0.68p pd=4.68u as=0 ps=0 w=2u l=4u
X9 M21_1/nmosHV$5_priv1_0.D M21_1/nmosHV$5_priv1_0.D M21_1/nmosHV$5_priv1_0.D VSS.t5 sg13_hv_nmos ad=0.51p pd=3.68u as=16.6844p ps=93.14999u w=1.5u l=0.5u
X10 pmosHV_priv24_0.S ACC_CAP nmosHV_priv13_0.D VDD3_3.t40 sg13_hv_pmos ad=1.36p pd=8.68u as=1.36p ps=8.68u w=4u l=0.5u
X11 VSS.t398 Cap_M11 M23_2/pmosHV$1_priv3_0.D VSS.t397 sg13_hv_nmos ad=0.17p pd=1.68u as=0.17p ps=1.68u w=0.5u l=0.5u
X12 GROUP1$1_0.G GROUP1$1_0.G GROUP1$1_0.G VSS.t333 sg13_hv_nmos ad=0.68p pd=4.68u as=64.9628p ps=0.22442m w=2u l=4u
X13 M15_1/nmosHV$1_priv1_0.D Cap_M21 VSS.t70 VSS.t69 sg13_hv_nmos ad=0.19p pd=1.38u as=0.19p ps=1.38u w=1u l=0.5u
X14 lnaf VDD3_3.t227 M15_1/nmosHV$1_priv1_0.D VSS.t383 sg13_hv_nmos ad=0.34p pd=2.68u as=0.19p ps=1.38u w=1u l=0.5u
X15 GROUP1$1$3_0.G GROUP1$1$3_0.G GROUP1$1$3_0.G VDD3_3.t85 sg13_hv_pmos ad=0.68p pd=4.68u as=64.9628p ps=0.22442m w=2u l=4u
X16 VSS.t313 nmosHV_priv13_1.D nmosHV_priv13_1.D VSS.t312 sg13_hv_nmos ad=0.68p pd=4.68u as=0.68p ps=4.68u w=2u l=0.5u
X17 nmosHV_priv13_1.D nmosHV_priv13_1.D nmosHV_priv13_1.D VDD3_3.t42 sg13_hv_pmos ad=1.36p pd=8.68u as=31.50855p ps=0.11409m w=4u l=0.5u
X18 pmosHV_priv26_3.S ACC_CAP nmosHV_priv13_3.D VDD3_3.t49 sg13_hv_pmos ad=1.36p pd=8.68u as=1.36p ps=8.68u w=4u l=0.5u
X19 GROUP1$1$2_0.G GROUP1$3_0.G GROUP1$3_0.nmosHV_priv3$3_0.S VSS.t371 sg13_hv_nmos ad=0.68p pd=4.68u as=0.68p ps=4.68u w=2u l=4u
X20 VDD1_5 VDD1_5 VDD1_5 VDD1_5 sg13_hv_pmos ad=0.68p pd=4.68u as=0 ps=0 w=2u l=4u
X21 VSS.t294 nmosHV_priv13_2.D nmosHV_priv13_2.D VSS.t293 sg13_hv_nmos ad=0.68p pd=4.68u as=0.68p ps=4.68u w=2u l=0.5u
X22 VDD3_3.t97 M24_1/pmosHV$1_priv4_0.D M24_1/pmosHV$1_priv4_0.D VDD3_3.t0 sg13_hv_pmos ad=0.38p pd=2.38u as=0.38p ps=2.38u w=2u l=0.5u
X23 VDD3_3.t126 VDD3_3.t124 VDD3_3.t125 VDD3_3.t0 sg13_hv_pmos ad=0.68p pd=4.68u as=0 ps=0 w=2u l=0.5u
X24 M15_0/nmosHV$1_priv1_0.D vin VSS.t447 VSS.t446 sg13_hv_nmos ad=0.19p pd=1.38u as=0.19p ps=1.38u w=1u l=0.5u
X25 VDD3_3.t105 VDD3_3.t103 VDD3_3.t104 VDD3_3.t21 sg13_hv_pmos ad=0.68p pd=4.68u as=0 ps=0 w=2u l=0.5u
X26 VSS.t167 VSS.t165 VSS.t166 VSS.t9 sg13_hv_nmos ad=0.34p pd=2.68u as=0 ps=0 w=1u l=0.5u
X27 VDD1_5 VDD1_5 VDD1_5 VDD1_5 sg13_hv_pmos ad=0.68p pd=4.68u as=0 ps=0 w=2u l=4u
X28 GROUP3_0.G GROUP3_0.G VDD3_3.t58 VDD3_3.t19 sg13_hv_pmos ad=0.68p pd=4.68u as=0.38p ps=2.38u w=2u l=0.5u
X29 VSS.t16 Cap_M2 M15_2/nmosHV$1_priv1_0.D VSS.t9 sg13_hv_nmos ad=0.19p pd=1.38u as=0.19p ps=1.38u w=1u l=0.5u
X30 VDD3_3.t114 VDD3_3.t112 VDD3_3.t113 VDD3_3.t20 sg13_hv_pmos ad=0.68p pd=4.68u as=0 ps=0 w=2u l=0.5u
X31 VSS.t260 nmosHV_priv13_0.D GROUP1$4_0.G VSS.t259 sg13_hv_nmos ad=0.68p pd=4.68u as=0.68p ps=4.68u w=2u l=0.5u
X32 pmosHV_priv26_2.S vref2 GROUP1$3_0.G VDD3_3.t45 sg13_hv_pmos ad=1.36p pd=8.68u as=1.36p ps=8.68u w=4u l=0.5u
X33 pmosHV_priv16_1.S vref0 GROUP1_0.G VDD3_3.t42 sg13_hv_pmos ad=1.36p pd=8.68u as=1.36p ps=8.68u w=4u l=0.5u
X34 VDD3_3.t204 M22_2/pmosHV$1_priv2_0.D M23_2/pmosHV$1_priv3_0.D VDD3_3.t20 sg13_hv_pmos ad=0.38p pd=2.38u as=0.38p ps=2.38u w=2u l=0.5u
X35 VDD1_5 GROUP1$1$2_0.G q2 VDD1_5 sg13_hv_pmos ad=0.68p pd=4.68u as=0.68p ps=4.68u w=2u l=4u
X36 VDD3_3.t95 M24_1/pmosHV$1_priv4_0.D M24_1/pmosHV$1_priv4_0.D VDD3_3.t0 sg13_hv_pmos ad=0.38p pd=2.38u as=0.38p ps=2.38u w=2u l=0.5u
X37 VDD1_5 GROUP1$1$1_0.G q1 VDD1_5 sg13_hv_pmos ad=0.68p pd=4.68u as=0.68p ps=4.68u w=2u l=4u
X38 M20_1/nmosHV$5_priv2_0.D M20_1/nmosHV$5_priv2_0.D M20_1/nmosHV$5_priv2_0.D VSS.t430 sg13_hv_nmos ad=0.68p pd=4.68u as=37.62435p ps=0.10861m w=2u l=0.5u
X39 Cap_M11 Cap_M11 Cap_M11 VDD3_3.t20 sg13_hv_pmos ad=0.238p pd=2.08u as=16.0372p ps=91.63999u w=0.7u l=0.5u
X40 VSS.t361 nmosHV_priv13_3.D GROUP1$2_0.G VSS.t360 sg13_hv_nmos ad=0.68p pd=4.68u as=0.68p ps=4.68u w=2u l=0.5u
X41 pmosHV_priv26_2.S ACC_CAP nmosHV_priv13_2.D VDD3_3.t45 sg13_hv_pmos ad=1.36p pd=8.68u as=1.36p ps=8.68u w=4u l=0.5u
X42 M23_0/pmosHV$1_priv3_0.D M23_0/pmosHV$1_priv3_0.D M23_0/pmosHV$1_priv3_0.D VDD3_3.t21 sg13_hv_pmos ad=0.68p pd=4.68u as=11.7335p ps=72.64u w=2u l=0.5u
X43 opm ACC_CAP ACC_CAP opm sg13_hv_pmos ad=0.38p pd=2.38u as=0.38p ps=2.38u w=2u l=0.5u
X44 nmosHV_priv13_3.D nmosHV_priv13_3.D nmosHV_priv13_3.D VSS.t353 sg13_hv_nmos ad=0.68p pd=4.68u as=31.50855p ps=0.11409m w=2u l=0.5u
X45 VDD3_3.t159 VDD3_3.t157 VDD3_3.t158 VDD3_3.t48 sg13_hv_pmos ad=1.36p pd=8.68u as=0 ps=0 w=4u l=0.5u
X46 M23_1/pmosHV$1_priv3_0.D M23_1/pmosHV$1_priv3_0.D M23_1/pmosHV$1_priv3_0.D VDD3_3.t0 sg13_hv_pmos ad=0.68p pd=4.68u as=11.7335p ps=72.64u w=2u l=0.5u
X47 VDD3_3.t117 VDD3_3.t115 VDD3_3.t116 VSS.t379 sg13_hv_nmos ad=0.51p pd=3.68u as=0 ps=0 w=1.5u l=0.5u
X48 VSS.t367 nmosHV_priv13_3.D nmosHV_priv13_3.D VSS.t366 sg13_hv_nmos ad=0.68p pd=4.68u as=0.68p ps=4.68u w=2u l=0.5u
X49 pmosHV_priv24_0.S pmosHV_priv24_0.S pmosHV_priv24_0.S VDD3_3.t16 sg13_hv_pmos ad=1.36p pd=8.68u as=30.225p ps=0.1221m w=4u l=0.5u
X50 VSS.t55 Cap_M21 M15_1/nmosHV$1_priv1_0.D VSS.t56 sg13_hv_nmos ad=0.19p pd=1.38u as=0.19p ps=1.38u w=1u l=0.5u
X51 M22_2/pmosHV$1_priv2_0.D VSS.t37 VSS.t36 rhigh l=15.02u w=2u
X52 VSS.t215 VSS.t212 VSS.t214 VSS.t213 sg13_hv_nmos ad=0.68p pd=4.68u as=0 ps=0 w=2u l=4u
X53 q3 q3 q3 VSS.t415 sg13_hv_nmos ad=0.68p pd=4.68u as=29.0796p ps=57.16u w=2u l=4u
X54 VDD1_5 GROUP1$1_0.G q0 VDD1_5 sg13_hv_pmos ad=0.68p pd=4.68u as=0.68p ps=4.68u w=2u l=4u
X55 VSS.t73 Cap_M21 M15_1/nmosHV$1_priv1_0.D VSS.t74 sg13_hv_nmos ad=0.19p pd=1.38u as=0.19p ps=1.38u w=1u l=0.5u
X56 VSS.t129 VSS.t126 VSS.t128 VSS.t127 sg13_hv_nmos ad=0.17p pd=1.68u as=0 ps=0 w=0.5u l=0.5u
X57 M22_0/pmosHV$1_priv2_0.D M22_0/pmosHV$1_priv2_0.D VDD3_3.t215 VDD3_3.t21 sg13_hv_pmos ad=0.38p pd=2.38u as=0.38p ps=2.38u w=2u l=0.5u
X58 pmosHV_priv26_2.S vref2 GROUP1$3_0.G VDD3_3.t45 sg13_hv_pmos ad=1.36p pd=8.68u as=1.36p ps=8.68u w=4u l=0.5u
X59 GROUP3$1_0.G VSS.t375 VSS.t374 rhigh l=0.1483m w=2u
X60 VDD3_3.t174 VDD3_3.t172 VDD3_3.t173 VDD3_3.t19 sg13_hv_pmos ad=0.68p pd=4.68u as=0 ps=0 w=2u l=0.5u
X61 GROUP3_0.G GROUP3_0.G GROUP3_0.G VDD3_3.t19 sg13_hv_pmos ad=0.68p pd=4.68u as=33.483p ps=0.1089m w=2u l=0.5u
X62 M22_2/pmosHV$1_priv2_0.D M22_2/pmosHV$1_priv2_0.D VDD3_3.t200 VDD3_3.t20 sg13_hv_pmos ad=0.38p pd=2.38u as=0.38p ps=2.38u w=2u l=0.5u
X63 VSS.t439 M2_2/nmosHV$3_priv4_0.D lnaf VSS.t438 sg13_hv_nmos ad=0.17p pd=1.68u as=0.17p ps=1.68u w=0.5u l=0.5u
X64 VSS.t227 M20_0/nmosHV$5_priv2_0.D M20_0/nmosHV$5_priv2_0.D VSS.t226 sg13_hv_nmos ad=0.38p pd=2.38u as=0.38p ps=2.38u w=2u l=0.5u
X65 Cap_M1 Cap_M1 Cap_M1 VDD3_3.t21 sg13_hv_pmos ad=0.68p pd=4.68u as=16.0372p ps=91.63999u w=2u l=0.5u
X66 Cap_M11 Cap_M11 Cap_M11 VDD3_3.t20 sg13_hv_pmos ad=0.68p pd=4.68u as=0 ps=0 w=2u l=0.5u
X67 VSS.t300 nmosHV_priv13_2.D GROUP1$3_0.G VSS.t299 sg13_hv_nmos ad=0.68p pd=4.68u as=0.68p ps=4.68u w=2u l=0.5u
X68 VDD3_3.t219 M22_0/pmosHV$1_priv2_0.D M23_0/pmosHV$1_priv3_0.D VDD3_3.t21 sg13_hv_pmos ad=0.38p pd=2.38u as=0.38p ps=2.38u w=2u l=0.5u
X69 pmosHV_priv16_1.S ACC_CAP nmosHV_priv13_1.D VDD3_3.t42 sg13_hv_pmos ad=1.36p pd=8.68u as=1.36p ps=8.68u w=4u l=0.5u
X70 M21_0/nmosHV$5_priv1_0.D M21_0/nmosHV$5_priv1_0.D M21_0/nmosHV$5_priv1_0.D VSS.t391 sg13_hv_nmos ad=0.68p pd=4.68u as=16.6844p ps=93.14999u w=2u l=0.5u
X71 VSS.t339 M16_1/nmosHV$2_priv1_0.D M16_1/nmosHV$2_priv1_0.D VSS.t340 sg13_hv_nmos ad=0.19p pd=1.38u as=0.34p ps=2.68u w=1u l=0.5u
X72 VSS.t70 Cap_M21 M15_1/nmosHV$1_priv1_0.D VSS.t71 sg13_hv_nmos ad=0.19p pd=1.38u as=0.19p ps=1.38u w=1u l=0.5u
X73 M21_1/nmosHV$5_priv1_0.D M21_1/nmosHV$5_priv1_0.D M21_1/nmosHV$5_priv1_0.D VSS.t6 sg13_hv_nmos ad=0.68p pd=4.68u as=0 ps=0 w=2u l=0.5u
X74 VDD3_3.t165 VDD3_3.t163 VDD3_3.t164 VDD3_3.t44 sg13_hv_pmos ad=1.36p pd=8.68u as=0 ps=0 w=4u l=0.5u
X75 M16_0/nmosHV$2_priv1_0.D M16_0/nmosHV$2_priv1_0.D M16_0/nmosHV$2_priv1_0.D VSS.t41 sg13_hv_nmos ad=0.34p pd=2.68u as=34.1645p ps=81.03u w=1u l=0.5u
X76 M15_2/nmosHV$1_priv1_0.D Cap_M2 VSS.t20 VSS.t9 sg13_hv_nmos ad=0.19p pd=1.38u as=0.19p ps=1.38u w=1u l=0.5u
X77 VDD3_3.t9 M22_1/pmosHV$1_priv2_0.D M23_1/pmosHV$1_priv3_0.D VDD3_3.t0 sg13_hv_pmos ad=0.38p pd=2.38u as=0.38p ps=2.38u w=2u l=0.5u
X78 GROUP1$4_0.G GROUP1$4_0.G GROUP1$4_0.G VDD3_3.t40 sg13_hv_pmos ad=1.36p pd=8.68u as=54.5816p ps=0.24978m w=4u l=0.5u
X79 VDD3_3.t150 VDD3_3.t148 VDD3_3.t149 VDD3_3.t41 sg13_hv_pmos ad=1.36p pd=8.68u as=0 ps=0 w=4u l=0.5u
X80 VDD3_3.t26 M24_0/pmosHV$1_priv4_0.D Cap_M1 VDD3_3.t21 sg13_hv_pmos ad=0.38p pd=2.38u as=0.38p ps=2.38u w=2u l=0.5u
X81 VSS.t132 VSS.t130 VSS.t131 VDD3_3.t0 sg13_hv_pmos ad=0.238p pd=2.08u as=0 ps=0 w=0.7u l=0.5u
X82 VDD3_3.t221 M22_0/pmosHV$1_priv2_0.D M23_0/pmosHV$1_priv3_0.D VDD3_3.t21 sg13_hv_pmos ad=0.38p pd=2.38u as=0.38p ps=2.38u w=2u l=0.5u
X83 VDD3_3.t74 M24_2/pmosHV$1_priv4_0.D Cap_M11 VDD3_3.t20 sg13_hv_pmos ad=0.38p pd=2.38u as=0.38p ps=2.38u w=2u l=0.5u
X84 GROUP1$3_0.G GROUP1$3_0.G GROUP1$3_0.G VSS.t370 sg13_hv_nmos ad=0.68p pd=4.68u as=54.5816p ps=0.24978m w=2u l=0.5u
X85 VSS.t207 VSS.t204 VSS.t206 VSS.t205 sg13_hv_nmos ad=0.68p pd=4.68u as=0 ps=0 w=2u l=4u
X86 VSS.t171 VSS.t168 VSS.t170 VSS.t169 sg13_hv_nmos ad=0.34p pd=2.68u as=0 ps=0 w=1u l=0.5u
X87 VSS.t392 M21_0/nmosHV$5_priv1_0.D Cap_M1 VDD3_3.t21 sg13_hv_pmos ad=0.238p pd=2.08u as=0.238p ps=2.08u w=0.7u l=0.5u
X88 VSS.t304 nmosHV_priv13_2.D nmosHV_priv13_2.D VSS.t303 sg13_hv_nmos ad=0.68p pd=4.68u as=0.68p ps=4.68u w=2u l=0.5u
X89 pmosHV_priv24_0.S pmosHV_priv24_0.S pmosHV_priv24_0.S VDD3_3.t40 sg13_hv_pmos ad=1.36p pd=8.68u as=0 ps=0 w=4u l=0.5u
X90 VSS.t164 VSS.t161 VSS.t163 VSS.t162 sg13_hv_nmos ad=0.34p pd=2.68u as=0 ps=0 w=1u l=0.5u
X91 M15_2/nmosHV$1_priv1_0.D Cap_M2 VSS.t10 VSS.t9 sg13_hv_nmos ad=0.34p pd=2.68u as=0.19p ps=1.38u w=1u l=0.5u
X92 VSS.t453 vin M15_0/nmosHV$1_priv1_0.D VSS.t454 sg13_hv_nmos ad=0.19p pd=1.38u as=0.19p ps=1.38u w=1u l=0.5u
X93 VSS.t323 nmosHV_priv13_1.D nmosHV_priv13_1.D VSS.t322 sg13_hv_nmos ad=0.68p pd=4.68u as=0.68p ps=4.68u w=2u l=0.5u
X94 q3 GROUP1$1$3_0.G VSS.t411 VSS.t410 sg13_hv_nmos ad=0.68p pd=4.68u as=0.68p ps=4.68u w=2u l=4u
X95 M24_1/pmosHV$1_priv4_0.D M24_1/pmosHV$1_priv4_0.D VDD3_3.t99 VDD3_3.t0 sg13_hv_pmos ad=0.38p pd=2.38u as=0.38p ps=2.38u w=2u l=0.5u
X96 M15_2/nmosHV$1_priv1_0.D Cap_M2 VSS.t22 VSS.t9 sg13_hv_nmos ad=0.19p pd=1.38u as=0.19p ps=1.38u w=1u l=0.5u
X97 pmosHV_priv26_3.S pmosHV_priv26_3.S pmosHV_priv26_3.S VDD3_3.t49 sg13_hv_pmos ad=1.36p pd=8.68u as=30.225p ps=0.1221m w=4u l=0.5u
X98 M20_2/nmosHV$5_priv2_0.D M20_2/nmosHV$5_priv2_0.D VSS.t278 VSS.t277 sg13_hv_nmos ad=0.38p pd=2.38u as=0.68p ps=4.68u w=2u l=0.5u
X99 M21_0/nmosHV$5_priv1_0.D M23_0/pmosHV$1_priv3_0.D VDD3_3.t192 VSS.t403 sg13_hv_nmos ad=0.51p pd=3.68u as=0.51p ps=3.68u w=1.5u l=0.5u
X100 GROUP1$4_0.nmosHV_priv3$4_0.S VSS.t223 VSS.t222 rhigh l=0.12344m w=2u
X101 VDD3_3.t141 VDD3_3.t139 VDD3_3.t140 VDD3_3.t21 sg13_hv_pmos ad=0.68p pd=4.68u as=0 ps=0 w=2u l=0.5u
X102 M21_2/nmosHV$5_priv1_0.D M20_2/nmosHV$5_priv2_0.D VSS.t276 VSS.t275 sg13_hv_nmos ad=0.38p pd=2.38u as=0.68p ps=4.68u w=2u l=0.5u
X103 VSS.t272 nmosHV_priv13_0.D GROUP1$4_0.G VSS.t271 sg13_hv_nmos ad=0.68p pd=4.68u as=0.68p ps=4.68u w=2u l=0.5u
X104 VDD3_3.t144 VDD3_3.t142 VDD3_3.t143 VDD3_3.t20 sg13_hv_pmos ad=0.68p pd=4.68u as=0 ps=0 w=2u l=0.5u
X105 pmosHV_priv24_0.S vref3 GROUP1$4_0.G VDD3_3.t40 sg13_hv_pmos ad=1.36p pd=8.68u as=1.36p ps=8.68u w=4u l=0.5u
X106 M16_0/nmosHV$2_priv1_0.D VDD3_3.t210 VSS.t414 rhigh l=0.20002m w=2u
X107 VSS.t359 nmosHV_priv13_3.D GROUP1$2_0.G VSS.t358 sg13_hv_nmos ad=0.68p pd=4.68u as=0.68p ps=4.68u w=2u l=0.5u
X108 GROUP1_0.nmosHV_priv3_0.S VSS.t407 VSS.t406 rhigh l=0.12344m w=2u
X109 VSS.t268 nmosHV_priv13_0.D GROUP1$4_0.G VSS.t267 sg13_hv_nmos ad=0.68p pd=4.68u as=0.68p ps=4.68u w=2u l=0.5u
X110 opm GROUP3_0.G VDD3_3.t68 VDD3_3.t19 sg13_hv_pmos ad=0.38p pd=2.38u as=0.68p ps=4.68u w=2u l=0.5u
X111 M21_2/nmosHV$5_priv1_0.D M23_1/pmosHV$1_priv3_0.D VDD3_3.t37 VSS.t33 sg13_hv_nmos ad=0.51p pd=3.68u as=0.51p ps=3.68u w=1.5u l=0.5u
X112 VSS.t365 nmosHV_priv13_3.D GROUP1$2_0.G VSS.t364 sg13_hv_nmos ad=0.68p pd=4.68u as=0.68p ps=4.68u w=2u l=0.5u
X113 ACC_CAP ACC_CAP opm opm sg13_hv_pmos ad=0.38p pd=2.38u as=0.38p ps=2.38u w=2u l=0.5u
X114 M23_1/pmosHV$1_priv3_0.D M23_1/pmosHV$1_priv3_0.D M23_1/pmosHV$1_priv3_0.D VSS.t34 sg13_hv_nmos ad=0.17p pd=1.68u as=0 ps=0 w=0.5u l=0.5u
X115 VSS.t236 M20_0/nmosHV$5_priv2_0.D M21_0/nmosHV$5_priv1_0.D VSS.t235 sg13_hv_nmos ad=0.38p pd=2.38u as=0.38p ps=2.38u w=2u l=0.5u
X116 VSS.t106 VSS.t103 VSS.t105 VSS.t104 sg13_hv_nmos ad=0.17p pd=1.68u as=0 ps=0 w=0.5u l=0.5u
X117 VDD3_3.t87 M24_1/pmosHV$1_priv4_0.D lnaf VDD3_3.t0 sg13_hv_pmos ad=0.68p pd=4.68u as=0.38p ps=2.38u w=2u l=0.5u
X118 VSS.t125 VSS.t122 VSS.t124 VSS.t123 sg13_hv_nmos ad=0.17p pd=1.68u as=0 ps=0 w=0.5u l=0.5u
X119 VSS.t345 Cap_M1 M23_0/pmosHV$1_priv3_0.D VSS.t344 sg13_hv_nmos ad=0.17p pd=1.68u as=0.17p ps=1.68u w=0.5u l=0.5u
X120 opm GROUP3_0.G VDD3_3.t59 VDD3_3.t19 sg13_hv_pmos ad=0.38p pd=2.38u as=0.38p ps=2.38u w=2u l=0.5u
X121 VDD3_3.t30 M24_0/pmosHV$1_priv4_0.D M24_0/pmosHV$1_priv4_0.D VDD3_3.t21 sg13_hv_pmos ad=0.38p pd=2.38u as=0.38p ps=2.38u w=2u l=0.5u
X122 M15_1/nmosHV$1_priv1_0.D Cap_M21 VSS.t64 VSS.t63 sg13_hv_nmos ad=0.19p pd=1.38u as=0.19p ps=1.38u w=1u l=0.5u
X123 VDD3_3.t78 M24_2/pmosHV$1_priv4_0.D M24_2/pmosHV$1_priv4_0.D VDD3_3.t20 sg13_hv_pmos ad=0.38p pd=2.38u as=0.38p ps=2.38u w=2u l=0.5u
X124 VDD3_3.t186 VDD3_3.t184 VDD3_3.t185 VDD3_3.t15 sg13_hv_pmos ad=0.68p pd=4.68u as=0 ps=0 w=2u l=4u
X125 pmosHV_priv26_2.S pmosHV_priv26_2.S pmosHV_priv26_2.S VDD3_3.t45 sg13_hv_pmos ad=1.36p pd=8.68u as=30.225p ps=0.1221m w=4u l=0.5u
X126 VSS.t91 VSS.t88 VSS.t90 VSS.t89 sg13_hv_nmos ad=0.68p pd=4.68u as=0 ps=0 w=2u l=0.5u
X127 VSS.t191 VSS.t188 VSS.t190 VSS.t189 sg13_hv_nmos ad=0.68p pd=4.68u as=0 ps=0 w=2u l=0.5u
X128 VDD3_3.t183 VDD3_3.t181 VDD3_3.t182 VDD3_3.t51 sg13_hv_pmos ad=0.68p pd=4.68u as=0 ps=0 w=2u l=4u
X129 lnaf lnaf lnaf VDD3_3.t0 sg13_hv_pmos ad=0.238p pd=2.08u as=0 ps=0 w=0.7u l=0.5u
X130 pmosHV_priv26_3.S pmosHV_priv26_3.S pmosHV_priv26_3.S VDD3_3.t48 sg13_hv_pmos ad=1.36p pd=8.68u as=0 ps=0 w=4u l=0.5u
X131 VSS.t140 VSS.t137 VSS.t139 VSS.t138 sg13_hv_nmos ad=0.68p pd=4.68u as=0 ps=0 w=2u l=0.5u
X132 M23_2/pmosHV$1_priv3_0.D M23_2/pmosHV$1_priv3_0.D M23_2/pmosHV$1_priv3_0.D VDD3_3.t20 sg13_hv_pmos ad=0.68p pd=4.68u as=11.7335p ps=72.64u w=2u l=0.5u
X133 VDD3_3.t135 VDD3_3.t133 VDD3_3.t134 VDD3_3.t0 sg13_hv_pmos ad=0.68p pd=4.68u as=0 ps=0 w=2u l=0.5u
X134 M16_1/nmosHV$2_priv1_0.D VDD3_3.t190 VSS.t400 rhigh l=0.20002m w=2u
X135 VSS.t12 Cap_M2 M15_2/nmosHV$1_priv1_0.D VSS.t9 sg13_hv_nmos ad=0.19p pd=1.38u as=0.19p ps=1.38u w=1u l=0.5u
X136 M22_1/pmosHV$1_priv2_0.D M22_1/pmosHV$1_priv2_0.D VDD3_3.t1 VDD3_3.t0 sg13_hv_pmos ad=0.38p pd=2.38u as=0.68p ps=4.68u w=2u l=0.5u
X137 M15_0/nmosHV$1_priv1_0.D vin VSS.t459 VSS.t458 sg13_hv_nmos ad=0.19p pd=1.38u as=0.19p ps=1.38u w=1u l=0.5u
X138 M20_0/nmosHV$5_priv2_0.D M20_0/nmosHV$5_priv2_0.D VSS.t225 VSS.t224 sg13_hv_nmos ad=0.38p pd=2.38u as=0.68p ps=4.68u w=2u l=0.5u
X139 VDD3_3.t189 VDD3_3.t187 VDD3_3.t188 VDD3_3.t85 sg13_hv_pmos ad=0.68p pd=4.68u as=0 ps=0 w=2u l=4u
X140 VSS.t179 VSS.t176 VSS.t178 VSS.t177 sg13_hv_nmos ad=0.68p pd=4.68u as=0 ps=0 w=2u l=0.5u
X141 VSS.t211 VSS.t208 VSS.t210 VSS.t209 sg13_hv_nmos ad=0.68p pd=4.68u as=0 ps=0 w=2u l=4u
X142 VSS.t24 Cap_M2 M15_2/nmosHV$1_priv1_0.D VSS.t9 sg13_hv_nmos ad=0.19p pd=1.38u as=0.19p ps=1.38u w=1u l=0.5u
X143 M20_1/nmosHV$5_priv2_0.D M20_1/nmosHV$5_priv2_0.D VSS.t423 VSS.t422 sg13_hv_nmos ad=0.38p pd=2.38u as=0.68p ps=4.68u w=2u l=0.5u
X144 VDD3_3.t202 M22_2/pmosHV$1_priv2_0.D M22_2/pmosHV$1_priv2_0.D VDD3_3.t20 sg13_hv_pmos ad=0.38p pd=2.38u as=0.38p ps=2.38u w=2u l=0.5u
X145 vref0 vref1 VSS.t47 rhigh l=2.8u w=2u
X146 VSS.t264 nmosHV_priv13_0.D nmosHV_priv13_0.D VSS.t263 sg13_hv_nmos ad=0.68p pd=4.68u as=0.68p ps=4.68u w=2u l=0.5u
X147 M15_0/nmosHV$1_priv1_0.D vin VSS.t444 VSS.t443 sg13_hv_nmos ad=0.34p pd=2.68u as=0.19p ps=1.38u w=1u l=0.5u
X148 VDD3_3.t180 VDD3_3.t178 VDD3_3.t179 VDD3_3.t84 sg13_hv_pmos ad=0.68p pd=4.68u as=0 ps=0 w=2u l=4u
X149 GROUP3$1_3.G GROUP3$1_3.G GROUP3$1_3.G VDD3_3.t44 sg13_hv_pmos ad=1.36p pd=8.68u as=38.75025p ps=92.41u w=4u l=0.5u
X150 VSS.t14 Cap_M2 M15_2/nmosHV$1_priv1_0.D VSS.t9 sg13_hv_nmos ad=0.19p pd=1.38u as=0.19p ps=1.38u w=1u l=0.5u
X151 M15_0/nmosHV$1_priv1_0.D vin VSS.t462 VSS.t461 sg13_hv_nmos ad=0.19p pd=1.38u as=0.19p ps=1.38u w=1u l=0.5u
X152 M23_1/pmosHV$1_priv3_0.D M22_1/pmosHV$1_priv2_0.D VDD3_3.t9 VDD3_3.t0 sg13_hv_pmos ad=0.38p pd=2.38u as=0.38p ps=2.38u w=2u l=0.5u
X153 VSS.t363 nmosHV_priv13_3.D nmosHV_priv13_3.D VSS.t362 sg13_hv_nmos ad=0.68p pd=4.68u as=0.68p ps=4.68u w=2u l=0.5u
X154 GROUP1$2_0.G GROUP1$2_0.G GROUP1$2_0.G VDD3_3.t49 sg13_hv_pmos ad=1.36p pd=8.68u as=54.5816p ps=0.24978m w=4u l=0.5u
X155 VSS.t26 Cap_M2 M15_2/nmosHV$1_priv1_0.D VSS.t9 sg13_hv_nmos ad=0.19p pd=1.38u as=0.34p ps=2.68u w=1u l=0.5u
X156 M23_2/pmosHV$1_priv3_0.D M22_2/pmosHV$1_priv2_0.D VDD3_3.t204 VDD3_3.t20 sg13_hv_pmos ad=0.38p pd=2.38u as=0.38p ps=2.38u w=2u l=0.5u
X157 VDD3_3.t147 VDD3_3.t145 VDD3_3.t146 VDD3_3.t0 sg13_hv_pmos ad=0.68p pd=4.68u as=0 ps=0 w=2u l=0.5u
X158 Cap_M1 Cap_M1 Cap_M1 VSS.t346 sg13_hv_nmos ad=0.17p pd=1.68u as=0 ps=0 w=0.5u l=0.5u
X159 VSS.t270 nmosHV_priv13_0.D nmosHV_priv13_0.D VSS.t269 sg13_hv_nmos ad=0.68p pd=4.68u as=0.68p ps=4.68u w=2u l=0.5u
X160 VDD3_3.t101 GROUP1$3_0.G GROUP1$1$2_0.G VDD3_3.t15 sg13_hv_pmos ad=0.68p pd=4.68u as=0.68p ps=4.68u w=2u l=4u
X161 Cap_M11 Cap_M11 Cap_M11 VSS.t399 sg13_hv_nmos ad=0.17p pd=1.68u as=0 ps=0 w=0.5u l=0.5u
X162 VDD3_3.t61 GROUP3_0.G opm VDD3_3.t19 sg13_hv_pmos ad=0.38p pd=2.38u as=0.38p ps=2.38u w=2u l=0.5u
X163 M23_1/pmosHV$1_priv3_0.D M22_1/pmosHV$1_priv2_0.D VDD3_3.t11 VDD3_3.t0 sg13_hv_pmos ad=0.38p pd=2.38u as=0.38p ps=2.38u w=2u l=0.5u
X164 M15_2/nmosHV$1_priv1_0.D M15_2/nmosHV$1_priv1_0.D M15_2/nmosHV$1_priv1_0.D VSS.t250 sg13_hv_nmos ad=0.34p pd=2.68u as=6.9973p ps=50.28u w=1u l=0.5u
X165 M15_0/nmosHV$1_priv1_0.D M15_0/nmosHV$1_priv1_0.D M15_0/nmosHV$1_priv1_0.D VSS.t372 sg13_hv_nmos ad=0.34p pd=2.68u as=6.9973p ps=50.28u w=1u l=0.5u
X166 VSS.t311 nmosHV_priv13_1.D nmosHV_priv13_1.D VSS.t310 sg13_hv_nmos ad=0.68p pd=4.68u as=0.68p ps=4.68u w=2u l=0.5u
X167 VDD3_3.t52 GROUP1$2_0.G GROUP1$1$1_0.G VDD3_3.t51 sg13_hv_pmos ad=0.68p pd=4.68u as=0.68p ps=4.68u w=2u l=4u
X168 VDD3_3.t94 M24_1/pmosHV$1_priv4_0.D M24_1/pmosHV$1_priv4_0.D VDD3_3.t0 sg13_hv_pmos ad=0.68p pd=4.68u as=0.38p ps=2.38u w=2u l=0.5u
X169 M2_0/nmosHV$3_priv4_0.D M2_0/nmosHV$3_priv4_0.D M2_0/nmosHV$3_priv4_0.D VSS.t348 sg13_hv_nmos ad=0.17p pd=1.68u as=14.44555p ps=50.73u w=0.5u l=0.5u
X170 M16_2/nmosHV$2_priv1_0.D M16_2/nmosHV$2_priv1_0.D M16_2/nmosHV$2_priv1_0.D VSS.t154 sg13_hv_nmos ad=0.34p pd=2.68u as=34.1645p ps=81.03u w=1u l=0.5u
X171 VSS.t7 M21_1/nmosHV$5_priv1_0.D Cap_M11 VDD3_3.t20 sg13_hv_pmos ad=0.238p pd=2.08u as=0.238p ps=2.08u w=0.7u l=0.5u
X172 VDD3_3.t56 GROUP3_0.G opm VDD3_3.t19 sg13_hv_pmos ad=0.38p pd=2.38u as=0.38p ps=2.38u w=2u l=0.5u
X173 VSS.t280 M20_2/nmosHV$5_priv2_0.D M20_2/nmosHV$5_priv2_0.D VSS.t279 sg13_hv_nmos ad=0.38p pd=2.38u as=0.38p ps=2.38u w=2u l=0.5u
X174 opm ACC_CAP ACC_CAP opm sg13_hv_pmos ad=0.38p pd=2.38u as=0.38p ps=2.38u w=2u l=0.5u
X175 pmosHV_priv26_3.S vref1 GROUP1$2_0.G VDD3_3.t49 sg13_hv_pmos ad=1.36p pd=8.68u as=1.36p ps=8.68u w=4u l=0.5u
X176 VSS.t329 vref0 VSS.t328 rhigh l=12.9u w=2u
X177 VSS.t287 M20_2/nmosHV$5_priv2_0.D M21_2/nmosHV$5_priv1_0.D VSS.t286 sg13_hv_nmos ad=0.38p pd=2.38u as=0.38p ps=2.38u w=2u l=0.5u
X178 lnaf M24_1/pmosHV$1_priv4_0.D VDD3_3.t92 VDD3_3.t0 sg13_hv_pmos ad=0.38p pd=2.38u as=0.38p ps=2.38u w=2u l=0.5u
X179 M21_0/nmosHV$5_priv1_0.D M20_0/nmosHV$5_priv2_0.D VSS.t234 VSS.t233 sg13_hv_nmos ad=0.38p pd=2.38u as=0.68p ps=4.68u w=2u l=0.5u
X180 GROUP1$1$3_0.G GROUP1$1$3_0.G GROUP1$1$3_0.G VSS.t409 sg13_hv_nmos ad=0.68p pd=4.68u as=0 ps=0 w=2u l=4u
X181 GROUP1$3_0.nmosHV_priv3$3_0.S GROUP1$3_0.nmosHV_priv3$3_0.S GROUP1$3_0.nmosHV_priv3$3_0.S VSS.t251 sg13_hv_nmos ad=0.68p pd=4.68u as=15.7454p ps=34.18u w=2u l=4u
X182 M21_1/nmosHV$5_priv1_0.D M20_1/nmosHV$5_priv2_0.D VSS.t421 VSS.t420 sg13_hv_nmos ad=0.38p pd=2.38u as=0.68p ps=4.68u w=2u l=0.5u
X183 M21_1/nmosHV$5_priv1_0.D M23_2/pmosHV$1_priv3_0.D VDD3_3.t102 VSS.t376 sg13_hv_nmos ad=0.51p pd=3.68u as=0.51p ps=3.68u w=1.5u l=0.5u
X184 VDD3_3.t191 GROUP1_0.G GROUP1$1_0.G VDD3_3.t84 sg13_hv_pmos ad=0.68p pd=4.68u as=0.68p ps=4.68u w=2u l=4u
X185 GROUP1$3_0.G GROUP1$3_0.G GROUP1$3_0.G VDD3_3.t45 sg13_hv_pmos ad=1.36p pd=8.68u as=0 ps=0 w=4u l=0.5u
X186 Cap_M2 M16_2/nmosHV$2_priv1_0.D VSS.t249 rhigh l=40u w=2u
X187 GROUP3_0.G GROUP3_0.G VDD3_3.t62 VDD3_3.t19 sg13_hv_pmos ad=0.38p pd=2.38u as=0.38p ps=2.38u w=2u l=0.5u
X188 VDD3_3.t217 M22_0/pmosHV$1_priv2_0.D M22_0/pmosHV$1_priv2_0.D VDD3_3.t21 sg13_hv_pmos ad=0.38p pd=2.38u as=0.38p ps=2.38u w=2u l=0.5u
X189 opm ACC_CAP ACC_CAP opm sg13_hv_pmos ad=0.38p pd=2.38u as=0.38p ps=2.38u w=2u l=0.5u
X190 VDD3_3.t23 M24_0/pmosHV$1_priv4_0.D Cap_M1 VDD3_3.t21 sg13_hv_pmos ad=0.68p pd=4.68u as=0.38p ps=2.38u w=2u l=0.5u
X191 VDD3_3.t71 M24_2/pmosHV$1_priv4_0.D Cap_M11 VDD3_3.t20 sg13_hv_pmos ad=0.68p pd=4.68u as=0.38p ps=2.38u w=2u l=0.5u
X192 VSS.t144 VSS.t141 VSS.t143 VSS.t142 sg13_hv_nmos ad=0.17p pd=1.68u as=0 ps=0 w=0.5u l=0.5u
X193 VSS.t308 nmosHV_priv13_2.D GROUP1$3_0.G VSS.t307 sg13_hv_nmos ad=0.68p pd=4.68u as=0.68p ps=4.68u w=2u l=0.5u
X194 VSS.t447 vin M15_0/nmosHV$1_priv1_0.D VSS.t448 sg13_hv_nmos ad=0.19p pd=1.38u as=0.19p ps=1.38u w=1u l=0.5u
X195 pmosHV_priv26_2.S ACC_CAP nmosHV_priv13_2.D VDD3_3.t45 sg13_hv_pmos ad=1.36p pd=8.68u as=1.36p ps=8.68u w=4u l=0.5u
X196 M15_2/nmosHV$1_priv1_0.D Cap_M2 VSS.t18 VSS.t9 sg13_hv_nmos ad=0.19p pd=1.38u as=0.19p ps=1.38u w=1u l=0.5u
X197 GROUP1_0.nmosHV_priv3_0.S GROUP1_0.nmosHV_priv3_0.S GROUP1_0.nmosHV_priv3_0.S VSS.t242 sg13_hv_nmos ad=0.68p pd=4.68u as=15.7454p ps=34.18u w=2u l=4u
X198 VSS.t465 vin M15_0/nmosHV$1_priv1_0.D VSS.t466 sg13_hv_nmos ad=0.19p pd=1.38u as=0.19p ps=1.38u w=1u l=0.5u
X199 VDD3_3.t24 M24_0/pmosHV$1_priv4_0.D Cap_M1 VDD3_3.t21 sg13_hv_pmos ad=0.38p pd=2.38u as=0.38p ps=2.38u w=2u l=0.5u
X200 VDD3_3.t72 M24_2/pmosHV$1_priv4_0.D Cap_M11 VDD3_3.t20 sg13_hv_pmos ad=0.38p pd=2.38u as=0.38p ps=2.38u w=2u l=0.5u
X201 VDD3_3.t46 GROUP3$1_3.G pmosHV_priv26_2.S VDD3_3.t44 sg13_hv_pmos ad=1.36p pd=8.68u as=1.36p ps=8.68u w=4u l=0.5u
X202 pmosHV_priv24_0.S ACC_CAP nmosHV_priv13_0.D VDD3_3.t40 sg13_hv_pmos ad=1.36p pd=8.68u as=1.36p ps=8.68u w=4u l=0.5u
X203 VSS.t39 M16_0/nmosHV$2_priv1_0.D M16_0/nmosHV$2_priv1_0.D VSS.t40 sg13_hv_nmos ad=0.19p pd=1.38u as=0.34p ps=2.68u w=1u l=0.5u
X204 VSS.t117 VSS.t114 VSS.t116 VSS.t115 sg13_hv_nmos ad=0.17p pd=1.68u as=0 ps=0 w=0.5u l=0.5u
X205 VSS.t203 VSS.t200 VSS.t202 VSS.t201 sg13_hv_nmos ad=0.68p pd=4.68u as=0 ps=0 w=2u l=0.5u
X206 VDD3_3.t195 GROUP4_1.G GROUP4_1.G VDD3_3.t41 sg13_hv_pmos ad=1.36p pd=8.68u as=1.36p ps=8.68u w=4u l=0.5u
X207 VSS.t450 vin M15_0/nmosHV$1_priv1_0.D VSS.t451 sg13_hv_nmos ad=0.19p pd=1.38u as=0.19p ps=1.38u w=1u l=0.5u
X208 GROUP1$1$3_0.G GROUP1$4_0.G GROUP1$4_0.nmosHV_priv3$4_0.S VSS.t337 sg13_hv_nmos ad=0.68p pd=4.68u as=0.68p ps=4.68u w=2u l=4u
X209 VDD3_3.t168 VDD3_3.t166 VDD3_3.t167 VDD3_3.t16 sg13_hv_pmos ad=1.36p pd=8.68u as=0 ps=0 w=4u l=0.5u
X210 M15_1/nmosHV$1_priv1_0.D VDD3_3.t226 lnaf VSS.t384 sg13_hv_nmos ad=0.19p pd=1.38u as=0.34p ps=2.68u w=1u l=0.5u
X211 pmosHV_priv26_3.S ACC_CAP nmosHV_priv13_3.D VDD3_3.t49 sg13_hv_pmos ad=1.36p pd=8.68u as=1.36p ps=8.68u w=4u l=0.5u
X212 VSS.t468 vin M15_0/nmosHV$1_priv1_0.D VSS.t469 sg13_hv_nmos ad=0.19p pd=1.38u as=0.34p ps=2.68u w=1u l=0.5u
X213 M22_1/pmosHV$1_priv2_0.D M22_1/pmosHV$1_priv2_0.D VDD3_3.t6 VDD3_3.t0 sg13_hv_pmos ad=0.68p pd=4.68u as=0.38p ps=2.38u w=2u l=0.5u
X214 M15_2/nmosHV$1_priv1_0.D Cap_M2 VSS.t16 VSS.t9 sg13_hv_nmos ad=0.19p pd=1.38u as=0.19p ps=1.38u w=1u l=0.5u
X215 VSS.t425 M20_1/nmosHV$5_priv2_0.D M20_1/nmosHV$5_priv2_0.D VSS.t424 sg13_hv_nmos ad=0.38p pd=2.38u as=0.38p ps=2.38u w=2u l=0.5u
X216 M22_2/pmosHV$1_priv2_0.D M22_2/pmosHV$1_priv2_0.D VDD3_3.t202 VDD3_3.t20 sg13_hv_pmos ad=0.68p pd=4.68u as=0.38p ps=2.38u w=2u l=0.5u
X217 pmosHV_priv26_2.S ACC_CAP nmosHV_priv13_2.D VDD3_3.t45 sg13_hv_pmos ad=1.36p pd=8.68u as=1.36p ps=8.68u w=4u l=0.5u
X218 VSS.t428 M20_1/nmosHV$5_priv2_0.D M20_1/nmosHV$5_priv2_0.D VSS.t427 sg13_hv_nmos ad=0.38p pd=2.38u as=0.38p ps=2.38u w=2u l=0.5u
X219 VDD3_3.t11 M22_1/pmosHV$1_priv2_0.D M23_1/pmosHV$1_priv3_0.D VDD3_3.t0 sg13_hv_pmos ad=0.38p pd=2.38u as=0.38p ps=2.38u w=2u l=0.5u
X220 pmosHV_priv16_1.S vref0 GROUP1_0.G VDD3_3.t42 sg13_hv_pmos ad=1.36p pd=8.68u as=1.36p ps=8.68u w=4u l=0.5u
X221 VDD3_3.t206 M22_2/pmosHV$1_priv2_0.D M23_2/pmosHV$1_priv3_0.D VDD3_3.t20 sg13_hv_pmos ad=0.38p pd=2.38u as=0.38p ps=2.38u w=2u l=0.5u
X222 GROUP3$1_3.G VSS.t244 VSS.t243 rhigh l=0.1483m w=2u
X223 VDD3_3.t13 M22_1/pmosHV$1_priv2_0.D M23_1/pmosHV$1_priv3_0.D VDD3_3.t0 sg13_hv_pmos ad=0.38p pd=2.38u as=0.38p ps=2.38u w=2u l=0.5u
X224 M21_2/nmosHV$5_priv1_0.D M21_2/nmosHV$5_priv1_0.D M21_2/nmosHV$5_priv1_0.D VSS.t44 sg13_hv_nmos ad=0.51p pd=3.68u as=16.6844p ps=93.14999u w=1.5u l=0.5u
X225 VSS.t52 Cap_M21 M15_1/nmosHV$1_priv1_0.D VSS.t53 sg13_hv_nmos ad=0.19p pd=1.38u as=0.19p ps=1.38u w=1u l=0.5u
X226 M24_1/pmosHV$1_priv4_0.D M24_1/pmosHV$1_priv4_0.D VDD3_3.t97 VDD3_3.t0 sg13_hv_pmos ad=0.38p pd=2.38u as=0.38p ps=2.38u w=2u l=0.5u
X227 VDD3_3.t70 M24_2/pmosHV$1_priv4_0.D M24_2/pmosHV$1_priv4_0.D VDD3_3.t20 sg13_hv_pmos ad=0.68p pd=4.68u as=0.38p ps=2.38u w=2u l=0.5u
X228 VDD3_3.t22 M24_0/pmosHV$1_priv4_0.D M24_0/pmosHV$1_priv4_0.D VDD3_3.t21 sg13_hv_pmos ad=0.68p pd=4.68u as=0.38p ps=2.38u w=2u l=0.5u
X229 lnaf lnaf lnaf VSS.t254 sg13_hv_nmos ad=0.17p pd=1.68u as=0 ps=0 w=0.5u l=0.5u
X230 VSS.t296 nmosHV_priv13_2.D nmosHV_priv13_2.D VSS.t295 sg13_hv_nmos ad=0.68p pd=4.68u as=0.68p ps=4.68u w=2u l=0.5u
X231 pmosHV_priv16_1.S vref0 GROUP1_0.G VDD3_3.t42 sg13_hv_pmos ad=1.36p pd=8.68u as=1.36p ps=8.68u w=4u l=0.5u
X232 M2_1/nmosHV$3_priv4_0.D M2_1/nmosHV$3_priv4_0.D M2_1/nmosHV$3_priv4_0.D VSS.t28 sg13_hv_nmos ad=0.17p pd=1.68u as=14.44555p ps=50.73u w=0.5u l=0.5u
X233 M16_2/nmosHV$2_priv1_0.D VDD3_3.t225 VSS.t470 rhigh l=0.20002m w=2u
X234 ACC_CAP ACC_CAP opm opm sg13_hv_pmos ad=0.68p pd=4.68u as=0.38p ps=2.38u w=2u l=0.5u
X235 VDD3_3.t36 M2_0/nmosHV$3_priv4_0.D VSS.t8 rhigh l=0.24997m w=2u
X236 VDD3_3.t38 M2_1/nmosHV$3_priv4_0.D VSS.t35 rhigh l=0.24997m w=2u
X237 VSS.t432 M20_1/nmosHV$5_priv2_0.D M21_1/nmosHV$5_priv1_0.D VSS.t431 sg13_hv_nmos ad=0.38p pd=2.38u as=0.38p ps=2.38u w=2u l=0.5u
X238 VDD3_3.t123 VDD3_3.t121 VDD3_3.t122 VDD3_3.t21 sg13_hv_pmos ad=0.68p pd=4.68u as=0 ps=0 w=2u l=0.5u
X239 q2 q2 q2 VDD1_5 sg13_hv_pmos ad=0.68p pd=4.68u as=29.0796p ps=57.16u w=2u l=4u
X240 M22_0/pmosHV$1_priv2_0.D M22_0/pmosHV$1_priv2_0.D VDD3_3.t217 VDD3_3.t21 sg13_hv_pmos ad=0.68p pd=4.68u as=0.38p ps=2.38u w=2u l=0.5u
X241 GROUP1$2_0.nmosHV_priv3$2_0.S GROUP1$2_0.nmosHV_priv3$2_0.S GROUP1$2_0.nmosHV_priv3$2_0.S VSS.t442 sg13_hv_nmos ad=0.68p pd=4.68u as=15.7454p ps=34.18u w=2u l=4u
X242 M24_1/pmosHV$1_priv4_0.D VSS.t394 VSS.t393 rhigh l=15.02u w=2u
X243 M15_0/nmosHV$1_priv1_0.D vin VSS.t456 VSS.t455 sg13_hv_nmos ad=0.19p pd=1.38u as=0.19p ps=1.38u w=1u l=0.5u
X244 VSS.t435 M20_1/nmosHV$5_priv2_0.D M21_1/nmosHV$5_priv1_0.D VSS.t434 sg13_hv_nmos ad=0.38p pd=2.38u as=0.38p ps=2.38u w=2u l=0.5u
X245 M20_2/nmosHV$5_priv2_0.D VDD3_3.t50 VSS.t241 rhigh l=0.20002m w=2u
X246 pmosHV_priv16_1.S vref0 GROUP1_0.G VDD3_3.t42 sg13_hv_pmos ad=1.36p pd=8.68u as=1.36p ps=8.68u w=4u l=0.5u
X247 VSS.t230 M20_0/nmosHV$5_priv2_0.D M20_0/nmosHV$5_priv2_0.D VSS.t229 sg13_hv_nmos ad=0.38p pd=2.38u as=0.38p ps=2.38u w=2u l=0.5u
X248 nmosHV_priv13_2.D nmosHV_priv13_2.D nmosHV_priv13_2.D VSS.t292 sg13_hv_nmos ad=0.68p pd=4.68u as=31.50855p ps=0.11409m w=2u l=0.5u
X249 nmosHV_priv13_0.D nmosHV_priv13_0.D nmosHV_priv13_0.D VDD3_3.t40 sg13_hv_pmos ad=1.36p pd=8.68u as=31.50855p ps=0.11409m w=4u l=0.5u
X250 VSS.t317 nmosHV_priv13_1.D GROUP1_0.G VSS.t316 sg13_hv_nmos ad=0.68p pd=4.68u as=0.68p ps=4.68u w=2u l=0.5u
X251 VDD3_3.t43 M2_2/nmosHV$3_priv4_0.D VSS.t48 rhigh l=0.24997m w=2u
X252 VSS.t187 VSS.t184 VSS.t186 VSS.t185 sg13_hv_nmos ad=0.68p pd=4.68u as=0 ps=0 w=2u l=0.5u
X253 M15_0/nmosHV$1_priv1_0.D vin VSS.t453 VSS.t452 sg13_hv_nmos ad=0.19p pd=1.38u as=0.19p ps=1.38u w=1u l=0.5u
X254 VDD3_3.t132 VDD3_3.t130 VDD3_3.t131 VSS.t380 sg13_hv_nmos ad=0.51p pd=3.68u as=0 ps=0 w=1.5u l=0.5u
X255 q1 q1 q1 VDD1_5 sg13_hv_pmos ad=0.68p pd=4.68u as=29.0796p ps=57.16u w=2u l=4u
X256 VDD3_3.t153 VDD3_3.t151 VDD3_3.t152 VDD3_3.t41 sg13_hv_pmos ad=1.36p pd=8.68u as=0 ps=0 w=4u l=0.5u
X257 VSS.t20 Cap_M2 M15_2/nmosHV$1_priv1_0.D VSS.t9 sg13_hv_nmos ad=0.19p pd=1.38u as=0.19p ps=1.38u w=1u l=0.5u
X258 M22_2/pmosHV$1_priv2_0.D M22_2/pmosHV$1_priv2_0.D VDD3_3.t197 VDD3_3.t20 sg13_hv_pmos ad=0.38p pd=2.38u as=0.68p ps=4.68u w=2u l=0.5u
X259 VDD3_3.t177 VDD3_3.t175 VDD3_3.t176 VDD3_3.t19 sg13_hv_pmos ad=0.68p pd=4.68u as=0 ps=0 w=2u l=0.5u
X260 pmosHV_priv26_3.S pmosHV_priv26_3.S pmosHV_priv26_3.S VDD3_3.t49 sg13_hv_pmos ad=1.36p pd=8.68u as=0 ps=0 w=4u l=0.5u
X261 M22_1/pmosHV$1_priv2_0.D VSS.t396 VSS.t395 rhigh l=15.02u w=2u
X262 Cap_M1 M24_0/pmosHV$1_priv4_0.D VDD3_3.t28 VDD3_3.t21 sg13_hv_pmos ad=0.38p pd=2.38u as=0.38p ps=2.38u w=2u l=0.5u
X263 VSS.t352 M2_0/nmosHV$3_priv4_0.D Cap_M1 VSS.t351 sg13_hv_nmos ad=0.17p pd=1.68u as=0.17p ps=1.68u w=0.5u l=0.5u
X264 q0 q0 q0 VDD1_5 sg13_hv_pmos ad=0.68p pd=4.68u as=29.0796p ps=57.16u w=2u l=4u
X265 GROUP1_0.G GROUP1_0.G GROUP1_0.G VSS.t401 sg13_hv_nmos ad=0.68p pd=4.68u as=54.5816p ps=0.24978m w=2u l=0.5u
X266 Cap_M11 M24_2/pmosHV$1_priv4_0.D VDD3_3.t76 VDD3_3.t20 sg13_hv_pmos ad=0.38p pd=2.38u as=0.38p ps=2.38u w=2u l=0.5u
X267 VSS.t32 M2_1/nmosHV$3_priv4_0.D Cap_M11 VSS.t31 sg13_hv_nmos ad=0.17p pd=1.68u as=0.17p ps=1.68u w=0.5u l=0.5u
X268 M15_2/nmosHV$1_priv1_0.D VDD3_3.t228 Cap_M11 VSS.t250 sg13_hv_nmos ad=0.19p pd=1.38u as=0.34p ps=2.68u w=1u l=0.5u
X269 M15_0/nmosHV$1_priv1_0.D VDD3_3.t230 Cap_M1 VSS.t382 sg13_hv_nmos ad=0.19p pd=1.38u as=0.34p ps=2.68u w=1u l=0.5u
X270 vin M16_0/nmosHV$2_priv1_0.D VSS.t248 rhigh l=40u w=2u
X271 VSS.t10 Cap_M2 M15_2/nmosHV$1_priv1_0.D VSS.t9 sg13_hv_nmos ad=0.19p pd=1.38u as=0.19p ps=1.38u w=1u l=0.5u
X272 VSS.t258 nmosHV_priv13_0.D nmosHV_priv13_0.D VSS.t257 sg13_hv_nmos ad=0.68p pd=4.68u as=0.68p ps=4.68u w=2u l=0.5u
X273 VSS.t136 VSS.t133 VSS.t135 VSS.t134 sg13_hv_nmos ad=0.17p pd=1.68u as=0 ps=0 w=0.5u l=0.5u
X274 VSS.t471 M16_2/nmosHV$2_priv1_0.D M16_2/nmosHV$2_priv1_0.D VSS.t154 sg13_hv_nmos ad=0.19p pd=1.38u as=0.34p ps=2.68u w=1u l=0.5u
X275 M15_1/nmosHV$1_priv1_0.D Cap_M21 VSS.t58 VSS.t57 sg13_hv_nmos ad=0.19p pd=1.38u as=0.19p ps=1.38u w=1u l=0.5u
X276 VDD1_5 GROUP1$1$3_0.G q3 VDD1_5 sg13_hv_pmos ad=0.68p pd=4.68u as=0.68p ps=4.68u w=2u l=4u
X277 VSS.t22 Cap_M2 M15_2/nmosHV$1_priv1_0.D VSS.t9 sg13_hv_nmos ad=0.19p pd=1.38u as=0.19p ps=1.38u w=1u l=0.5u
X278 M20_1/nmosHV$5_priv2_0.D M20_1/nmosHV$5_priv2_0.D VSS.t425 VSS.t426 sg13_hv_nmos ad=0.38p pd=2.38u as=0.38p ps=2.38u w=2u l=0.5u
X279 M23_0/pmosHV$1_priv3_0.D M22_0/pmosHV$1_priv2_0.D VDD3_3.t221 VDD3_3.t21 sg13_hv_pmos ad=0.38p pd=2.38u as=0.38p ps=2.38u w=2u l=0.5u
X280 pmosHV_priv24_0.S vref3 GROUP1$4_0.G VDD3_3.t40 sg13_hv_pmos ad=1.36p pd=8.68u as=1.36p ps=8.68u w=4u l=0.5u
X281 M23_2/pmosHV$1_priv3_0.D M22_2/pmosHV$1_priv2_0.D VDD3_3.t206 VDD3_3.t20 sg13_hv_pmos ad=0.38p pd=2.38u as=0.38p ps=2.38u w=2u l=0.5u
X282 VSS.t355 nmosHV_priv13_3.D GROUP1$2_0.G VSS.t354 sg13_hv_nmos ad=0.68p pd=4.68u as=0.68p ps=4.68u w=2u l=0.5u
X283 M15_1/nmosHV$1_priv1_0.D Cap_M21 VSS.t61 VSS.t60 sg13_hv_nmos ad=0.19p pd=1.38u as=0.19p ps=1.38u w=1u l=0.5u
X284 VSS.t239 M20_0/nmosHV$5_priv2_0.D M21_0/nmosHV$5_priv1_0.D VSS.t238 sg13_hv_nmos ad=0.38p pd=2.38u as=0.38p ps=2.38u w=2u l=0.5u
X285 M24_2/pmosHV$1_priv4_0.D M24_2/pmosHV$1_priv4_0.D VDD3_3.t82 VDD3_3.t20 sg13_hv_pmos ad=0.38p pd=2.38u as=0.38p ps=2.38u w=2u l=0.5u
X286 M24_0/pmosHV$1_priv4_0.D M24_0/pmosHV$1_priv4_0.D VDD3_3.t34 VDD3_3.t21 sg13_hv_pmos ad=0.38p pd=2.38u as=0.38p ps=2.38u w=2u l=0.5u
X287 VDD3_3.t59 GROUP3_0.G opm VDD3_3.t19 sg13_hv_pmos ad=0.38p pd=2.38u as=0.38p ps=2.38u w=2u l=0.5u
X288 M24_2/pmosHV$1_priv4_0.D VSS.t79 VSS.t78 rhigh l=15.02u w=2u
X289 pmosHV_priv26_2.S pmosHV_priv26_2.S pmosHV_priv26_2.S VDD3_3.t45 sg13_hv_pmos ad=1.36p pd=8.68u as=0 ps=0 w=4u l=0.5u
X290 M20_1/nmosHV$5_priv2_0.D VDD3_3.t193 VSS.t405 rhigh l=0.20002m w=2u
X291 VSS.t219 VSS.t216 VSS.t218 VSS.t217 sg13_hv_nmos ad=0.68p pd=4.68u as=0 ps=0 w=2u l=4u
X292 GROUP3$1_2.G VSS.t274 VSS.t273 rhigh l=0.1483m w=2u
X293 VSS.t283 M20_2/nmosHV$5_priv2_0.D M20_2/nmosHV$5_priv2_0.D VSS.t282 sg13_hv_nmos ad=0.38p pd=2.38u as=0.38p ps=2.38u w=2u l=0.5u
X294 VSS.t298 nmosHV_priv13_2.D GROUP1$3_0.G VSS.t297 sg13_hv_nmos ad=0.68p pd=4.68u as=0.68p ps=4.68u w=2u l=0.5u
X295 GROUP3_0.G GROUP3_0.G VDD3_3.t69 VDD3_3.t19 sg13_hv_pmos ad=0.38p pd=2.38u as=0.68p ps=4.68u w=2u l=0.5u
X296 VSS.t290 M20_2/nmosHV$5_priv2_0.D M21_2/nmosHV$5_priv1_0.D VSS.t289 sg13_hv_nmos ad=0.38p pd=2.38u as=0.38p ps=2.38u w=2u l=0.5u
X297 M24_2/pmosHV$1_priv4_0.D M24_2/pmosHV$1_priv4_0.D VDD3_3.t80 VDD3_3.t20 sg13_hv_pmos ad=0.38p pd=2.38u as=0.38p ps=2.38u w=2u l=0.5u
X298 M24_0/pmosHV$1_priv4_0.D M24_0/pmosHV$1_priv4_0.D VDD3_3.t32 VDD3_3.t21 sg13_hv_pmos ad=0.38p pd=2.38u as=0.38p ps=2.38u w=2u l=0.5u
X299 pmosHV_priv16_1.S pmosHV_priv16_1.S pmosHV_priv16_1.S VDD3_3.t42 sg13_hv_pmos ad=1.36p pd=8.68u as=30.225p ps=0.1221m w=4u l=0.5u
X300 M22_0/pmosHV$1_priv2_0.D M22_0/pmosHV$1_priv2_0.D VDD3_3.t212 VDD3_3.t21 sg13_hv_pmos ad=0.38p pd=2.38u as=0.68p ps=4.68u w=2u l=0.5u
X301 VSS.t175 VSS.t172 VSS.t174 VSS.t173 sg13_hv_nmos ad=0.68p pd=4.68u as=0 ps=0 w=2u l=0.5u
X302 M22_0/pmosHV$1_priv2_0.D M22_0/pmosHV$1_priv2_0.D VDD3_3.t213 VDD3_3.t21 sg13_hv_pmos ad=0.38p pd=2.38u as=0.38p ps=2.38u w=2u l=0.5u
X303 M21_1/nmosHV$5_priv1_0.D M20_1/nmosHV$5_priv2_0.D VSS.t432 VSS.t433 sg13_hv_nmos ad=0.38p pd=2.38u as=0.38p ps=2.38u w=2u l=0.5u
X304 GROUP3_0.G GROUP3_0.G VDD3_3.t66 VDD3_3.t19 sg13_hv_pmos ad=0.38p pd=2.38u as=0.38p ps=2.38u w=2u l=0.5u
X305 M2_0/nmosHV$3_priv4_0.D M2_0/nmosHV$3_priv4_0.D VSS.t350 VSS.t349 sg13_hv_nmos ad=0.17p pd=1.68u as=0.17p ps=1.68u w=0.5u l=0.5u
X306 M20_0/nmosHV$5_priv2_0.D M20_0/nmosHV$5_priv2_0.D VSS.t227 VSS.t228 sg13_hv_nmos ad=0.38p pd=2.38u as=0.38p ps=2.38u w=2u l=0.5u
X307 VDD3_3.t17 GROUP3$1_0.G GROUP3$1_0.G VDD3_3.t16 sg13_hv_pmos ad=1.36p pd=8.68u as=1.36p ps=8.68u w=4u l=0.5u
X308 VSS.t247 opm VSS.t246 rhigh l=8u w=2u
X309 M15_2/nmosHV$1_priv1_0.D Cap_M2 VSS.t14 VSS.t9 sg13_hv_nmos ad=0.19p pd=1.38u as=0.19p ps=1.38u w=1u l=0.5u
X310 VSS.t262 nmosHV_priv13_0.D GROUP1$4_0.G VSS.t261 sg13_hv_nmos ad=0.68p pd=4.68u as=0.68p ps=4.68u w=2u l=0.5u
X311 nmosHV_priv13_3.D nmosHV_priv13_3.D nmosHV_priv13_3.D VDD3_3.t49 sg13_hv_pmos ad=1.36p pd=8.68u as=0 ps=0 w=4u l=0.5u
X312 VSS.t459 vin M15_0/nmosHV$1_priv1_0.D VSS.t460 sg13_hv_nmos ad=0.19p pd=1.38u as=0.19p ps=1.38u w=1u l=0.5u
X313 M15_2/nmosHV$1_priv1_0.D Cap_M2 VSS.t26 VSS.t9 sg13_hv_nmos ad=0.19p pd=1.38u as=0.19p ps=1.38u w=1u l=0.5u
X314 VSS.t50 GROUP3_0.G VSS.t49 rhigh l=10u w=2u
X315 M2_2/nmosHV$3_priv4_0.D M2_2/nmosHV$3_priv4_0.D VSS.t441 VSS.t440 sg13_hv_nmos ad=0.17p pd=1.68u as=0.17p ps=1.68u w=0.5u l=0.5u
X316 pmosHV_priv26_2.S pmosHV_priv26_2.S pmosHV_priv26_2.S VDD3_3.t44 sg13_hv_pmos ad=1.36p pd=8.68u as=0 ps=0 w=4u l=0.5u
X317 VDD3_3.t111 VDD3_3.t109 VDD3_3.t110 VDD3_3.t21 sg13_hv_pmos ad=0.68p pd=4.68u as=0 ps=0 w=2u l=0.5u
X318 VDD3_3.t120 VDD3_3.t118 VDD3_3.t119 VDD3_3.t20 sg13_hv_pmos ad=0.68p pd=4.68u as=0 ps=0 w=2u l=0.5u
X319 GROUP4_1.G GROUP4_1.G GROUP4_1.G VDD3_3.t41 sg13_hv_pmos ad=1.36p pd=8.68u as=38.75025p ps=92.41u w=4u l=0.5u
X320 VSS.t444 vin M15_0/nmosHV$1_priv1_0.D VSS.t445 sg13_hv_nmos ad=0.19p pd=1.38u as=0.19p ps=1.38u w=1u l=0.5u
X321 GROUP1$4_0.G GROUP1$4_0.G GROUP1$4_0.G VSS.t336 sg13_hv_nmos ad=0.68p pd=4.68u as=0 ps=0 w=2u l=0.5u
X322 VSS.t462 vin M15_0/nmosHV$1_priv1_0.D VSS.t463 sg13_hv_nmos ad=0.19p pd=1.38u as=0.19p ps=1.38u w=1u l=0.5u
X323 vref1 vref2 VSS.t42 rhigh l=1.4u w=2u
X324 M20_0/nmosHV$5_priv2_0.D VDD3_3.t39 VSS.t43 rhigh l=0.20002m w=2u
X325 VSS.t64 Cap_M21 M15_1/nmosHV$1_priv1_0.D VSS.t65 sg13_hv_nmos ad=0.19p pd=1.38u as=0.19p ps=1.38u w=1u l=0.5u
X326 lnaf M24_1/pmosHV$1_priv4_0.D VDD3_3.t90 VDD3_3.t0 sg13_hv_pmos ad=0.38p pd=2.38u as=0.38p ps=2.38u w=2u l=0.5u
X327 VDD3_3.t198 M22_2/pmosHV$1_priv2_0.D M22_2/pmosHV$1_priv2_0.D VDD3_3.t20 sg13_hv_pmos ad=0.38p pd=2.38u as=0.38p ps=2.38u w=2u l=0.5u
X328 vref3 VDD3_3.t55 VSS.t332 rhigh l=28.8u w=2u
X329 q1 q1 q1 VSS.t418 sg13_hv_nmos ad=0.68p pd=4.68u as=0 ps=0 w=2u l=4u
X330 VSS.t67 Cap_M21 M15_1/nmosHV$1_priv1_0.D VSS.t68 sg13_hv_nmos ad=0.19p pd=1.38u as=0.19p ps=1.38u w=1u l=0.5u
X331 pmosHV_priv26_3.S vref1 GROUP1$2_0.G VDD3_3.t49 sg13_hv_pmos ad=1.36p pd=8.68u as=1.36p ps=8.68u w=4u l=0.5u
X332 M22_0/pmosHV$1_priv2_0.D M22_0/pmosHV$1_priv2_0.D M22_0/pmosHV$1_priv2_0.D VDD3_3.t21 sg13_hv_pmos ad=0.68p pd=4.68u as=35.2356p ps=0.14882m w=2u l=0.5u
X333 nmosHV_priv13_2.D nmosHV_priv13_2.D nmosHV_priv13_2.D VDD3_3.t45 sg13_hv_pmos ad=1.36p pd=8.68u as=0 ps=0 w=4u l=0.5u
X334 opm GROUP3_0.G VDD3_3.t56 VDD3_3.t19 sg13_hv_pmos ad=0.68p pd=4.68u as=0.38p ps=2.38u w=2u l=0.5u
X335 VDD3_3.t62 GROUP3_0.G GROUP3_0.G VDD3_3.t19 sg13_hv_pmos ad=0.38p pd=2.38u as=0.38p ps=2.38u w=2u l=0.5u
X336 M23_1/pmosHV$1_priv3_0.D M22_1/pmosHV$1_priv2_0.D VDD3_3.t8 VDD3_3.t0 sg13_hv_pmos ad=0.38p pd=2.38u as=0.68p ps=4.68u w=2u l=0.5u
X337 M21_0/nmosHV$5_priv1_0.D M20_0/nmosHV$5_priv2_0.D VSS.t236 VSS.t237 sg13_hv_nmos ad=0.38p pd=2.38u as=0.38p ps=2.38u w=2u l=0.5u
X338 M22_1/pmosHV$1_priv2_0.D M22_1/pmosHV$1_priv2_0.D M22_1/pmosHV$1_priv2_0.D VDD3_3.t0 sg13_hv_pmos ad=0.68p pd=4.68u as=35.2356p ps=0.14882m w=2u l=0.5u
X339 pmosHV_priv24_0.S vref3 GROUP1$4_0.G VDD3_3.t40 sg13_hv_pmos ad=1.36p pd=8.68u as=1.36p ps=8.68u w=4u l=0.5u
X340 VDD3_3.t208 M22_2/pmosHV$1_priv2_0.D M23_2/pmosHV$1_priv3_0.D VDD3_3.t20 sg13_hv_pmos ad=0.38p pd=2.38u as=0.38p ps=2.38u w=2u l=0.5u
X341 GROUP1$1$2_0.G GROUP1$1$2_0.G GROUP1$1$2_0.G VDD3_3.t15 sg13_hv_pmos ad=0.68p pd=4.68u as=64.9628p ps=0.22442m w=2u l=4u
X342 GROUP1_0.G GROUP1_0.G GROUP1_0.G VDD3_3.t42 sg13_hv_pmos ad=1.36p pd=8.68u as=0 ps=0 w=4u l=0.5u
X343 pmosHV_priv26_3.S vref1 GROUP1$2_0.G VDD3_3.t49 sg13_hv_pmos ad=1.36p pd=8.68u as=1.36p ps=8.68u w=4u l=0.5u
X344 VDD3_3.t58 GROUP3_0.G GROUP3_0.G VDD3_3.t19 sg13_hv_pmos ad=0.38p pd=2.38u as=0.38p ps=2.38u w=2u l=0.5u
X345 M15_1/nmosHV$1_priv1_0.D M15_1/nmosHV$1_priv1_0.D M15_1/nmosHV$1_priv1_0.D VSS.t326 sg13_hv_nmos ad=0.34p pd=2.68u as=0 ps=0 w=1u l=0.5u
X346 GROUP4_1.G VSS.t343 VSS.t342 rhigh l=0.1483m w=2u
X347 M20_2/nmosHV$5_priv2_0.D M20_2/nmosHV$5_priv2_0.D VSS.t280 VSS.t281 sg13_hv_nmos ad=0.38p pd=2.38u as=0.38p ps=2.38u w=2u l=0.5u
X348 pmosHV_priv26_2.S vref2 GROUP1$3_0.G VDD3_3.t45 sg13_hv_pmos ad=1.36p pd=8.68u as=1.36p ps=8.68u w=4u l=0.5u
X349 M21_2/nmosHV$5_priv1_0.D M20_2/nmosHV$5_priv2_0.D VSS.t287 VSS.t288 sg13_hv_nmos ad=0.38p pd=2.38u as=0.38p ps=2.38u w=2u l=0.5u
X350 VSS.t152 VSS.t149 VSS.t151 VSS.t150 sg13_hv_nmos ad=0.34p pd=2.68u as=0 ps=0 w=1u l=0.5u
X351 Cap_M1 M24_0/pmosHV$1_priv4_0.D VDD3_3.t24 VDD3_3.t21 sg13_hv_pmos ad=0.38p pd=2.38u as=0.38p ps=2.38u w=2u l=0.5u
X352 VSS.t199 VSS.t196 VSS.t198 VSS.t197 sg13_hv_nmos ad=0.68p pd=4.68u as=0 ps=0 w=2u l=0.5u
X353 VSS.t160 VSS.t157 VSS.t159 VSS.t158 sg13_hv_nmos ad=0.34p pd=2.68u as=0 ps=0 w=1u l=0.5u
X354 Cap_M11 M24_2/pmosHV$1_priv4_0.D VDD3_3.t72 VDD3_3.t20 sg13_hv_pmos ad=0.38p pd=2.38u as=0.38p ps=2.38u w=2u l=0.5u
X355 VSS.t110 VSS.t107 VSS.t109 VSS.t108 sg13_hv_nmos ad=0.17p pd=1.68u as=0 ps=0 w=0.5u l=0.5u
X356 VSS.t302 nmosHV_priv13_2.D GROUP1$3_0.G VSS.t301 sg13_hv_nmos ad=0.68p pd=4.68u as=0.68p ps=4.68u w=2u l=0.5u
X357 pmosHV_priv24_0.S vref3 GROUP1$4_0.G VDD3_3.t40 sg13_hv_pmos ad=1.36p pd=8.68u as=1.36p ps=8.68u w=4u l=0.5u
X358 M24_1/pmosHV$1_priv4_0.D M24_1/pmosHV$1_priv4_0.D VDD3_3.t95 VDD3_3.t0 sg13_hv_pmos ad=0.38p pd=2.38u as=0.38p ps=2.38u w=2u l=0.5u
X359 M16_0/nmosHV$2_priv1_0.D M16_0/nmosHV$2_priv1_0.D VSS.t39 VSS.t38 sg13_hv_nmos ad=0.34p pd=2.68u as=0.19p ps=1.38u w=1u l=0.5u
X360 q1 GROUP1$1$1_0.G VSS.t387 VSS.t386 sg13_hv_nmos ad=0.68p pd=4.68u as=0.68p ps=4.68u w=2u l=4u
X361 GROUP1$1$1_0.G GROUP1$1$1_0.G GROUP1$1$1_0.G VDD3_3.t51 sg13_hv_pmos ad=0.68p pd=4.68u as=64.9628p ps=0.22442m w=2u l=4u
X362 GROUP1$3_0.nmosHV_priv3$3_0.S VSS.t413 VSS.t412 rhigh l=0.12344m w=2u
X363 VDD3_3.t213 M22_0/pmosHV$1_priv2_0.D M22_0/pmosHV$1_priv2_0.D VDD3_3.t21 sg13_hv_pmos ad=0.38p pd=2.38u as=0.38p ps=2.38u w=2u l=0.5u
X364 pmosHV_priv16_1.S ACC_CAP nmosHV_priv13_1.D VDD3_3.t42 sg13_hv_pmos ad=1.36p pd=8.68u as=1.36p ps=8.68u w=4u l=0.5u
X365 M15_0/nmosHV$1_priv1_0.D vin VSS.t450 VSS.t449 sg13_hv_nmos ad=0.19p pd=1.38u as=0.19p ps=1.38u w=1u l=0.5u
X366 VSS.t87 VSS.t84 VSS.t86 VSS.t85 sg13_hv_nmos ad=0.68p pd=4.68u as=0 ps=0 w=2u l=0.5u
X367 VDD3_3.t138 VDD3_3.t136 VDD3_3.t137 VDD3_3.t0 sg13_hv_pmos ad=0.68p pd=4.68u as=0 ps=0 w=2u l=0.5u
X368 VDD3_3.t2 M22_1/pmosHV$1_priv2_0.D M22_1/pmosHV$1_priv2_0.D VDD3_3.t0 sg13_hv_pmos ad=0.38p pd=2.38u as=0.38p ps=2.38u w=2u l=0.5u
X369 GROUP1$1_0.G GROUP1$1_0.G GROUP1$1_0.G VDD3_3.t84 sg13_hv_pmos ad=0.68p pd=4.68u as=0 ps=0 w=2u l=4u
X370 pmosHV_priv26_3.S vref1 GROUP1$2_0.G VDD3_3.t49 sg13_hv_pmos ad=1.36p pd=8.68u as=1.36p ps=8.68u w=4u l=0.5u
X371 VSS.t18 Cap_M2 M15_2/nmosHV$1_priv1_0.D VSS.t9 sg13_hv_nmos ad=0.19p pd=1.38u as=0.19p ps=1.38u w=1u l=0.5u
X372 ACC_CAP ACC_CAP opm opm sg13_hv_pmos ad=0.38p pd=2.38u as=0.38p ps=2.38u w=2u l=0.5u
X373 M15_0/nmosHV$1_priv1_0.D vin VSS.t468 VSS.t467 sg13_hv_nmos ad=0.19p pd=1.38u as=0.19p ps=1.38u w=1u l=0.5u
X374 Cap_M1 M24_0/pmosHV$1_priv4_0.D VDD3_3.t26 VDD3_3.t21 sg13_hv_pmos ad=0.38p pd=2.38u as=0.38p ps=2.38u w=2u l=0.5u
X375 VDD3_3.t194 GROUP4_1.G pmosHV_priv16_1.S VDD3_3.t41 sg13_hv_pmos ad=1.36p pd=8.68u as=1.36p ps=8.68u w=4u l=0.5u
X376 Cap_M11 M24_2/pmosHV$1_priv4_0.D VDD3_3.t74 VDD3_3.t20 sg13_hv_pmos ad=0.38p pd=2.38u as=0.38p ps=2.38u w=2u l=0.5u
X377 VDD3_3.t215 M22_0/pmosHV$1_priv2_0.D M22_0/pmosHV$1_priv2_0.D VDD3_3.t21 sg13_hv_pmos ad=0.38p pd=2.38u as=0.38p ps=2.38u w=2u l=0.5u
X378 VDD3_3.t129 VDD3_3.t127 VDD3_3.t128 VDD3_3.t20 sg13_hv_pmos ad=0.68p pd=4.68u as=0 ps=0 w=2u l=0.5u
X379 VDD3_3.t92 M24_1/pmosHV$1_priv4_0.D lnaf VDD3_3.t0 sg13_hv_pmos ad=0.38p pd=2.38u as=0.68p ps=4.68u w=2u l=0.5u
X380 opm opm opm VDD3_3.t19 sg13_hv_pmos ad=0.68p pd=4.68u as=10.6782p ps=68.3u w=2u l=0.5u
X381 VDD3_3.t156 VDD3_3.t154 VDD3_3.t155 VDD3_3.t48 sg13_hv_pmos ad=1.36p pd=8.68u as=0 ps=0 w=4u l=0.5u
X382 VDD3_3.t54 GROUP3$1_2.G GROUP3$1_2.G VDD3_3.t48 sg13_hv_pmos ad=1.36p pd=8.68u as=1.36p ps=8.68u w=4u l=0.5u
X383 VDD3_3.t86 GROUP1$4_0.G GROUP1$1$3_0.G VDD3_3.t85 sg13_hv_pmos ad=0.68p pd=4.68u as=0.68p ps=4.68u w=2u l=4u
X384 pmosHV_priv26_2.S vref2 GROUP1$3_0.G VDD3_3.t45 sg13_hv_pmos ad=1.36p pd=8.68u as=1.36p ps=8.68u w=4u l=0.5u
X385 M15_1/nmosHV$1_priv1_0.D Cap_M21 VSS.t55 VSS.t54 sg13_hv_nmos ad=0.19p pd=1.38u as=0.19p ps=1.38u w=1u l=0.5u
X386 lnaf lnaf lnaf VDD3_3.t0 sg13_hv_pmos ad=0.68p pd=4.68u as=0 ps=0 w=2u l=0.5u
X387 VSS.t369 nmosHV_priv13_3.D nmosHV_priv13_3.D VSS.t368 sg13_hv_nmos ad=0.68p pd=4.68u as=0.68p ps=4.68u w=2u l=0.5u
X388 GROUP3$1_0.G GROUP3$1_0.G GROUP3$1_0.G VDD3_3.t16 sg13_hv_pmos ad=1.36p pd=8.68u as=38.75025p ps=92.41u w=4u l=0.5u
X389 q0 GROUP1$1_0.G VSS.t335 VSS.t334 sg13_hv_nmos ad=0.68p pd=4.68u as=0.68p ps=4.68u w=2u l=4u
X390 M15_1/nmosHV$1_priv1_0.D Cap_M21 VSS.t73 VSS.t72 sg13_hv_nmos ad=0.19p pd=1.38u as=0.19p ps=1.38u w=1u l=0.5u
X391 M2_1/nmosHV$3_priv4_0.D M2_1/nmosHV$3_priv4_0.D VSS.t30 VSS.t29 sg13_hv_nmos ad=0.17p pd=1.68u as=0.17p ps=1.68u w=0.5u l=0.5u
X392 VDD3_3.t223 M22_0/pmosHV$1_priv2_0.D M23_0/pmosHV$1_priv3_0.D VDD3_3.t21 sg13_hv_pmos ad=0.38p pd=2.38u as=0.38p ps=2.38u w=2u l=0.5u
X393 pmosHV_priv16_1.S ACC_CAP nmosHV_priv13_1.D VDD3_3.t42 sg13_hv_pmos ad=1.36p pd=8.68u as=1.36p ps=8.68u w=4u l=0.5u
X394 GROUP1$2_0.G GROUP1$2_0.G GROUP1$2_0.G VSS.t330 sg13_hv_nmos ad=0.68p pd=4.68u as=0 ps=0 w=2u l=0.5u
X395 q2 q2 q2 VSS.t417 sg13_hv_nmos ad=0.68p pd=4.68u as=0 ps=0 w=2u l=4u
X396 M15_1/nmosHV$1_priv1_0.D Cap_M21 VSS.t76 VSS.t75 sg13_hv_nmos ad=0.19p pd=1.38u as=0.19p ps=1.38u w=1u l=0.5u
X397 M15_1/nmosHV$1_priv1_0.D Cap_M21 VSS.t52 VSS.t51 sg13_hv_nmos ad=0.34p pd=2.68u as=0.19p ps=1.38u w=1u l=0.5u
X398 pmosHV_priv26_2.S ACC_CAP nmosHV_priv13_2.D VDD3_3.t45 sg13_hv_pmos ad=1.36p pd=8.68u as=1.36p ps=8.68u w=4u l=0.5u
X399 M16_1/nmosHV$2_priv1_0.D M16_1/nmosHV$2_priv1_0.D VSS.t339 VSS.t338 sg13_hv_nmos ad=0.34p pd=2.68u as=0.19p ps=1.38u w=1u l=0.5u
X400 GROUP1$4_0.nmosHV_priv3$4_0.S GROUP1$4_0.nmosHV_priv3$4_0.S GROUP1$4_0.nmosHV_priv3$4_0.S VSS.t419 sg13_hv_nmos ad=0.68p pd=4.68u as=15.7454p ps=34.18u w=2u l=4u
X401 pmosHV_priv16_1.S ACC_CAP nmosHV_priv13_1.D VDD3_3.t42 sg13_hv_pmos ad=1.36p pd=8.68u as=1.36p ps=8.68u w=4u l=0.5u
X402 VDD3_3.t162 VDD3_3.t160 VDD3_3.t161 VDD3_3.t44 sg13_hv_pmos ad=1.36p pd=8.68u as=0 ps=0 w=4u l=0.5u
X403 VDD3_3.t47 GROUP3$1_3.G GROUP3$1_3.G VDD3_3.t44 sg13_hv_pmos ad=1.36p pd=8.68u as=1.36p ps=8.68u w=4u l=0.5u
X404 VSS.t121 VSS.t118 VSS.t120 VSS.t119 sg13_hv_nmos ad=0.68p pd=4.68u as=0 ps=0 w=2u l=0.5u
X405 M23_2/pmosHV$1_priv3_0.D M23_2/pmosHV$1_priv3_0.D M23_2/pmosHV$1_priv3_0.D VSS.t377 sg13_hv_nmos ad=0.17p pd=1.68u as=0 ps=0 w=0.5u l=0.5u
X406 M20_1/nmosHV$5_priv2_0.D M20_1/nmosHV$5_priv2_0.D VSS.t428 VSS.t429 sg13_hv_nmos ad=0.68p pd=4.68u as=0.38p ps=2.38u w=2u l=0.5u
X407 VSS.t83 VSS.t80 VSS.t82 VSS.t81 sg13_hv_nmos ad=0.68p pd=4.68u as=0 ps=0 w=2u l=0.5u
X408 M24_0/pmosHV$1_priv4_0.D M24_0/pmosHV$1_priv4_0.D VDD3_3.t30 VDD3_3.t21 sg13_hv_pmos ad=0.38p pd=2.38u as=0.38p ps=2.38u w=2u l=0.5u
X409 M24_2/pmosHV$1_priv4_0.D M24_2/pmosHV$1_priv4_0.D VDD3_3.t78 VDD3_3.t20 sg13_hv_pmos ad=0.38p pd=2.38u as=0.38p ps=2.38u w=2u l=0.5u
X410 VSS.t306 nmosHV_priv13_2.D nmosHV_priv13_2.D VSS.t305 sg13_hv_nmos ad=0.68p pd=4.68u as=0.68p ps=4.68u w=2u l=0.5u
X411 q0 q0 q0 VSS.t416 sg13_hv_nmos ad=0.68p pd=4.68u as=0 ps=0 w=2u l=4u
X412 M23_1/pmosHV$1_priv3_0.D M22_1/pmosHV$1_priv2_0.D VDD3_3.t13 VDD3_3.t0 sg13_hv_pmos ad=0.68p pd=4.68u as=0.38p ps=2.38u w=2u l=0.5u
X413 M20_0/nmosHV$5_priv2_0.D M20_0/nmosHV$5_priv2_0.D M20_0/nmosHV$5_priv2_0.D VSS.t232 sg13_hv_nmos ad=0.68p pd=4.68u as=37.62435p ps=0.10861m w=2u l=0.5u
X414 q3 q3 q3 VDD1_5 sg13_hv_pmos ad=0.68p pd=4.68u as=0 ps=0 w=2u l=4u
X415 M23_2/pmosHV$1_priv3_0.D M22_2/pmosHV$1_priv2_0.D VDD3_3.t208 VDD3_3.t20 sg13_hv_pmos ad=0.68p pd=4.68u as=0.38p ps=2.38u w=2u l=0.5u
X416 pmosHV_priv24_0.S pmosHV_priv24_0.S pmosHV_priv24_0.S VDD3_3.t40 sg13_hv_pmos ad=1.36p pd=8.68u as=0 ps=0 w=4u l=0.5u
X417 M22_2/pmosHV$1_priv2_0.D M22_2/pmosHV$1_priv2_0.D M22_2/pmosHV$1_priv2_0.D VDD3_3.t20 sg13_hv_pmos ad=0.68p pd=4.68u as=35.2356p ps=0.14882m w=2u l=0.5u
X418 M24_0/pmosHV$1_priv4_0.D VSS.t221 VSS.t220 rhigh l=15.02u w=2u
X419 q2 GROUP1$1$2_0.G VSS.t4 VSS.t3 sg13_hv_nmos ad=0.68p pd=4.68u as=0.68p ps=4.68u w=2u l=4u
X420 VDD3_3.t76 M24_2/pmosHV$1_priv4_0.D Cap_M11 VDD3_3.t20 sg13_hv_pmos ad=0.38p pd=2.38u as=0.68p ps=4.68u w=2u l=0.5u
X421 VDD3_3.t28 M24_0/pmosHV$1_priv4_0.D Cap_M1 VDD3_3.t21 sg13_hv_pmos ad=0.38p pd=2.38u as=0.68p ps=4.68u w=2u l=0.5u
X422 VDD3_3.t99 M24_1/pmosHV$1_priv4_0.D M24_1/pmosHV$1_priv4_0.D VDD3_3.t0 sg13_hv_pmos ad=0.38p pd=2.38u as=0.68p ps=4.68u w=2u l=0.5u
X423 VSS.t183 VSS.t180 VSS.t182 VSS.t181 sg13_hv_nmos ad=0.68p pd=4.68u as=0 ps=0 w=2u l=0.5u
X424 opm ACC_CAP ACC_CAP opm sg13_hv_pmos ad=0.38p pd=2.38u as=0.68p ps=4.68u w=2u l=0.5u
X425 VSS.t456 vin M15_0/nmosHV$1_priv1_0.D VSS.t457 sg13_hv_nmos ad=0.19p pd=1.38u as=0.19p ps=1.38u w=1u l=0.5u
X426 M24_1/pmosHV$1_priv4_0.D M24_1/pmosHV$1_priv4_0.D M24_1/pmosHV$1_priv4_0.D VDD3_3.t0 sg13_hv_pmos ad=0.68p pd=4.68u as=34.3557p ps=0.14088m w=2u l=0.5u
X427 M15_2/nmosHV$1_priv1_0.D Cap_M2 VSS.t24 VSS.t9 sg13_hv_nmos ad=0.19p pd=1.38u as=0.19p ps=1.38u w=1u l=0.5u
X428 M22_0/pmosHV$1_priv2_0.D VSS.t1 VSS.t0 rhigh l=15.02u w=2u
X429 pmosHV_priv24_0.S ACC_CAP nmosHV_priv13_0.D VDD3_3.t40 sg13_hv_pmos ad=1.36p pd=8.68u as=1.36p ps=8.68u w=4u l=0.5u
X430 nmosHV_priv13_1.D nmosHV_priv13_1.D nmosHV_priv13_1.D VSS.t309 sg13_hv_nmos ad=0.68p pd=4.68u as=0 ps=0 w=2u l=0.5u
X431 VSS.t98 VSS.t96 VSS.t97 VDD3_3.t21 sg13_hv_pmos ad=0.238p pd=2.08u as=0 ps=0 w=0.7u l=0.5u
X432 M2_2/nmosHV$3_priv4_0.D M2_2/nmosHV$3_priv4_0.D M2_2/nmosHV$3_priv4_0.D VSS.t437 sg13_hv_nmos ad=0.17p pd=1.68u as=14.44555p ps=50.73u w=0.5u l=0.5u
X433 M15_2/nmosHV$1_priv1_0.D M15_2/nmosHV$1_priv1_0.D M15_2/nmosHV$1_priv1_0.D VSS.t9 sg13_hv_nmos ad=0.34p pd=2.68u as=0 ps=0 w=1u l=0.5u
X434 M22_1/pmosHV$1_priv2_0.D M22_1/pmosHV$1_priv2_0.D VDD3_3.t2 VDD3_3.t0 sg13_hv_pmos ad=0.38p pd=2.38u as=0.38p ps=2.38u w=2u l=0.5u
X435 VSS.t321 nmosHV_priv13_1.D nmosHV_priv13_1.D VSS.t320 sg13_hv_nmos ad=0.68p pd=4.68u as=0.68p ps=4.68u w=2u l=0.5u
X436 opm ACC_CAP ACC_CAP opm sg13_hv_pmos ad=0.38p pd=2.38u as=0.38p ps=2.38u w=2u l=0.5u
X437 VSS.t156 VSS.t153 VSS.t155 VSS.t154 sg13_hv_nmos ad=0.34p pd=2.68u as=0 ps=0 w=1u l=0.5u
X438 Cap_M1 VDD3_3.t231 M15_0/nmosHV$1_priv1_0.D VSS.t381 sg13_hv_nmos ad=0.34p pd=2.68u as=0.19p ps=1.38u w=1u l=0.5u
X439 Cap_M11 VDD3_3.t229 M15_2/nmosHV$1_priv1_0.D VSS.t250 sg13_hv_nmos ad=0.34p pd=2.68u as=0.19p ps=1.38u w=1u l=0.5u
X440 M21_1/nmosHV$5_priv1_0.D M20_1/nmosHV$5_priv2_0.D VSS.t435 VSS.t436 sg13_hv_nmos ad=0.68p pd=4.68u as=0.38p ps=2.38u w=2u l=0.5u
X441 M22_2/pmosHV$1_priv2_0.D M22_2/pmosHV$1_priv2_0.D VDD3_3.t198 VDD3_3.t20 sg13_hv_pmos ad=0.38p pd=2.38u as=0.38p ps=2.38u w=2u l=0.5u
X442 lnaf M24_1/pmosHV$1_priv4_0.D VDD3_3.t88 VDD3_3.t0 sg13_hv_pmos ad=0.38p pd=2.38u as=0.38p ps=2.38u w=2u l=0.5u
X443 M21_0/nmosHV$5_priv1_0.D M21_0/nmosHV$5_priv1_0.D M21_0/nmosHV$5_priv1_0.D VSS.t390 sg13_hv_nmos ad=0.51p pd=3.68u as=0 ps=0 w=1.5u l=0.5u
X444 VSS.t102 VSS.t99 VSS.t101 VSS.t100 sg13_hv_nmos ad=0.68p pd=4.68u as=0 ps=0 w=2u l=0.5u
X445 M16_2/nmosHV$2_priv1_0.D M16_2/nmosHV$2_priv1_0.D VSS.t471 VSS.t154 sg13_hv_nmos ad=0.34p pd=2.68u as=0.19p ps=1.38u w=1u l=0.5u
X446 M22_1/pmosHV$1_priv2_0.D M22_1/pmosHV$1_priv2_0.D VDD3_3.t4 VDD3_3.t0 sg13_hv_pmos ad=0.38p pd=2.38u as=0.38p ps=2.38u w=2u l=0.5u
X447 GROUP1$2_0.nmosHV_priv3$2_0.S VSS.t389 VSS.t388 rhigh l=0.12344m w=2u
X448 M20_0/nmosHV$5_priv2_0.D M20_0/nmosHV$5_priv2_0.D VSS.t230 VSS.t231 sg13_hv_nmos ad=0.68p pd=4.68u as=0.38p ps=2.38u w=2u l=0.5u
X449 GROUP1$1$1_0.G GROUP1$1$1_0.G GROUP1$1$1_0.G VSS.t385 sg13_hv_nmos ad=0.68p pd=4.68u as=0 ps=0 w=2u l=4u
X450 GROUP3$1_2.G GROUP3$1_2.G GROUP3$1_2.G VDD3_3.t48 sg13_hv_pmos ad=1.36p pd=8.68u as=38.75025p ps=92.41u w=4u l=0.5u
X451 pmosHV_priv24_0.S ACC_CAP nmosHV_priv13_0.D VDD3_3.t40 sg13_hv_pmos ad=1.36p pd=8.68u as=1.36p ps=8.68u w=4u l=0.5u
X452 VSS.t357 nmosHV_priv13_3.D nmosHV_priv13_3.D VSS.t356 sg13_hv_nmos ad=0.68p pd=4.68u as=0.68p ps=4.68u w=2u l=0.5u
X453 M20_2/nmosHV$5_priv2_0.D M20_2/nmosHV$5_priv2_0.D M20_2/nmosHV$5_priv2_0.D VSS.t285 sg13_hv_nmos ad=0.68p pd=4.68u as=37.62435p ps=0.10861m w=2u l=0.5u
X454 M21_2/nmosHV$5_priv1_0.D M21_2/nmosHV$5_priv1_0.D M21_2/nmosHV$5_priv1_0.D VSS.t45 sg13_hv_nmos ad=0.68p pd=4.68u as=0 ps=0 w=2u l=0.5u
X455 VSS.t58 Cap_M21 M15_1/nmosHV$1_priv1_0.D VSS.t59 sg13_hv_nmos ad=0.19p pd=1.38u as=0.19p ps=1.38u w=1u l=0.5u
X456 VSS.t253 lnaf M23_1/pmosHV$1_priv3_0.D VSS.t252 sg13_hv_nmos ad=0.17p pd=1.68u as=0.17p ps=1.68u w=0.5u l=0.5u
X457 M23_0/pmosHV$1_priv3_0.D M22_0/pmosHV$1_priv2_0.D VDD3_3.t223 VDD3_3.t21 sg13_hv_pmos ad=0.68p pd=4.68u as=0.38p ps=2.38u w=2u l=0.5u
X458 VDD3_3.t32 M24_0/pmosHV$1_priv4_0.D M24_0/pmosHV$1_priv4_0.D VDD3_3.t21 sg13_hv_pmos ad=0.38p pd=2.38u as=0.38p ps=2.38u w=2u l=0.5u
X459 VDD3_3.t80 M24_2/pmosHV$1_priv4_0.D M24_2/pmosHV$1_priv4_0.D VDD3_3.t20 sg13_hv_pmos ad=0.38p pd=2.38u as=0.38p ps=2.38u w=2u l=0.5u
X460 VSS.t195 VSS.t192 VSS.t194 VSS.t193 sg13_hv_nmos ad=0.68p pd=4.68u as=0 ps=0 w=2u l=0.5u
X461 VSS.t76 Cap_M21 M15_1/nmosHV$1_priv1_0.D VSS.t77 sg13_hv_nmos ad=0.19p pd=1.38u as=0.34p ps=2.68u w=1u l=0.5u
X462 Cap_M1 Cap_M1 Cap_M1 VSS.t347 sg13_hv_nmos ad=0.34p pd=2.68u as=0 ps=0 w=1u l=0.5u
X463 Cap_M11 Cap_M11 Cap_M11 VSS.t250 sg13_hv_nmos ad=0.34p pd=2.68u as=0 ps=0 w=1u l=0.5u
X464 VSS.t95 VSS.t92 VSS.t94 VSS.t93 sg13_hv_nmos ad=0.17p pd=1.68u as=0 ps=0 w=0.5u l=0.5u
X465 M16_1/nmosHV$2_priv1_0.D M16_1/nmosHV$2_priv1_0.D M16_1/nmosHV$2_priv1_0.D VSS.t341 sg13_hv_nmos ad=0.34p pd=2.68u as=34.1645p ps=81.03u w=1u l=0.5u
X466 VSS.t61 Cap_M21 M15_1/nmosHV$1_priv1_0.D VSS.t62 sg13_hv_nmos ad=0.19p pd=1.38u as=0.19p ps=1.38u w=1u l=0.5u
X467 VDD3_3.t34 M24_0/pmosHV$1_priv4_0.D M24_0/pmosHV$1_priv4_0.D VDD3_3.t21 sg13_hv_pmos ad=0.38p pd=2.38u as=0.68p ps=4.68u w=2u l=0.5u
X468 VDD3_3.t82 M24_2/pmosHV$1_priv4_0.D M24_2/pmosHV$1_priv4_0.D VDD3_3.t20 sg13_hv_pmos ad=0.38p pd=2.38u as=0.68p ps=4.68u w=2u l=0.5u
X469 pmosHV_priv16_1.S pmosHV_priv16_1.S pmosHV_priv16_1.S VDD3_3.t42 sg13_hv_pmos ad=1.36p pd=8.68u as=0 ps=0 w=4u l=0.5u
X470 VSS.t46 M21_2/nmosHV$5_priv1_0.D lnaf VDD3_3.t0 sg13_hv_pmos ad=0.238p pd=2.08u as=0.238p ps=2.08u w=0.7u l=0.5u
X471 Cap_M1 Cap_M1 Cap_M1 VDD3_3.t21 sg13_hv_pmos ad=0.238p pd=2.08u as=0 ps=0 w=0.7u l=0.5u
X472 M23_2/pmosHV$1_priv3_0.D M22_2/pmosHV$1_priv2_0.D VDD3_3.t196 VDD3_3.t20 sg13_hv_pmos ad=0.38p pd=2.38u as=0.68p ps=4.68u w=2u l=0.5u
X473 GROUP1$1$1_0.G GROUP1$2_0.G GROUP1$2_0.nmosHV_priv3$2_0.S VSS.t331 sg13_hv_nmos ad=0.68p pd=4.68u as=0.68p ps=4.68u w=2u l=4u
X474 VSS.t148 VSS.t145 VSS.t147 VSS.t146 sg13_hv_nmos ad=0.17p pd=1.68u as=0 ps=0 w=0.5u l=0.5u
X475 M20_2/nmosHV$5_priv2_0.D M20_2/nmosHV$5_priv2_0.D VSS.t283 VSS.t284 sg13_hv_nmos ad=0.68p pd=4.68u as=0.38p ps=2.38u w=2u l=0.5u
X476 M21_0/nmosHV$5_priv1_0.D M20_0/nmosHV$5_priv2_0.D VSS.t239 VSS.t240 sg13_hv_nmos ad=0.68p pd=4.68u as=0.38p ps=2.38u w=2u l=0.5u
X477 VSS.t315 nmosHV_priv13_1.D GROUP1_0.G VSS.t314 sg13_hv_nmos ad=0.68p pd=4.68u as=0.68p ps=4.68u w=2u l=0.5u
X478 VDD3_3.t66 GROUP3_0.G GROUP3_0.G VDD3_3.t19 sg13_hv_pmos ad=0.38p pd=2.38u as=0.38p ps=2.38u w=2u l=0.5u
X479 M15_2/nmosHV$1_priv1_0.D Cap_M2 VSS.t12 VSS.t9 sg13_hv_nmos ad=0.19p pd=1.38u as=0.19p ps=1.38u w=1u l=0.5u
X480 M21_2/nmosHV$5_priv1_0.D M20_2/nmosHV$5_priv2_0.D VSS.t290 VSS.t291 sg13_hv_nmos ad=0.68p pd=4.68u as=0.38p ps=2.38u w=2u l=0.5u
X481 Cap_M21 M16_1/nmosHV$2_priv1_0.D VSS.t408 rhigh l=40u w=2u
X482 VSS.t325 nmosHV_priv13_1.D GROUP1_0.G VSS.t324 sg13_hv_nmos ad=0.68p pd=4.68u as=0.68p ps=4.68u w=2u l=0.5u
X483 opm GROUP3_0.G VDD3_3.t61 VDD3_3.t19 sg13_hv_pmos ad=0.38p pd=2.38u as=0.38p ps=2.38u w=2u l=0.5u
X484 VDD3_3.t108 VDD3_3.t106 VDD3_3.t107 VSS.t378 sg13_hv_nmos ad=0.51p pd=3.68u as=0 ps=0 w=1.5u l=0.5u
X485 M15_0/nmosHV$1_priv1_0.D vin VSS.t465 VSS.t464 sg13_hv_nmos ad=0.19p pd=1.38u as=0.19p ps=1.38u w=1u l=0.5u
X486 VSS.t319 nmosHV_priv13_1.D GROUP1_0.G VSS.t318 sg13_hv_nmos ad=0.68p pd=4.68u as=0.68p ps=4.68u w=2u l=0.5u
X487 M15_0/nmosHV$1_priv1_0.D M15_0/nmosHV$1_priv1_0.D M15_0/nmosHV$1_priv1_0.D VSS.t373 sg13_hv_nmos ad=0.34p pd=2.68u as=0 ps=0 w=1u l=0.5u
X488 nmosHV_priv13_0.D nmosHV_priv13_0.D nmosHV_priv13_0.D VSS.t256 sg13_hv_nmos ad=0.68p pd=4.68u as=0 ps=0 w=2u l=0.5u
X489 VDD3_3.t171 VDD3_3.t169 VDD3_3.t170 VDD3_3.t16 sg13_hv_pmos ad=1.36p pd=8.68u as=0 ps=0 w=4u l=0.5u
X490 VDD3_3.t18 GROUP3$1_0.G pmosHV_priv24_0.S VDD3_3.t16 sg13_hv_pmos ad=1.36p pd=8.68u as=1.36p ps=8.68u w=4u l=0.5u
X491 GROUP1$1_0.G GROUP1_0.G GROUP1_0.nmosHV_priv3_0.S VSS.t402 sg13_hv_nmos ad=0.68p pd=4.68u as=0.68p ps=4.68u w=2u l=4u
X492 pmosHV_priv26_3.S ACC_CAP nmosHV_priv13_3.D VDD3_3.t49 sg13_hv_pmos ad=1.36p pd=8.68u as=1.36p ps=8.68u w=4u l=0.5u
X493 VSS.t266 nmosHV_priv13_0.D nmosHV_priv13_0.D VSS.t265 sg13_hv_nmos ad=0.68p pd=4.68u as=0.68p ps=4.68u w=2u l=0.5u
X494 GROUP1$1$2_0.G GROUP1$1$2_0.G GROUP1$1$2_0.G VSS.t2 sg13_hv_nmos ad=0.68p pd=4.68u as=0 ps=0 w=2u l=4u
X495 ACC_CAP ACC_CAP opm opm sg13_hv_pmos ad=0.38p pd=2.38u as=0.38p ps=2.38u w=2u l=0.5u
X496 M23_0/pmosHV$1_priv3_0.D M23_0/pmosHV$1_priv3_0.D M23_0/pmosHV$1_priv3_0.D VSS.t404 sg13_hv_nmos ad=0.17p pd=1.68u as=0 ps=0 w=0.5u l=0.5u
X497 VDD3_3.t53 GROUP3$1_2.G pmosHV_priv26_3.S VDD3_3.t48 sg13_hv_pmos ad=1.36p pd=8.68u as=1.36p ps=8.68u w=4u l=0.5u
X498 vref2 vref3 VSS.t245 rhigh l=1.4u w=2u
X499 M24_0/pmosHV$1_priv4_0.D M24_0/pmosHV$1_priv4_0.D M24_0/pmosHV$1_priv4_0.D VDD3_3.t21 sg13_hv_pmos ad=0.68p pd=4.68u as=34.3557p ps=0.14088m w=2u l=0.5u
X500 pmosHV_priv16_1.S pmosHV_priv16_1.S pmosHV_priv16_1.S VDD3_3.t41 sg13_hv_pmos ad=1.36p pd=8.68u as=0 ps=0 w=4u l=0.5u
X501 M24_2/pmosHV$1_priv4_0.D M24_2/pmosHV$1_priv4_0.D M24_2/pmosHV$1_priv4_0.D VDD3_3.t20 sg13_hv_pmos ad=0.68p pd=4.68u as=34.3557p ps=0.14088m w=2u l=0.5u
X502 VDD3_3.t88 M24_1/pmosHV$1_priv4_0.D lnaf VDD3_3.t0 sg13_hv_pmos ad=0.38p pd=2.38u as=0.38p ps=2.38u w=2u l=0.5u
X503 VDD3_3.t4 M22_1/pmosHV$1_priv2_0.D M22_1/pmosHV$1_priv2_0.D VDD3_3.t0 sg13_hv_pmos ad=0.38p pd=2.38u as=0.38p ps=2.38u w=2u l=0.5u
X504 VSS.t113 VSS.t111 VSS.t112 VDD3_3.t20 sg13_hv_pmos ad=0.238p pd=2.08u as=0 ps=0 w=0.7u l=0.5u
X505 VDD3_3.t200 M22_2/pmosHV$1_priv2_0.D M22_2/pmosHV$1_priv2_0.D VDD3_3.t20 sg13_hv_pmos ad=0.38p pd=2.38u as=0.38p ps=2.38u w=2u l=0.5u
X506 ACC_CAP ACC_CAP opm opm sg13_hv_pmos ad=0.38p pd=2.38u as=0.38p ps=2.38u w=2u l=0.5u
X507 M15_1/nmosHV$1_priv1_0.D Cap_M21 VSS.t67 VSS.t66 sg13_hv_nmos ad=0.19p pd=1.38u as=0.19p ps=1.38u w=1u l=0.5u
R0 VDD3_3.n27 VDD3_3.n28 0.0378558
R1 VDD3_3.n26 VDD3_3.n25 0.0378558
R2 VDD3_3.n31 VDD3_3.n32 0.0378558
R3 VDD3_3.n30 VDD3_3.n29 0.0378558
R4 VDD3_3.n36 VDD3_3.n35 0.0378558
R5 VDD3_3.n33 VDD3_3.n34 0.0378558
R6 VDD3_3.n40 VDD3_3.n39 0.0378558
R7 VDD3_3.n37 VDD3_3.n38 0.0378558
R8 VDD3_3.n43 VDD3_3.n44 0.0378558
R9 VDD3_3.n42 VDD3_3.n41 0.0378558
R10 VDD3_3.n47 VDD3_3.n48 0.0378558
R11 VDD3_3.n46 VDD3_3.n45 0.0378558
R12 VDD3_3.t107 VDD3_3.n245 17.0005
R13 VDD3_3.n249 VDD3_3.t107 17.0005
R14 VDD3_3.n52 VDD3_3.n51 0.0378558
R15 VDD3_3.n49 VDD3_3.n50 0.0378558
R16 VDD3_3.n56 VDD3_3.n55 0.0378558
R17 VDD3_3.n53 VDD3_3.n54 0.0378558
R18 VDD3_3.n104 VDD3_3.t171 17.0005
R19 VDD3_3.t171 VDD3_3.n95 17.0005
R20 VDD3_3.t171 VDD3_3.n92 17.0005
R21 VDD3_3.t170 VDD3_3.n101 17.0005
R22 VDD3_3.n118 VDD3_3.t168 17.0005
R23 VDD3_3.t167 VDD3_3.n107 17.0005
R24 VDD3_3.t165 VDD3_3.n136 17.0005
R25 VDD3_3.n141 VDD3_3.t164 17.0005
R26 VDD3_3.n135 VDD3_3.t164 17.0005
R27 VDD3_3.t164 VDD3_3.n129 17.0005
R28 VDD3_3.n156 VDD3_3.t162 17.0005
R29 VDD3_3.t162 VDD3_3.n147 17.0005
R30 VDD3_3.t162 VDD3_3.n144 17.0005
R31 VDD3_3.t161 VDD3_3.n152 17.0005
R32 VDD3_3.n179 VDD3_3.t159 17.0005
R33 VDD3_3.t159 VDD3_3.n171 17.0005
R34 VDD3_3.t159 VDD3_3.n167 17.0005
R35 VDD3_3.t158 VDD3_3.n175 17.0005
R36 VDD3_3.n194 VDD3_3.t156 17.0005
R37 VDD3_3.t156 VDD3_3.n184 17.0005
R38 VDD3_3.t156 VDD3_3.n182 17.0005
R39 VDD3_3.t155 VDD3_3.n190 17.0005
R40 VDD3_3.t153 VDD3_3.n216 17.0005
R41 VDD3_3.t153 VDD3_3.n210 17.0005
R42 VDD3_3.t153 VDD3_3.n205 17.0005
R43 VDD3_3.n218 VDD3_3.t152 17.0005
R44 VDD3_3.n215 VDD3_3.t152 17.0005
R45 VDD3_3.n209 VDD3_3.t152 17.0005
R46 VDD3_3.n232 VDD3_3.t150 17.0005
R47 VDD3_3.t149 VDD3_3.n221 17.0005
R48 VDD3_3.n60 VDD3_3.n59 0.0378558
R49 VDD3_3.n57 VDD3_3.n58 0.0378558
R50 VDD3_3.n64 VDD3_3.n63 0.0378558
R51 VDD3_3.n61 VDD3_3.n62 0.0378558
R52 VDD3_3.n67 VDD3_3.n68 0.0378558
R53 VDD3_3.n66 VDD3_3.n65 0.0378558
R54 VDD3_3.n71 VDD3_3.n72 0.0378558
R55 VDD3_3.n70 VDD3_3.n69 0.0378558
R56 VDD3_3.t116 VDD3_3.n360 17.0005
R57 VDD3_3.n364 VDD3_3.t116 17.0005
R58 VDD3_3.n76 VDD3_3.n75 0.0378558
R59 VDD3_3.n73 VDD3_3.n74 0.0378558
R60 VDD3_3.n80 VDD3_3.n79 0.0378558
R61 VDD3_3.n77 VDD3_3.n78 0.0378558
R62 VDD3_3.t131 VDD3_3.n516 17.0005
R63 VDD3_3.n520 VDD3_3.t131 17.0005
R64 VDD3_3.t145 VDD3_3.n27 15.0513
R65 VDD3_3.t133 VDD3_3.n31 15.0513
R66 VDD3_3.t121 VDD3_3.n33 15.0513
R67 VDD3_3.t103 VDD3_3.n37 15.0513
R68 VDD3_3.t139 VDD3_3.n43 15.0513
R69 VDD3_3.t109 VDD3_3.n47 15.0513
R70 VDD3_3.t106 VDD3_3.n249 15.0513
R71 VDD3_3.t175 VDD3_3.n49 15.0513
R72 VDD3_3.t172 VDD3_3.n53 15.0513
R73 VDD3_3.t169 VDD3_3.n104 15.0513
R74 VDD3_3.t166 VDD3_3.n118 15.0513
R75 VDD3_3.t163 VDD3_3.n141 15.0513
R76 VDD3_3.t160 VDD3_3.n156 15.0513
R77 VDD3_3.t157 VDD3_3.n179 15.0513
R78 VDD3_3.t154 VDD3_3.n194 15.0513
R79 VDD3_3.t151 VDD3_3.n218 15.0513
R80 VDD3_3.t148 VDD3_3.n232 15.0513
R81 VDD3_3.t127 VDD3_3.n57 15.0513
R82 VDD3_3.t112 VDD3_3.n61 15.0513
R83 VDD3_3.t142 VDD3_3.n67 15.0513
R84 VDD3_3.t118 VDD3_3.n71 15.0513
R85 VDD3_3.t115 VDD3_3.n364 15.0513
R86 VDD3_3.t136 VDD3_3.n73 15.0513
R87 VDD3_3.t124 VDD3_3.n77 15.0513
R88 VDD3_3.t130 VDD3_3.n520 15.0513
R89 VDD3_3.n474 VDD3_3.t227 15.0005
R90 VDD3_3.t227 VDD3_3.n472 15.0005
R91 VDD3_3.n496 VDD3_3.t145 15.0005
R92 VDD3_3.n486 VDD3_3.t133 15.0005
R93 VDD3_3.n304 VDD3_3.t121 15.0005
R94 VDD3_3.n295 VDD3_3.t103 15.0005
R95 VDD3_3.n272 VDD3_3.t139 15.0005
R96 VDD3_3.n260 VDD3_3.t109 15.0005
R97 VDD3_3.n286 VDD3_3.t231 15.0005
R98 VDD3_3.t231 VDD3_3.n284 15.0005
R99 VDD3_3.n250 VDD3_3.t106 15.0005
R100 VDD3_3.n82 VDD3_3.t175 15.0005
R101 VDD3_3.n642 VDD3_3.t172 15.0005
R102 VDD3_3.n105 VDD3_3.t169 15.0005
R103 VDD3_3.n119 VDD3_3.t166 15.0005
R104 VDD3_3.n142 VDD3_3.t163 15.0005
R105 VDD3_3.n157 VDD3_3.t160 15.0005
R106 VDD3_3.n180 VDD3_3.t157 15.0005
R107 VDD3_3.n195 VDD3_3.t154 15.0005
R108 VDD3_3.n219 VDD3_3.t151 15.0005
R109 VDD3_3.n233 VDD3_3.t148 15.0005
R110 VDD3_3.n352 VDD3_3.t127 15.0005
R111 VDD3_3.n343 VDD3_3.t112 15.0005
R112 VDD3_3.n387 VDD3_3.t142 15.0005
R113 VDD3_3.n377 VDD3_3.t118 15.0005
R114 VDD3_3.n401 VDD3_3.t229 15.0005
R115 VDD3_3.t229 VDD3_3.n399 15.0005
R116 VDD3_3.n365 VDD3_3.t115 15.0005
R117 VDD3_3.n462 VDD3_3.t136 15.0005
R118 VDD3_3.n453 VDD3_3.t124 15.0005
R119 VDD3_3.n521 VDD3_3.t130 15.0005
R120 VDD3_3.n479 VDD3_3.t99 12.3725
R121 VDD3_3.n505 VDD3_3.t97 12.3725
R122 VDD3_3.n478 VDD3_3.t95 12.3725
R123 VDD3_3.n494 VDD3_3.t92 12.3725
R124 VDD3_3.n493 VDD3_3.t90 12.3725
R125 VDD3_3.n483 VDD3_3.t88 12.3725
R126 VDD3_3.n278 VDD3_3.t34 12.3725
R127 VDD3_3.n279 VDD3_3.t32 12.3725
R128 VDD3_3.n275 VDD3_3.t30 12.3725
R129 VDD3_3.n270 VDD3_3.t28 12.3725
R130 VDD3_3.n257 VDD3_3.t26 12.3725
R131 VDD3_3.n263 VDD3_3.t24 12.3725
R132 VDD3_3.n370 VDD3_3.t82 12.3725
R133 VDD3_3.n396 VDD3_3.t80 12.3725
R134 VDD3_3.n369 VDD3_3.t78 12.3725
R135 VDD3_3.n385 VDD3_3.t76 12.3725
R136 VDD3_3.n384 VDD3_3.t74 12.3725
R137 VDD3_3.n374 VDD3_3.t72 12.3725
R138 VDD3_3.n307 VDD3_3.t223 12.3721
R139 VDD3_3.n308 VDD3_3.t221 12.3721
R140 VDD3_3.n7 VDD3_3.t219 12.3721
R141 VDD3_3.n298 VDD3_3.t217 12.3721
R142 VDD3_3.n299 VDD3_3.t215 12.3721
R143 VDD3_3.n293 VDD3_3.t213 12.3721
R144 VDD3_3.n355 VDD3_3.t208 12.3721
R145 VDD3_3.n356 VDD3_3.t206 12.3721
R146 VDD3_3.n2 VDD3_3.t204 12.3721
R147 VDD3_3.n346 VDD3_3.t202 12.3721
R148 VDD3_3.n347 VDD3_3.t200 12.3721
R149 VDD3_3.n341 VDD3_3.t198 12.3721
R150 VDD3_3.n465 VDD3_3.t13 12.3721
R151 VDD3_3.n466 VDD3_3.t11 12.3721
R152 VDD3_3.n10 VDD3_3.t9 12.3721
R153 VDD3_3.n456 VDD3_3.t6 12.3721
R154 VDD3_3.n457 VDD3_3.t4 12.3721
R155 VDD3_3.n451 VDD3_3.t2 12.3721
R156 VDD3_3.n8 VDD3_3.n251 9.88511
R157 VDD3_3.n3 VDD3_3.n366 9.88511
R158 VDD3_3.n19 VDD3_3.n522 9.88511
R159 VDD3_3.n311 VDD3_3.n310 9.53557
R160 VDD3_3.n302 VDD3_3.n301 9.53557
R161 VDD3_3.n86 VDD3_3.n85 9.53557
R162 VDD3_3.n646 VDD3_3.n645 9.53557
R163 VDD3_3.n359 VDD3_3.n358 9.53557
R164 VDD3_3.n350 VDD3_3.n349 9.53557
R165 VDD3_3.n469 VDD3_3.n468 9.53557
R166 VDD3_3.n460 VDD3_3.n459 9.53557
R167 VDD3_3.n121 VDD3_3.n120 9.44563
R168 VDD3_3.n159 VDD3_3.n158 9.44563
R169 VDD3_3.n197 VDD3_3.n196 9.44563
R170 VDD3_3.n235 VDD3_3.n234 9.44563
R171 VDD3_3.n127 VDD3_3.n126 9.42404
R172 VDD3_3.n165 VDD3_3.n164 9.42404
R173 VDD3_3.n203 VDD3_3.n202 9.42404
R174 VDD3_3.n90 VDD3_3.n89 9.42386
R175 VDD3_3.n8 VDD3_3.n311 9.26803
R176 VDD3_3.n310 VDD3_3.n307 9.26803
R177 VDD3_3.n6 VDD3_3.n302 9.26803
R178 VDD3_3.n301 VDD3_3.n298 9.26803
R179 VDD3_3.t19 VDD3_3.n86 9.26803
R180 VDD3_3.n85 VDD3_3.t58 9.26803
R181 VDD3_3.n647 VDD3_3.n646 9.26803
R182 VDD3_3.n645 VDD3_3.t56 9.26803
R183 VDD3_3.n3 VDD3_3.n359 9.26803
R184 VDD3_3.n358 VDD3_3.n355 9.26803
R185 VDD3_3.n1 VDD3_3.n350 9.26803
R186 VDD3_3.n349 VDD3_3.n346 9.26803
R187 VDD3_3.n13 VDD3_3.n469 9.26803
R188 VDD3_3.n468 VDD3_3.n465 9.26803
R189 VDD3_3.n12 VDD3_3.n460 9.26803
R190 VDD3_3.n459 VDD3_3.n456 9.26803
R191 VDD3_3.n503 VDD3_3.n479 9.07844
R192 VDD3_3.n489 VDD3_3.n488 9.07844
R193 VDD3_3.n278 VDD3_3.n277 9.07844
R194 VDD3_3.n265 VDD3_3.n262 9.07844
R195 VDD3_3.n394 VDD3_3.n370 9.07844
R196 VDD3_3.n380 VDD3_3.n379 9.07844
R197 VDD3_3.n20 VDD3_3.n19 2.24146
R198 VDD3_3.n505 VDD3_3.n504 9.0005
R199 VDD3_3.n484 VDD3_3.n483 9.0005
R200 VDD3_3.n493 VDD3_3.n492 9.0005
R201 VDD3_3.n494 VDD3_3.n482 9.0005
R202 VDD3_3.n499 VDD3_3.n498 9.0005
R203 VDD3_3.n500 VDD3_3.n478 9.0005
R204 VDD3_3.n488 VDD3_3.n487 9.0005
R205 VDD3_3.n498 VDD3_3.n497 9.0005
R206 VDD3_3.n492 VDD3_3.n491 9.0005
R207 VDD3_3.n490 VDD3_3.n482 9.0005
R208 VDD3_3.n499 VDD3_3.n481 9.0005
R209 VDD3_3.n501 VDD3_3.n500 9.0005
R210 VDD3_3.n306 VDD3_3.n7 9.0005
R211 VDD3_3.n309 VDD3_3.n308 9.0005
R212 VDD3_3.n8 VDD3_3.n305 9.0005
R213 VDD3_3.n297 VDD3_3.n293 9.0005
R214 VDD3_3.n300 VDD3_3.n299 9.0005
R215 VDD3_3.n6 VDD3_3.n296 9.0005
R216 VDD3_3.n8 VDD3_3.n18 2.24146
R217 VDD3_3.n280 VDD3_3.n279 9.0005
R218 VDD3_3.n264 VDD3_3.n263 9.0005
R219 VDD3_3.n258 VDD3_3.n257 9.0005
R220 VDD3_3.n270 VDD3_3.n269 9.0005
R221 VDD3_3.n274 VDD3_3.n255 9.0005
R222 VDD3_3.n276 VDD3_3.n275 9.0005
R223 VDD3_3.n262 VDD3_3.n261 9.0005
R224 VDD3_3.n274 VDD3_3.n273 9.0005
R225 VDD3_3.n266 VDD3_3.n258 9.0005
R226 VDD3_3.n269 VDD3_3.n268 9.0005
R227 VDD3_3.n267 VDD3_3.n255 9.0005
R228 VDD3_3.n276 VDD3_3.n256 9.0005
R229 VDD3_3.t19 VDD3_3.t69 9.0005
R230 VDD3_3.n84 VDD3_3.t62 9.0005
R231 VDD3_3.n83 VDD3_3.t66 9.0005
R232 VDD3_3.n643 VDD3_3.t59 9.0005
R233 VDD3_3.n644 VDD3_3.t61 9.0005
R234 VDD3_3.n647 VDD3_3.t68 9.0005
R235 VDD3_3.n121 VDD3_3.n106 9.0005
R236 VDD3_3.n159 VDD3_3.n143 9.0005
R237 VDD3_3.n197 VDD3_3.n181 9.0005
R238 VDD3_3.n235 VDD3_3.n220 9.0005
R239 VDD3_3.n354 VDD3_3.n2 9.0005
R240 VDD3_3.n357 VDD3_3.n356 9.0005
R241 VDD3_3.n3 VDD3_3.n353 9.0005
R242 VDD3_3.n345 VDD3_3.n341 9.0005
R243 VDD3_3.n348 VDD3_3.n347 9.0005
R244 VDD3_3.n1 VDD3_3.n344 9.0005
R245 VDD3_3.n3 VDD3_3.n17 2.24146
R246 VDD3_3.n396 VDD3_3.n395 9.0005
R247 VDD3_3.n375 VDD3_3.n374 9.0005
R248 VDD3_3.n384 VDD3_3.n383 9.0005
R249 VDD3_3.n385 VDD3_3.n373 9.0005
R250 VDD3_3.n390 VDD3_3.n389 9.0005
R251 VDD3_3.n391 VDD3_3.n369 9.0005
R252 VDD3_3.n379 VDD3_3.n378 9.0005
R253 VDD3_3.n389 VDD3_3.n388 9.0005
R254 VDD3_3.n383 VDD3_3.n382 9.0005
R255 VDD3_3.n381 VDD3_3.n373 9.0005
R256 VDD3_3.n390 VDD3_3.n372 9.0005
R257 VDD3_3.n392 VDD3_3.n391 9.0005
R258 VDD3_3.n464 VDD3_3.n10 9.0005
R259 VDD3_3.n467 VDD3_3.n466 9.0005
R260 VDD3_3.n13 VDD3_3.n463 9.0005
R261 VDD3_3.n455 VDD3_3.n451 9.0005
R262 VDD3_3.n458 VDD3_3.n457 9.0005
R263 VDD3_3.n12 VDD3_3.n454 9.0005
R264 VDD3_3.n123 VDD3_3.t16 8.60351
R265 VDD3_3.n161 VDD3_3.t44 8.60351
R266 VDD3_3.n199 VDD3_3.t48 8.60351
R267 VDD3_3.n237 VDD3_3.t41 8.60351
R268 VDD3_3.t21 VDD3_3.n292 8.59567
R269 VDD3_3.t20 VDD3_3.n407 8.59567
R270 VDD3_3.t0 VDD3_3.n515 8.59567
R271 VDD3_3.t147 VDD3_3.n28 5.65162
R272 VDD3_3.t147 VDD3_3.n26 5.65162
R273 VDD3_3.t146 VDD3_3.n27 8.49202
R274 VDD3_3.t146 VDD3_3.n495 8.49202
R275 VDD3_3.n25 VDD3_3.t146 8.49202
R276 VDD3_3.t135 VDD3_3.n32 5.65162
R277 VDD3_3.t135 VDD3_3.n30 5.65162
R278 VDD3_3.t134 VDD3_3.n31 8.49202
R279 VDD3_3.t134 VDD3_3.n485 8.49202
R280 VDD3_3.n29 VDD3_3.t134 8.49202
R281 VDD3_3.t123 VDD3_3.n35 8.49202
R282 VDD3_3.t123 VDD3_3.n303 8.49202
R283 VDD3_3.n33 VDD3_3.t123 8.49202
R284 VDD3_3.n36 VDD3_3.t122 5.65162
R285 VDD3_3.n34 VDD3_3.t122 5.65162
R286 VDD3_3.t105 VDD3_3.n39 8.49202
R287 VDD3_3.t105 VDD3_3.n294 8.49202
R288 VDD3_3.n37 VDD3_3.t105 8.49202
R289 VDD3_3.n40 VDD3_3.t104 5.65162
R290 VDD3_3.n38 VDD3_3.t104 5.65162
R291 VDD3_3.t141 VDD3_3.n44 5.65162
R292 VDD3_3.t141 VDD3_3.n42 5.65162
R293 VDD3_3.t140 VDD3_3.n43 8.49202
R294 VDD3_3.t140 VDD3_3.n271 8.49202
R295 VDD3_3.n41 VDD3_3.t140 8.49202
R296 VDD3_3.t111 VDD3_3.n48 5.65162
R297 VDD3_3.t111 VDD3_3.n46 5.65162
R298 VDD3_3.t110 VDD3_3.n47 8.49202
R299 VDD3_3.t110 VDD3_3.n259 8.49202
R300 VDD3_3.n45 VDD3_3.t110 8.49202
R301 VDD3_3.t177 VDD3_3.n52 5.65162
R302 VDD3_3.t177 VDD3_3.n50 5.65162
R303 VDD3_3.t176 VDD3_3.n51 8.49202
R304 VDD3_3.n81 VDD3_3.t176 8.49202
R305 VDD3_3.t176 VDD3_3.n49 8.49202
R306 VDD3_3.t174 VDD3_3.n56 5.65162
R307 VDD3_3.t174 VDD3_3.n54 5.65162
R308 VDD3_3.t173 VDD3_3.n55 8.49202
R309 VDD3_3.n641 VDD3_3.t173 8.49202
R310 VDD3_3.t173 VDD3_3.n53 8.49202
R311 VDD3_3.t129 VDD3_3.n59 8.49202
R312 VDD3_3.t129 VDD3_3.n351 8.49202
R313 VDD3_3.n57 VDD3_3.t129 8.49202
R314 VDD3_3.n60 VDD3_3.t128 5.65162
R315 VDD3_3.n58 VDD3_3.t128 5.65162
R316 VDD3_3.t114 VDD3_3.n63 8.49202
R317 VDD3_3.t114 VDD3_3.n342 8.49202
R318 VDD3_3.n61 VDD3_3.t114 8.49202
R319 VDD3_3.n64 VDD3_3.t113 5.65162
R320 VDD3_3.n62 VDD3_3.t113 5.65162
R321 VDD3_3.t144 VDD3_3.n68 5.65162
R322 VDD3_3.t144 VDD3_3.n66 5.65162
R323 VDD3_3.t143 VDD3_3.n67 8.49202
R324 VDD3_3.t143 VDD3_3.n386 8.49202
R325 VDD3_3.n65 VDD3_3.t143 8.49202
R326 VDD3_3.t120 VDD3_3.n72 5.65162
R327 VDD3_3.t120 VDD3_3.n70 5.65162
R328 VDD3_3.t119 VDD3_3.n71 8.49202
R329 VDD3_3.t119 VDD3_3.n376 8.49202
R330 VDD3_3.n69 VDD3_3.t119 8.49202
R331 VDD3_3.t138 VDD3_3.n75 8.49202
R332 VDD3_3.t138 VDD3_3.n461 8.49202
R333 VDD3_3.n73 VDD3_3.t138 8.49202
R334 VDD3_3.n76 VDD3_3.t137 5.65162
R335 VDD3_3.n74 VDD3_3.t137 5.65162
R336 VDD3_3.t126 VDD3_3.n79 8.49202
R337 VDD3_3.t126 VDD3_3.n452 8.49202
R338 VDD3_3.n77 VDD3_3.t126 8.49202
R339 VDD3_3.n80 VDD3_3.t125 5.65162
R340 VDD3_3.n78 VDD3_3.t125 5.65162
R341 VDD3_3.t171 VDD3_3.n103 8.49123
R342 VDD3_3.t171 VDD3_3.n97 8.49123
R343 VDD3_3.t171 VDD3_3.n96 8.49123
R344 VDD3_3.t171 VDD3_3.n94 8.49123
R345 VDD3_3.t170 VDD3_3.n93 8.49123
R346 VDD3_3.n102 VDD3_3.t170 8.49123
R347 VDD3_3.t170 VDD3_3.n100 8.49123
R348 VDD3_3.t170 VDD3_3.n99 8.49123
R349 VDD3_3.t170 VDD3_3.n98 8.49123
R350 VDD3_3.t168 VDD3_3.n111 8.49123
R351 VDD3_3.t168 VDD3_3.n112 8.49123
R352 VDD3_3.t168 VDD3_3.n110 8.49123
R353 VDD3_3.t168 VDD3_3.n117 8.49123
R354 VDD3_3.t168 VDD3_3.n109 8.49123
R355 VDD3_3.t167 VDD3_3.n108 8.49123
R356 VDD3_3.t167 VDD3_3.n114 8.49123
R357 VDD3_3.t167 VDD3_3.n115 8.49123
R358 VDD3_3.n116 VDD3_3.t167 8.49123
R359 VDD3_3.t167 VDD3_3.n113 8.49123
R360 VDD3_3.n140 VDD3_3.t165 8.49123
R361 VDD3_3.t165 VDD3_3.n134 8.49123
R362 VDD3_3.t165 VDD3_3.n139 8.49123
R363 VDD3_3.t165 VDD3_3.n133 8.49123
R364 VDD3_3.t165 VDD3_3.n131 8.49123
R365 VDD3_3.n130 VDD3_3.t164 8.49123
R366 VDD3_3.n138 VDD3_3.t164 8.49123
R367 VDD3_3.n137 VDD3_3.t164 8.49123
R368 VDD3_3.n132 VDD3_3.t164 8.49123
R369 VDD3_3.t162 VDD3_3.n155 8.49123
R370 VDD3_3.t162 VDD3_3.n149 8.49123
R371 VDD3_3.t162 VDD3_3.n148 8.49123
R372 VDD3_3.t162 VDD3_3.n146 8.49123
R373 VDD3_3.t161 VDD3_3.n145 8.49123
R374 VDD3_3.n154 VDD3_3.t161 8.49123
R375 VDD3_3.t161 VDD3_3.n151 8.49123
R376 VDD3_3.t161 VDD3_3.n150 8.49123
R377 VDD3_3.t161 VDD3_3.n153 8.49123
R378 VDD3_3.t159 VDD3_3.n178 8.49123
R379 VDD3_3.t159 VDD3_3.n172 8.49123
R380 VDD3_3.t159 VDD3_3.n170 8.49123
R381 VDD3_3.t159 VDD3_3.n169 8.49123
R382 VDD3_3.t158 VDD3_3.n168 8.49123
R383 VDD3_3.n177 VDD3_3.t158 8.49123
R384 VDD3_3.t158 VDD3_3.n174 8.49123
R385 VDD3_3.t158 VDD3_3.n176 8.49123
R386 VDD3_3.t158 VDD3_3.n173 8.49123
R387 VDD3_3.t156 VDD3_3.n187 8.49123
R388 VDD3_3.t156 VDD3_3.n193 8.49123
R389 VDD3_3.t156 VDD3_3.n186 8.49123
R390 VDD3_3.t156 VDD3_3.n185 8.49123
R391 VDD3_3.t155 VDD3_3.n183 8.49123
R392 VDD3_3.n192 VDD3_3.t155 8.49123
R393 VDD3_3.t155 VDD3_3.n188 8.49123
R394 VDD3_3.t155 VDD3_3.n189 8.49123
R395 VDD3_3.t155 VDD3_3.n191 8.49123
R396 VDD3_3.n217 VDD3_3.t153 8.49123
R397 VDD3_3.t153 VDD3_3.n214 8.49123
R398 VDD3_3.t153 VDD3_3.n212 8.49123
R399 VDD3_3.t153 VDD3_3.n208 8.49123
R400 VDD3_3.n206 VDD3_3.t152 8.49123
R401 VDD3_3.n213 VDD3_3.t152 8.49123
R402 VDD3_3.n211 VDD3_3.t152 8.49123
R403 VDD3_3.n207 VDD3_3.t152 8.49123
R404 VDD3_3.t150 VDD3_3.n225 8.49123
R405 VDD3_3.t150 VDD3_3.n224 8.49123
R406 VDD3_3.t150 VDD3_3.n226 8.49123
R407 VDD3_3.t150 VDD3_3.n231 8.49123
R408 VDD3_3.t150 VDD3_3.n223 8.49123
R409 VDD3_3.t149 VDD3_3.n222 8.49123
R410 VDD3_3.t149 VDD3_3.n229 8.49123
R411 VDD3_3.t149 VDD3_3.n228 8.49123
R412 VDD3_3.n230 VDD3_3.t149 8.49123
R413 VDD3_3.t149 VDD3_3.n227 8.49123
R414 VDD3_3.n246 VDD3_3.t108 8.49044
R415 VDD3_3.n248 VDD3_3.t108 8.49044
R416 VDD3_3.n247 VDD3_3.t107 8.49044
R417 VDD3_3.n361 VDD3_3.t117 8.49044
R418 VDD3_3.n363 VDD3_3.t117 8.49044
R419 VDD3_3.n362 VDD3_3.t116 8.49044
R420 VDD3_3.n517 VDD3_3.t132 8.49044
R421 VDD3_3.n519 VDD3_3.t132 8.49044
R422 VDD3_3.n518 VDD3_3.t131 8.49044
R423 VDD3_3.n87 VDD3_3.t187 7.5005
R424 VDD3_3.n124 VDD3_3.t184 7.5005
R425 VDD3_3.n162 VDD3_3.t181 7.5005
R426 VDD3_3.n200 VDD3_3.t178 7.5005
R427 VDD3_3.n473 VDD3_3.t226 6.82982
R428 VDD3_3.n285 VDD3_3.t230 6.82982
R429 VDD3_3.n400 VDD3_3.t228 6.82982
R430 VDD3_3.n90 VDD3_3.t85 5.5084
R431 VDD3_3.n127 VDD3_3.t15 5.50831
R432 VDD3_3.n165 VDD3_3.t51 5.50831
R433 VDD3_3.n203 VDD3_3.t84 5.50831
R434 VDD3_3.n640 VDD3_3.n639 5.48837
R435 VDD3_3.n639 VDD3_3.n638 5.319
R436 VDD3_3.n251 VDD3_3.t192 4.67826
R437 VDD3_3.n366 VDD3_3.t102 4.67826
R438 VDD3_3.n522 VDD3_3.t37 4.67826
R439 VDD3_3.n491 VDD3_3.n489 4.65588
R440 VDD3_3.n266 VDD3_3.n265 4.65588
R441 VDD3_3.n382 VDD3_3.n380 4.65588
R442 VDD3_3.n503 VDD3_3.n502 4.57712
R443 VDD3_3.n277 VDD3_3.n254 4.57712
R444 VDD3_3.n394 VDD3_3.n393 4.57712
R445 VDD3_3.n508 VDD3_3.n507 4.4955
R446 VDD3_3.n283 VDD3_3.n252 4.4955
R447 VDD3_3.n398 VDD3_3.n367 4.4955
R448 VDD3_3.n502 VDD3_3.n477 3.5945
R449 VDD3_3.n282 VDD3_3.n254 3.5945
R450 VDD3_3.n393 VDD3_3.n368 3.5945
R451 VDD3_3.n497 VDD3_3.t94 3.37253
R452 VDD3_3.n487 VDD3_3.t87 3.37253
R453 VDD3_3.n273 VDD3_3.t22 3.37253
R454 VDD3_3.n261 VDD3_3.t23 3.37253
R455 VDD3_3.n388 VDD3_3.t70 3.37253
R456 VDD3_3.n378 VDD3_3.t71 3.37253
R457 VDD3_3.n89 VDD3_3.t86 3.37187
R458 VDD3_3.n126 VDD3_3.t101 3.37187
R459 VDD3_3.n164 VDD3_3.t52 3.37187
R460 VDD3_3.n202 VDD3_3.t191 3.37187
R461 VDD3_3.n305 VDD3_3.t211 3.37096
R462 VDD3_3.n296 VDD3_3.t212 3.37096
R463 VDD3_3.n353 VDD3_3.t196 3.37096
R464 VDD3_3.n344 VDD3_3.t197 3.37096
R465 VDD3_3.n463 VDD3_3.t8 3.37096
R466 VDD3_3.n454 VDD3_3.t1 3.37096
R467 VDD3_3.n552 VDD3_3.t43 3.29751
R468 VDD3_3.n636 VDD3_3.n635 3.1355
R469 VDD3_3.n637 VDD3_3.n636 3.1355
R470 VDD3_3.n638 VDD3_3.n637 3.1355
R471 VDD3_3.n339 VDD3_3.t225 3.07253
R472 VDD3_3.n528 VDD3_3.t190 3.07253
R473 VDD3_3.n613 VDD3_3.n319 3.07178
R474 VDD3_3.n541 VDD3_3.n445 3.07178
R475 VDD3_3.n426 VDD3_3.n334 3.07178
R476 VDD3_3.n16 VDD3_3.n9 0.452301
R477 VDD3_3.n15 VDD3_3.n4 0.452301
R478 VDD3_3.n633 VDD3_3.n239 3.06922
R479 VDD3_3.n89 VDD3_3.n88 3.05532
R480 VDD3_3.n126 VDD3_3.n125 3.05532
R481 VDD3_3.n164 VDD3_3.n163 3.05532
R482 VDD3_3.n202 VDD3_3.n201 3.05532
R483 VDD3_3.n509 VDD3_3.n476 3.04112
R484 VDD3_3.n289 VDD3_3.n288 3.04112
R485 VDD3_3.n404 VDD3_3.n403 3.04112
R486 VDD3_3.n632 VDD3_3.n631 3.0005
R487 VDD3_3.n630 VDD3_3.n240 3.0005
R488 VDD3_3.n629 VDD3_3.n628 3.0005
R489 VDD3_3.n627 VDD3_3.n241 3.0005
R490 VDD3_3.n625 VDD3_3.n624 3.0005
R491 VDD3_3.n623 VDD3_3.n243 3.0005
R492 VDD3_3.n622 VDD3_3.n621 3.0005
R493 VDD3_3.n620 VDD3_3.n317 3.0005
R494 VDD3_3.n619 VDD3_3.n618 3.0005
R495 VDD3_3.n617 VDD3_3.n318 3.0005
R496 VDD3_3.n615 VDD3_3.n614 3.0005
R497 VDD3_3.n612 VDD3_3.n611 3.0005
R498 VDD3_3.n610 VDD3_3.n320 3.0005
R499 VDD3_3.n609 VDD3_3.n608 3.0005
R500 VDD3_3.n607 VDD3_3.n321 3.0005
R501 VDD3_3.n606 VDD3_3.n605 3.0005
R502 VDD3_3.n604 VDD3_3.n322 3.0005
R503 VDD3_3.n603 VDD3_3.n602 3.0005
R504 VDD3_3.n601 VDD3_3.n323 3.0005
R505 VDD3_3.n600 VDD3_3.n599 3.0005
R506 VDD3_3.n598 VDD3_3.n324 3.0005
R507 VDD3_3.n594 VDD3_3.n593 3.0005
R508 VDD3_3.n595 VDD3_3.n325 3.0005
R509 VDD3_3.n597 VDD3_3.n596 3.0005
R510 VDD3_3.n590 VDD3_3.n589 3.0005
R511 VDD3_3.n591 VDD3_3.n326 3.0005
R512 VDD3_3.n588 VDD3_3.n327 3.0005
R513 VDD3_3.n587 VDD3_3.n586 3.0005
R514 VDD3_3.n585 VDD3_3.n328 3.0005
R515 VDD3_3.n584 VDD3_3.n583 3.0005
R516 VDD3_3.n582 VDD3_3.n329 3.0005
R517 VDD3_3.n579 VDD3_3.n330 3.0005
R518 VDD3_3.n578 VDD3_3.n577 3.0005
R519 VDD3_3.n581 VDD3_3.n580 3.0005
R520 VDD3_3.n428 VDD3_3.n427 3.0005
R521 VDD3_3.n429 VDD3_3.n333 3.0005
R522 VDD3_3.n431 VDD3_3.n430 3.0005
R523 VDD3_3.n432 VDD3_3.n332 3.0005
R524 VDD3_3.n434 VDD3_3.n433 3.0005
R525 VDD3_3.n575 VDD3_3.n574 3.0005
R526 VDD3_3.n567 VDD3_3.n437 3.0005
R527 VDD3_3.n566 VDD3_3.n565 3.0005
R528 VDD3_3.n573 VDD3_3.n435 3.0005
R529 VDD3_3.n572 VDD3_3.n571 3.0005
R530 VDD3_3.n570 VDD3_3.n436 3.0005
R531 VDD3_3.n569 VDD3_3.n568 3.0005
R532 VDD3_3.n564 VDD3_3.n438 3.0005
R533 VDD3_3.n563 VDD3_3.n562 3.0005
R534 VDD3_3.n560 VDD3_3.n439 3.0005
R535 VDD3_3.n559 VDD3_3.n558 3.0005
R536 VDD3_3.n557 VDD3_3.n440 3.0005
R537 VDD3_3.n556 VDD3_3.n555 3.0005
R538 VDD3_3.n554 VDD3_3.n441 3.0005
R539 VDD3_3.n543 VDD3_3.n542 3.0005
R540 VDD3_3.n544 VDD3_3.n444 3.0005
R541 VDD3_3.n546 VDD3_3.n545 3.0005
R542 VDD3_3.n547 VDD3_3.n443 3.0005
R543 VDD3_3.n549 VDD3_3.n548 3.0005
R544 VDD3_3.n550 VDD3_3.n442 3.0005
R545 VDD3_3.n540 VDD3_3.n539 3.0005
R546 VDD3_3.n533 VDD3_3.n448 3.0005
R547 VDD3_3.n535 VDD3_3.n534 3.0005
R548 VDD3_3.n536 VDD3_3.n447 3.0005
R549 VDD3_3.n538 VDD3_3.n537 3.0005
R550 VDD3_3.n530 VDD3_3.n449 3.0005
R551 VDD3_3.n532 VDD3_3.n531 3.0005
R552 VDD3_3.n525 VDD3_3.n524 3.0005
R553 VDD3_3.n526 VDD3_3.n450 3.0005
R554 VDD3_3.n21 VDD3_3.n24 1.51275
R555 VDD3_3.n523 VDD3_3.n11 3.0005
R556 VDD3_3.n14 VDD3_3.n13 0.766875
R557 VDD3_3.n20 VDD3_3.n23 0.0137252
R558 VDD3_3.n511 VDD3_3.n22 3.0005
R559 VDD3_3.n512 VDD3_3.n471 3.0005
R560 VDD3_3.n514 VDD3_3.n513 3.0005
R561 VDD3_3.n510 VDD3_3.n470 3.0005
R562 VDD3_3.n508 VDD3_3.n477 3.0005
R563 VDD3_3.n314 VDD3_3.n313 3.0005
R564 VDD3_3.n315 VDD3_3.n242 3.0005
R565 VDD3_3.n312 VDD3_3.n244 3.0005
R566 VDD3_3.n8 VDD3_3.n9 0.404953
R567 VDD3_3.n16 VDD3_3.n18 0.0137252
R568 VDD3_3.n8 VDD3_3.n5 0.909842
R569 VDD3_3.n291 VDD3_3.n290 3.0005
R570 VDD3_3.n283 VDD3_3.n282 3.0005
R571 VDD3_3.n425 VDD3_3.n424 3.0005
R572 VDD3_3.n418 VDD3_3.n337 3.0005
R573 VDD3_3.n420 VDD3_3.n419 3.0005
R574 VDD3_3.n421 VDD3_3.n336 3.0005
R575 VDD3_3.n423 VDD3_3.n422 3.0005
R576 VDD3_3.n415 VDD3_3.n338 3.0005
R577 VDD3_3.n417 VDD3_3.n416 3.0005
R578 VDD3_3.n410 VDD3_3.n340 3.0005
R579 VDD3_3.n413 VDD3_3.n412 3.0005
R580 VDD3_3.n409 VDD3_3.n408 3.0005
R581 VDD3_3.n4 VDD3_3.n3 0.404953
R582 VDD3_3.n15 VDD3_3.n17 0.0137252
R583 VDD3_3.n3 VDD3_3.n0 0.909842
R584 VDD3_3.n406 VDD3_3.n405 3.0005
R585 VDD3_3.n398 VDD3_3.n368 3.0005
R586 VDD3_3.n87 VDD3_3.t188 2.91522
R587 VDD3_3.n124 VDD3_3.t185 2.91522
R588 VDD3_3.n162 VDD3_3.t182 2.91522
R589 VDD3_3.n200 VDD3_3.t179 2.91522
R590 VDD3_3.n88 VDD3_3.t189 2.83383
R591 VDD3_3.n125 VDD3_3.t186 2.83383
R592 VDD3_3.n163 VDD3_3.t183 2.83383
R593 VDD3_3.n201 VDD3_3.t180 2.83383
R594 VDD3_3.n128 VDD3_3.n127 2.8248
R595 VDD3_3.n166 VDD3_3.n165 2.8248
R596 VDD3_3.n204 VDD3_3.n203 2.8248
R597 VDD3_3.n91 VDD3_3.n90 2.82464
R598 VDD3_3.n639 VDD3_3.t55 2.77458
R599 VDD3_3.n616 VDD3_3.t39 2.54903
R600 VDD3_3.n335 VDD3_3.t193 2.54903
R601 VDD3_3.n446 VDD3_3.t50 2.54903
R602 VDD3_3 VDD3_3.t210 2.50632
R603 VDD3_3.n561 VDD3_3.t38 2.5005
R604 VDD3_3.n592 VDD3_3.t36 2.5005
R605 VDD3_3.n120 VDD3_3.t17 2.45968
R606 VDD3_3.n106 VDD3_3.t18 2.45942
R607 VDD3_3.n196 VDD3_3.t54 2.45936
R608 VDD3_3.n158 VDD3_3.t47 2.45912
R609 VDD3_3.n143 VDD3_3.t46 2.45904
R610 VDD3_3.n181 VDD3_3.t53 2.45873
R611 VDD3_3.n220 VDD3_3.t194 2.45852
R612 VDD3_3.n234 VDD3_3.t195 2.45852
R613 VDD3_3.n635 VDD3_3.n634 2.39255
R614 VDD3_3.n123 VDD3_3.n122 2.30367
R615 VDD3_3.n161 VDD3_3.n160 2.30367
R616 VDD3_3.n199 VDD3_3.n198 2.30367
R617 VDD3_3.n237 VDD3_3.n236 2.30367
R618 VDD3_3.n474 VDD3_3.n473 1.61226
R619 VDD3_3.n473 VDD3_3.n472 1.61226
R620 VDD3_3.n286 VDD3_3.n285 1.61226
R621 VDD3_3.n285 VDD3_3.n284 1.61226
R622 VDD3_3.n401 VDD3_3.n400 1.61226
R623 VDD3_3.n400 VDD3_3.n399 1.61226
R624 VDD3_3.n634 VDD3_3.n238 1.49607
R625 VDD3_3.n475 VDD3_3.n474 1.27959
R626 VDD3_3.n287 VDD3_3.n286 1.27959
R627 VDD3_3.n402 VDD3_3.n401 1.27959
R628 VDD3_3.n475 VDD3_3.n472 1.27205
R629 VDD3_3.n287 VDD3_3.n284 1.27205
R630 VDD3_3.n402 VDD3_3.n399 1.27205
R631 VDD3_3.n509 VDD3_3.n508 1.1965
R632 VDD3_3.n289 VDD3_3.n283 1.1965
R633 VDD3_3.n404 VDD3_3.n398 1.1965
R634 VDD3_3.n8 VDD3_3.n6 0.8305
R635 VDD3_3.n3 VDD3_3.n1 0.8305
R636 VDD3_3.n13 VDD3_3.n12 0.8305
R637 VDD3_3.n122 VDD3_3.n91 0.800933
R638 VDD3_3.n160 VDD3_3.n128 0.800933
R639 VDD3_3.n198 VDD3_3.n166 0.800933
R640 VDD3_3.n236 VDD3_3.n204 0.800933
R641 VDD3_3.n411 VDD3_3.n339 0.677317
R642 VDD3_3.n528 VDD3_3.n527 0.677317
R643 VDD3_3.n497 VDD3_3.n496 0.653499
R644 VDD3_3.n487 VDD3_3.n486 0.653499
R645 VDD3_3.n305 VDD3_3.n304 0.653499
R646 VDD3_3.n296 VDD3_3.n295 0.653499
R647 VDD3_3.n273 VDD3_3.n272 0.653499
R648 VDD3_3.n261 VDD3_3.n260 0.653499
R649 VDD3_3.n251 VDD3_3.n250 0.653499
R650 VDD3_3.t69 VDD3_3.n82 0.653499
R651 VDD3_3.t68 VDD3_3.n642 0.653499
R652 VDD3_3.n106 VDD3_3.n105 0.653499
R653 VDD3_3.n120 VDD3_3.n119 0.653499
R654 VDD3_3.n143 VDD3_3.n142 0.653499
R655 VDD3_3.n158 VDD3_3.n157 0.653499
R656 VDD3_3.n181 VDD3_3.n180 0.653499
R657 VDD3_3.n196 VDD3_3.n195 0.653499
R658 VDD3_3.n220 VDD3_3.n219 0.653499
R659 VDD3_3.n234 VDD3_3.n233 0.653499
R660 VDD3_3.n353 VDD3_3.n352 0.653499
R661 VDD3_3.n344 VDD3_3.n343 0.653499
R662 VDD3_3.n388 VDD3_3.n387 0.653499
R663 VDD3_3.n378 VDD3_3.n377 0.653499
R664 VDD3_3.n366 VDD3_3.n365 0.653499
R665 VDD3_3.n463 VDD3_3.n462 0.653499
R666 VDD3_3.n454 VDD3_3.n453 0.653499
R667 VDD3_3.n522 VDD3_3.n521 0.653499
R668 VDD3_3.n559 VDD3_3.n440 0.622
R669 VDD3_3.n555 VDD3_3.n440 0.606875
R670 VDD3_3.n508 VDD3_3.n506 0.5945
R671 VDD3_3.n480 VDD3_3.n477 0.5945
R672 VDD3_3.n283 VDD3_3.n253 0.5945
R673 VDD3_3.n282 VDD3_3.n281 0.5945
R674 VDD3_3.n398 VDD3_3.n397 0.5945
R675 VDD3_3.n371 VDD3_3.n368 0.5945
R676 VDD3_3.n309 VDD3_3.n306 0.534569
R677 VDD3_3.n300 VDD3_3.n297 0.534569
R678 VDD3_3.n84 VDD3_3.n83 0.534569
R679 VDD3_3.n644 VDD3_3.n643 0.534569
R680 VDD3_3.n357 VDD3_3.n354 0.534569
R681 VDD3_3.n348 VDD3_3.n345 0.534569
R682 VDD3_3.n467 VDD3_3.n464 0.534569
R683 VDD3_3.n458 VDD3_3.n455 0.534569
R684 VDD3_3.n498 VDD3_3.n494 0.53114
R685 VDD3_3.n499 VDD3_3.n482 0.53114
R686 VDD3_3.n490 VDD3_3.n481 0.53114
R687 VDD3_3.n274 VDD3_3.n270 0.53114
R688 VDD3_3.n269 VDD3_3.n255 0.53114
R689 VDD3_3.n268 VDD3_3.n267 0.53114
R690 VDD3_3.n389 VDD3_3.n385 0.53114
R691 VDD3_3.n390 VDD3_3.n373 0.53114
R692 VDD3_3.n381 VDD3_3.n372 0.53114
R693 VDD3_3.n529 VDD3_3.n528 0.519991
R694 VDD3_3.n414 VDD3_3.n339 0.519991
R695 VDD3_3.n552 VDD3_3.n551 0.51993
R696 VDD3_3.n558 VDD3_3.n557 0.4977
R697 VDD3_3.n557 VDD3_3.n556 0.4856
R698 VDD3_3.n553 VDD3_3.n552 0.443685
R699 VDD3_3.n647 VDD3_3.n640 0.428338
R700 VDD3_3.n584 VDD3_3.n329 0.413324
R701 VDD3_3.n590 VDD3_3.n327 0.392618
R702 VDD3_3.n560 VDD3_3.n559 0.391687
R703 VDD3_3.n585 VDD3_3.n584 0.370618
R704 VDD3_3.n586 VDD3_3.n327 0.368029
R705 VDD3_3.n638 VDD3_3.n123 0.358917
R706 VDD3_3.n637 VDD3_3.n161 0.358917
R707 VDD3_3.n636 VDD3_3.n199 0.358917
R708 VDD3_3.n635 VDD3_3.n237 0.358917
R709 VDD3_3.n611 VDD3_3.n319 0.358367
R710 VDD3_3.n427 VDD3_3.n426 0.358367
R711 VDD3_3.n542 VDD3_3.n541 0.358367
R712 VDD3_3.n622 VDD3_3.n317 0.357676
R713 VDD3_3.n535 VDD3_3.n448 0.357676
R714 VDD3_3.n420 VDD3_3.n337 0.357676
R715 VDD3_3.n8 VDD3_3.n7 0.3525
R716 VDD3_3.n308 VDD3_3.n7 0.3525
R717 VDD3_3.n308 VDD3_3.n307 0.3525
R718 VDD3_3.n6 VDD3_3.n293 0.3525
R719 VDD3_3.n299 VDD3_3.n293 0.3525
R720 VDD3_3.n299 VDD3_3.n298 0.3525
R721 VDD3_3.n3 VDD3_3.n2 0.3525
R722 VDD3_3.n356 VDD3_3.n2 0.3525
R723 VDD3_3.n356 VDD3_3.n355 0.3525
R724 VDD3_3.n1 VDD3_3.n341 0.3525
R725 VDD3_3.n347 VDD3_3.n341 0.3525
R726 VDD3_3.n347 VDD3_3.n346 0.3525
R727 VDD3_3.n13 VDD3_3.n10 0.3525
R728 VDD3_3.n466 VDD3_3.n10 0.3525
R729 VDD3_3.n466 VDD3_3.n465 0.3525
R730 VDD3_3.n12 VDD3_3.n451 0.3525
R731 VDD3_3.n457 VDD3_3.n451 0.3525
R732 VDD3_3.n457 VDD3_3.n456 0.3525
R733 VDD3_3.n554 VDD3_3.n553 0.347973
R734 VDD3_3.n640 VDD3_3.t19 0.342637
R735 VDD3_3.n593 VDD3_3.n325 0.337833
R736 VDD3_3.n566 VDD3_3.n438 0.337833
R737 VDD3_3.n583 VDD3_3.n582 0.330759
R738 VDD3_3.n597 VDD3_3.n325 0.325367
R739 VDD3_3.n567 VDD3_3.n566 0.325367
R740 VDD3_3.n629 VDD3_3.n241 0.318206
R741 VDD3_3.n562 VDD3_3.n560 0.314687
R742 VDD3_3.n589 VDD3_3.n588 0.314194
R743 VDD3_3.n558 VDD3_3.n439 0.31345
R744 VDD3_3.n618 VDD3_3.n317 0.306559
R745 VDD3_3.n536 VDD3_3.n535 0.306559
R746 VDD3_3.n421 VDD3_3.n420 0.306559
R747 VDD3_3.n591 VDD3_3.n590 0.301382
R748 VDD3_3.n603 VDD3_3.n323 0.300433
R749 VDD3_3.n573 VDD3_3.n572 0.300433
R750 VDD3_3.n583 VDD3_3.n328 0.296594
R751 VDD3_3.n588 VDD3_3.n587 0.294524
R752 VDD3_3.n543 VDD3_3.n445 0.286793
R753 VDD3_3.n613 VDD3_3.n612 0.286793
R754 VDD3_3.n428 VDD3_3.n334 0.286793
R755 VDD3_3.n534 VDD3_3.n533 0.286241
R756 VDD3_3.n621 VDD3_3.n620 0.286241
R757 VDD3_3.n419 VDD3_3.n418 0.286241
R758 VDD3_3.n618 VDD3_3.n617 0.285853
R759 VDD3_3.n537 VDD3_3.n536 0.285853
R760 VDD3_3.n422 VDD3_3.n421 0.285853
R761 VDD3_3.n122 VDD3_3.n121 0.281367
R762 VDD3_3.n160 VDD3_3.n159 0.281367
R763 VDD3_3.n198 VDD3_3.n197 0.281367
R764 VDD3_3.n236 VDD3_3.n235 0.281367
R765 VDD3_3.n599 VDD3_3.n598 0.279167
R766 VDD3_3.n568 VDD3_3.n436 0.279167
R767 VDD3_3.n551 VDD3_3.n441 0.278479
R768 VDD3_3.n13 VDD3_3.n11 0.277441
R769 VDD3_3.n555 VDD3_3.n554 0.270687
R770 VDD3_3.n565 VDD3_3.n564 0.270367
R771 VDD3_3.n595 VDD3_3.n594 0.270367
R772 VDD3_3.n579 VDD3_3.n578 0.268382
R773 VDD3_3.n617 VDD3_3.n616 0.267735
R774 VDD3_3.n537 VDD3_3.n446 0.267735
R775 VDD3_3.n422 VDD3_3.n335 0.267735
R776 VDD3_3.n624 VDD3_3.n623 0.262559
R777 VDD3_3.n531 VDD3_3.n530 0.262559
R778 VDD3_3.n416 VDD3_3.n415 0.262559
R779 VDD3_3.n598 VDD3_3.n597 0.261567
R780 VDD3_3.n568 VDD3_3.n567 0.261567
R781 VDD3_3.n564 VDD3_3.n563 0.260485
R782 VDD3_3.n565 VDD3_3.n437 0.260393
R783 VDD3_3.n596 VDD3_3.n595 0.260393
R784 VDD3_3.n610 VDD3_3.n609 0.2601
R785 VDD3_3.n431 VDD3_3.n333 0.2601
R786 VDD3_3.n546 VDD3_3.n444 0.2601
R787 VDD3_3.n539 VDD3_3.n538 0.259168
R788 VDD3_3.n614 VDD3_3.n318 0.259168
R789 VDD3_3.n424 VDD3_3.n423 0.259168
R790 VDD3_3.n609 VDD3_3.n321 0.256433
R791 VDD3_3.n432 VDD3_3.n431 0.256433
R792 VDD3_3.n547 VDD3_3.n546 0.256433
R793 VDD3_3.n628 VDD3_3.n627 0.254665
R794 VDD3_3.n311 VDD3_3.n306 0.253076
R795 VDD3_3.n310 VDD3_3.n309 0.253076
R796 VDD3_3.n302 VDD3_3.n297 0.253076
R797 VDD3_3.n301 VDD3_3.n300 0.253076
R798 VDD3_3.n86 VDD3_3.n83 0.253076
R799 VDD3_3.n85 VDD3_3.n84 0.253076
R800 VDD3_3.n646 VDD3_3.n643 0.253076
R801 VDD3_3.n645 VDD3_3.n644 0.253076
R802 VDD3_3.n359 VDD3_3.n354 0.253076
R803 VDD3_3.n358 VDD3_3.n357 0.253076
R804 VDD3_3.n350 VDD3_3.n345 0.253076
R805 VDD3_3.n349 VDD3_3.n348 0.253076
R806 VDD3_3.n469 VDD3_3.n464 0.253076
R807 VDD3_3.n468 VDD3_3.n467 0.253076
R808 VDD3_3.n460 VDD3_3.n455 0.253076
R809 VDD3_3.n459 VDD3_3.n458 0.253076
R810 VDD3_3.n611 VDD3_3.n610 0.252033
R811 VDD3_3.n427 VDD3_3.n333 0.252033
R812 VDD3_3.n542 VDD3_3.n444 0.252033
R813 VDD3_3.n563 VDD3_3.n439 0.25185
R814 VDD3_3.n599 VDD3_3.n323 0.248367
R815 VDD3_3.n572 VDD3_3.n436 0.248367
R816 VDD3_3.n534 VDD3_3.n447 0.245347
R817 VDD3_3.n620 VDD3_3.n619 0.245347
R818 VDD3_3.n419 VDD3_3.n336 0.245347
R819 VDD3_3.n513 VDD3_3.n510 0.24461
R820 VDD3_3.n630 VDD3_3.n629 0.243794
R821 VDD3_3.n524 VDD3_3.n450 0.241853
R822 VDD3_3.n471 VDD3_3.n22 0.241853
R823 VDD3_3.n5 VDD3_3.n16 0.389515
R824 VDD3_3.n315 VDD3_3.n314 0.241853
R825 VDD3_3.n0 VDD3_3.n15 0.389515
R826 VDD3_3.n413 VDD3_3.n340 0.241853
R827 VDD3_3.n589 VDD3_3.n326 0.241206
R828 VDD3_3.n524 VDD3_3.n523 0.240559
R829 VDD3_3.n314 VDD3_3.n244 0.240559
R830 VDD3_3.n408 VDD3_3.n340 0.240559
R831 VDD3_3.n571 VDD3_3.n435 0.240447
R832 VDD3_3.n602 VDD3_3.n601 0.240447
R833 VDD3_3.n562 VDD3_3.n561 0.239406
R834 VDD3_3.n605 VDD3_3.n604 0.237367
R835 VDD3_3.n548 VDD3_3.n442 0.237367
R836 VDD3_3.n631 VDD3_3.n630 0.236676
R837 VDD3_3.n623 VDD3_3.n622 0.230529
R838 VDD3_3.n531 VDD3_3.n448 0.230529
R839 VDD3_3.n416 VDD3_3.n337 0.230529
R840 VDD3_3.n538 VDD3_3.n447 0.228782
R841 VDD3_3.n619 VDD3_3.n318 0.228782
R842 VDD3_3.n423 VDD3_3.n336 0.228782
R843 VDD3_3.n605 VDD3_3.n321 0.2249
R844 VDD3_3.n433 VDD3_3.n432 0.2249
R845 VDD3_3.n548 VDD3_3.n547 0.2249
R846 VDD3_3.n570 VDD3_3.n569 0.223433
R847 VDD3_3.n600 VDD3_3.n324 0.223433
R848 VDD3_3.n556 VDD3_3.n441 0.21665
R849 VDD3_3.n586 VDD3_3.n585 0.215971
R850 VDD3_3.n577 VDD3_3.n330 0.214806
R851 VDD3_3.n532 VDD3_3.n449 0.210147
R852 VDD3_3.n625 VDD3_3.n243 0.210147
R853 VDD3_3.n417 VDD3_3.n338 0.210147
R854 VDD3_3.n569 VDD3_3.n437 0.209353
R855 VDD3_3.n596 VDD3_3.n324 0.209353
R856 VDD3_3.n545 VDD3_3.n544 0.20818
R857 VDD3_3.n608 VDD3_3.n320 0.20818
R858 VDD3_3.n430 VDD3_3.n429 0.20818
R859 VDD3_3.n545 VDD3_3.n443 0.205247
R860 VDD3_3.n608 VDD3_3.n607 0.205247
R861 VDD3_3.n430 VDD3_3.n332 0.205247
R862 VDD3_3.n514 VDD3_3.n471 0.203029
R863 VDD3_3.n544 VDD3_3.n543 0.201727
R864 VDD3_3.n612 VDD3_3.n320 0.201727
R865 VDD3_3.n429 VDD3_3.n428 0.201727
R866 VDD3_3.n571 VDD3_3.n570 0.198793
R867 VDD3_3.n601 VDD3_3.n600 0.198793
R868 VDD3_3.n580 VDD3_3.n579 0.197853
R869 VDD3_3.n628 VDD3_3.n240 0.195135
R870 VDD3_3.n512 VDD3_3.n511 0.193582
R871 VDD3_3.n526 VDD3_3.n525 0.193582
R872 VDD3_3.n313 VDD3_3.n242 0.193582
R873 VDD3_3.n412 VDD3_3.n410 0.193582
R874 VDD3_3.n525 VDD3_3.n11 0.192547
R875 VDD3_3.n313 VDD3_3.n312 0.192547
R876 VDD3_3.n410 VDD3_3.n409 0.192547
R877 VDD3_3.n631 VDD3_3.n239 0.191382
R878 VDD3_3.n550 VDD3_3.n549 0.189993
R879 VDD3_3.n606 VDD3_3.n322 0.189993
R880 VDD3_3.n632 VDD3_3.n240 0.189441
R881 VDD3_3.n515 VDD3_3.n514 0.187176
R882 VDD3_3.n292 VDD3_3.n5 0.388687
R883 VDD3_3.n407 VDD3_3.n0 0.388687
R884 VDD3_3.n533 VDD3_3.n532 0.184524
R885 VDD3_3.n621 VDD3_3.n243 0.184524
R886 VDD3_3.n418 VDD3_3.n417 0.184524
R887 VDD3_3.n549 VDD3_3.n443 0.18002
R888 VDD3_3.n607 VDD3_3.n606 0.18002
R889 VDD3_3.n434 VDD3_3.n332 0.18002
R890 VDD3_3.n624 VDD3_3.n316 0.1765
R891 VDD3_3.n530 VDD3_3.n529 0.1765
R892 VDD3_3.n415 VDD3_3.n414 0.1765
R893 VDD3_3.n23 VDD3_3.n22 0.175853
R894 VDD3_3.n587 VDD3_3.n328 0.172876
R895 VDD3_3.n513 VDD3_3.n512 0.162524
R896 VDD3_3.n581 VDD3_3.n330 0.158382
R897 VDD3_3.n594 VDD3_3.n326 0.157036
R898 VDD3_3.n505 VDD3_3.n479 0.15538
R899 VDD3_3.n498 VDD3_3.n478 0.15538
R900 VDD3_3.n494 VDD3_3.n493 0.15538
R901 VDD3_3.n493 VDD3_3.n483 0.15538
R902 VDD3_3.n488 VDD3_3.n483 0.15538
R903 VDD3_3.n500 VDD3_3.n499 0.15538
R904 VDD3_3.n492 VDD3_3.n482 0.15538
R905 VDD3_3.n492 VDD3_3.n484 0.15538
R906 VDD3_3.n501 VDD3_3.n481 0.15538
R907 VDD3_3.n491 VDD3_3.n490 0.15538
R908 VDD3_3.n279 VDD3_3.n278 0.15538
R909 VDD3_3.n275 VDD3_3.n274 0.15538
R910 VDD3_3.n270 VDD3_3.n257 0.15538
R911 VDD3_3.n263 VDD3_3.n257 0.15538
R912 VDD3_3.n263 VDD3_3.n262 0.15538
R913 VDD3_3.n276 VDD3_3.n255 0.15538
R914 VDD3_3.n269 VDD3_3.n258 0.15538
R915 VDD3_3.n264 VDD3_3.n258 0.15538
R916 VDD3_3.n267 VDD3_3.n256 0.15538
R917 VDD3_3.n268 VDD3_3.n266 0.15538
R918 VDD3_3.t62 VDD3_3.t66 0.15538
R919 VDD3_3.t62 VDD3_3.t58 0.15538
R920 VDD3_3.n647 VDD3_3.t59 0.15538
R921 VDD3_3.t61 VDD3_3.t59 0.15538
R922 VDD3_3.t61 VDD3_3.t56 0.15538
R923 VDD3_3.n396 VDD3_3.n370 0.15538
R924 VDD3_3.n389 VDD3_3.n369 0.15538
R925 VDD3_3.n385 VDD3_3.n384 0.15538
R926 VDD3_3.n384 VDD3_3.n374 0.15538
R927 VDD3_3.n379 VDD3_3.n374 0.15538
R928 VDD3_3.n391 VDD3_3.n390 0.15538
R929 VDD3_3.n383 VDD3_3.n373 0.15538
R930 VDD3_3.n383 VDD3_3.n375 0.15538
R931 VDD3_3.n392 VDD3_3.n372 0.15538
R932 VDD3_3.n382 VDD3_3.n381 0.15538
R933 VDD3_3.n633 VDD3_3.n632 0.153206
R934 VDD3_3.n239 VDD3_3.n238 0.152559
R935 VDD3_3.n527 VDD3_3.n449 0.1413
R936 VDD3_3.n626 VDD3_3.n625 0.1413
R937 VDD3_3.n411 VDD3_3.n338 0.1413
R938 VDD3_3.n511 VDD3_3.n19 0.140782
R939 VDD3_3.n507 VDD3_3.n470 0.136562
R940 VDD3_3.n291 VDD3_3.n252 0.136562
R941 VDD3_3.n406 VDD3_3.n367 0.136562
R942 VDD3_3.n23 VDD3_3.n21 0.140209
R943 VDD3_3.n515 VDD3_3.n470 0.118962
R944 VDD3_3.n292 VDD3_3.n291 0.118962
R945 VDD3_3.n407 VDD3_3.n406 0.118962
R946 VDD3_3.n592 VDD3_3.n591 0.112118
R947 VDD3_3.n510 VDD3_3.n509 0.109349
R948 VDD3_3.n290 VDD3_3.n289 0.109349
R949 VDD3_3.n405 VDD3_3.n404 0.109349
R950 VDD3_3.n578 VDD3_3.n331 0.0962647
R951 VDD3_3.n476 VDD3_3.n475 0.0939154
R952 VDD3_3.n288 VDD3_3.n287 0.0939154
R953 VDD3_3.n403 VDD3_3.n402 0.0939154
R954 VDD3_3.n316 VDD3_3.n241 0.0936765
R955 VDD3_3.n561 VDD3_3.n438 0.086575
R956 VDD3_3.n593 VDD3_3.n592 0.0845529
R957 VDD3_3.n88 VDD3_3.n87 0.0818851
R958 VDD3_3.n125 VDD3_3.n124 0.0818851
R959 VDD3_3.n163 VDD3_3.n162 0.0818851
R960 VDD3_3.n201 VDD3_3.n200 0.0818851
R961 VDD3_3.n506 VDD3_3.n478 0.07926
R962 VDD3_3.n500 VDD3_3.n480 0.07926
R963 VDD3_3.n502 VDD3_3.n501 0.07926
R964 VDD3_3.n275 VDD3_3.n253 0.07926
R965 VDD3_3.n281 VDD3_3.n276 0.07926
R966 VDD3_3.n256 VDD3_3.n254 0.07926
R967 VDD3_3.n397 VDD3_3.n369 0.07926
R968 VDD3_3.n391 VDD3_3.n371 0.07926
R969 VDD3_3.n393 VDD3_3.n392 0.07926
R970 VDD3_3.n634 VDD3_3.n633 0.0775361
R971 VDD3_3.n489 VDD3_3.n484 0.0771299
R972 VDD3_3.n504 VDD3_3.n503 0.0771299
R973 VDD3_3.n265 VDD3_3.n264 0.0771299
R974 VDD3_3.n280 VDD3_3.n277 0.0771299
R975 VDD3_3.n395 VDD3_3.n394 0.0771299
R976 VDD3_3.n380 VDD3_3.n375 0.0771299
R977 VDD3_3.n577 VDD3_3.n576 0.0771118
R978 VDD3_3.n506 VDD3_3.n505 0.07662
R979 VDD3_3.n504 VDD3_3.n480 0.07662
R980 VDD3_3.n279 VDD3_3.n253 0.07662
R981 VDD3_3.n281 VDD3_3.n280 0.07662
R982 VDD3_3.n397 VDD3_3.n396 0.07662
R983 VDD3_3.n395 VDD3_3.n371 0.07662
R984 VDD3_3.n627 VDD3_3.n626 0.0750412
R985 VDD3_3.n580 VDD3_3.n329 0.0742647
R986 VDD3_3.n582 VDD3_3.n581 0.0595118
R987 VDD3_3.n433 VDD3_3.n331 0.0569667
R988 VDD3_3.n616 VDD3_3.n615 0.0566
R989 VDD3_3.n540 VDD3_3.n446 0.0566
R990 VDD3_3.n425 VDD3_3.n335 0.0566
R991 VDD3_3.n615 VDD3_3.n319 0.0562333
R992 VDD3_3.n574 VDD3_3.n331 0.0562333
R993 VDD3_3.n541 VDD3_3.n540 0.0562333
R994 VDD3_3.n426 VDD3_3.n425 0.0562333
R995 VDD3_3.n529 VDD3_3.n450 0.0555
R996 VDD3_3.n316 VDD3_3.n315 0.0555
R997 VDD3_3.n414 VDD3_3.n413 0.0555
R998 VDD3_3.n523 VDD3_3.n14 0.632159
R999 VDD3_3.n244 VDD3_3.n9 0.789716
R1000 VDD3_3.n408 VDD3_3.n4 0.789716
R1001 VDD3_3.n507 VDD3_3.n476 0.0512692
R1002 VDD3_3.n496 VDD3_3.n25 0.0512692
R1003 VDD3_3.n486 VDD3_3.n29 0.0512692
R1004 VDD3_3.n304 VDD3_3.n35 0.0512692
R1005 VDD3_3.n295 VDD3_3.n39 0.0512692
R1006 VDD3_3.n272 VDD3_3.n41 0.0512692
R1007 VDD3_3.n260 VDD3_3.n45 0.0512692
R1008 VDD3_3.n288 VDD3_3.n252 0.0512692
R1009 VDD3_3.n250 VDD3_3.n245 0.0512692
R1010 VDD3_3.n82 VDD3_3.n51 0.0512692
R1011 VDD3_3.n642 VDD3_3.n55 0.0512692
R1012 VDD3_3.n105 VDD3_3.n92 0.0512692
R1013 VDD3_3.n119 VDD3_3.n107 0.0512692
R1014 VDD3_3.n142 VDD3_3.n129 0.0512692
R1015 VDD3_3.n157 VDD3_3.n144 0.0512692
R1016 VDD3_3.n180 VDD3_3.n167 0.0512692
R1017 VDD3_3.n195 VDD3_3.n182 0.0512692
R1018 VDD3_3.n219 VDD3_3.n205 0.0512692
R1019 VDD3_3.n233 VDD3_3.n221 0.0512692
R1020 VDD3_3.n352 VDD3_3.n59 0.0512692
R1021 VDD3_3.n343 VDD3_3.n63 0.0512692
R1022 VDD3_3.n387 VDD3_3.n65 0.0512692
R1023 VDD3_3.n377 VDD3_3.n69 0.0512692
R1024 VDD3_3.n403 VDD3_3.n367 0.0512692
R1025 VDD3_3.n365 VDD3_3.n360 0.0512692
R1026 VDD3_3.n462 VDD3_3.n75 0.0512692
R1027 VDD3_3.n453 VDD3_3.n79 0.0512692
R1028 VDD3_3.n521 VDD3_3.n516 0.0512692
R1029 VDD3_3.n576 VDD3_3.n434 0.0456733
R1030 VDD3_3.n539 VDD3_3.n445 0.0450867
R1031 VDD3_3.n576 VDD3_3.n575 0.0450867
R1032 VDD3_3.n614 VDD3_3.n613 0.0450867
R1033 VDD3_3.n424 VDD3_3.n334 0.0450867
R1034 VDD3_3.n527 VDD3_3.n526 0.0445
R1035 VDD3_3.n626 VDD3_3.n242 0.0445
R1036 VDD3_3.n412 VDD3_3.n411 0.0445
R1037 VDD3_3.n248 VDD3_3.n247 0.0437551
R1038 VDD3_3.n247 VDD3_3.n246 0.0437551
R1039 VDD3_3.n363 VDD3_3.n362 0.0437551
R1040 VDD3_3.n362 VDD3_3.n361 0.0437551
R1041 VDD3_3.n519 VDD3_3.n518 0.0437551
R1042 VDD3_3.n518 VDD3_3.n517 0.0437551
R1043 VDD3_3.n103 VDD3_3.n102 0.0405896
R1044 VDD3_3.n100 VDD3_3.n97 0.0405896
R1045 VDD3_3.n99 VDD3_3.n96 0.0405896
R1046 VDD3_3.n103 VDD3_3.n93 0.0405896
R1047 VDD3_3.n102 VDD3_3.n97 0.0405896
R1048 VDD3_3.n100 VDD3_3.n96 0.0405896
R1049 VDD3_3.n98 VDD3_3.n94 0.0405896
R1050 VDD3_3.n114 VDD3_3.n111 0.0405896
R1051 VDD3_3.n116 VDD3_3.n110 0.0405896
R1052 VDD3_3.n111 VDD3_3.n108 0.0405896
R1053 VDD3_3.n114 VDD3_3.n112 0.0405896
R1054 VDD3_3.n115 VDD3_3.n112 0.0405896
R1055 VDD3_3.n115 VDD3_3.n110 0.0405896
R1056 VDD3_3.n117 VDD3_3.n116 0.0405896
R1057 VDD3_3.n117 VDD3_3.n113 0.0405896
R1058 VDD3_3.n113 VDD3_3.n109 0.0405896
R1059 VDD3_3.n134 VDD3_3.n130 0.0405896
R1060 VDD3_3.n133 VDD3_3.n132 0.0405896
R1061 VDD3_3.n140 VDD3_3.n130 0.0405896
R1062 VDD3_3.n139 VDD3_3.n138 0.0405896
R1063 VDD3_3.n139 VDD3_3.n137 0.0405896
R1064 VDD3_3.n137 VDD3_3.n133 0.0405896
R1065 VDD3_3.n132 VDD3_3.n131 0.0405896
R1066 VDD3_3.n155 VDD3_3.n154 0.0405896
R1067 VDD3_3.n151 VDD3_3.n149 0.0405896
R1068 VDD3_3.n150 VDD3_3.n148 0.0405896
R1069 VDD3_3.n153 VDD3_3.n146 0.0405896
R1070 VDD3_3.n155 VDD3_3.n145 0.0405896
R1071 VDD3_3.n154 VDD3_3.n149 0.0405896
R1072 VDD3_3.n151 VDD3_3.n148 0.0405896
R1073 VDD3_3.n178 VDD3_3.n177 0.0405896
R1074 VDD3_3.n174 VDD3_3.n172 0.0405896
R1075 VDD3_3.n176 VDD3_3.n170 0.0405896
R1076 VDD3_3.n178 VDD3_3.n168 0.0405896
R1077 VDD3_3.n177 VDD3_3.n172 0.0405896
R1078 VDD3_3.n176 VDD3_3.n169 0.0405896
R1079 VDD3_3.n173 VDD3_3.n169 0.0405896
R1080 VDD3_3.n192 VDD3_3.n187 0.0405896
R1081 VDD3_3.n189 VDD3_3.n186 0.0405896
R1082 VDD3_3.n187 VDD3_3.n183 0.0405896
R1083 VDD3_3.n193 VDD3_3.n192 0.0405896
R1084 VDD3_3.n193 VDD3_3.n188 0.0405896
R1085 VDD3_3.n188 VDD3_3.n186 0.0405896
R1086 VDD3_3.n189 VDD3_3.n185 0.0405896
R1087 VDD3_3.n214 VDD3_3.n213 0.0405896
R1088 VDD3_3.n212 VDD3_3.n211 0.0405896
R1089 VDD3_3.n208 VDD3_3.n207 0.0405896
R1090 VDD3_3.n217 VDD3_3.n206 0.0405896
R1091 VDD3_3.n213 VDD3_3.n212 0.0405896
R1092 VDD3_3.n229 VDD3_3.n225 0.0405896
R1093 VDD3_3.n228 VDD3_3.n224 0.0405896
R1094 VDD3_3.n231 VDD3_3.n230 0.0405896
R1095 VDD3_3.n225 VDD3_3.n222 0.0405896
R1096 VDD3_3.n229 VDD3_3.n224 0.0405896
R1097 VDD3_3.n228 VDD3_3.n226 0.0405896
R1098 VDD3_3.n230 VDD3_3.n226 0.0405896
R1099 VDD3_3.n231 VDD3_3.n227 0.0405896
R1100 VDD3_3.n227 VDD3_3.n223 0.0405896
R1101 VDD3_3.n101 VDD3_3.n95 0.0396346
R1102 VDD3_3.n136 VDD3_3.n135 0.0396346
R1103 VDD3_3.n152 VDD3_3.n147 0.0396346
R1104 VDD3_3.n175 VDD3_3.n171 0.0396346
R1105 VDD3_3.n190 VDD3_3.n184 0.0396346
R1106 VDD3_3.n216 VDD3_3.n215 0.0396346
R1107 VDD3_3.n210 VDD3_3.n209 0.0396346
R1108 VDD3_3.n604 VDD3_3.n603 0.0393667
R1109 VDD3_3.n574 VDD3_3.n573 0.0393667
R1110 VDD3_3.n26 VDD3_3.n495 0.056333
R1111 VDD3_3.n30 VDD3_3.n485 0.056333
R1112 VDD3_3.n36 VDD3_3.n303 0.056333
R1113 VDD3_3.n40 VDD3_3.n294 0.056333
R1114 VDD3_3.n42 VDD3_3.n271 0.056333
R1115 VDD3_3.n46 VDD3_3.n259 0.056333
R1116 VDD3_3.n50 VDD3_3.n81 0.056333
R1117 VDD3_3.n54 VDD3_3.n641 0.056333
R1118 VDD3_3.n60 VDD3_3.n351 0.056333
R1119 VDD3_3.n64 VDD3_3.n342 0.056333
R1120 VDD3_3.n66 VDD3_3.n386 0.056333
R1121 VDD3_3.n70 VDD3_3.n376 0.056333
R1122 VDD3_3.n76 VDD3_3.n461 0.056333
R1123 VDD3_3.n80 VDD3_3.n452 0.056333
R1124 VDD3_3.n238 VDD3_3 0.0373824
R1125 VDD3_3.n553 VDD3_3.n442 0.0335
R1126 VDD3_3.n575 VDD3_3.n435 0.0315933
R1127 VDD3_3.n602 VDD3_3.n322 0.0315933
R1128 VDD3_3.n551 VDD3_3.n550 0.0269
R1129 VDD3_3.n14 VDD3_3.n21 0.590525
R1130 VDD3_3.n249 VDD3_3.n248 0.0221276
R1131 VDD3_3.n246 VDD3_3.n245 0.0221276
R1132 VDD3_3.n364 VDD3_3.n363 0.0221276
R1133 VDD3_3.n361 VDD3_3.n360 0.0221276
R1134 VDD3_3.n520 VDD3_3.n519 0.0221276
R1135 VDD3_3.n517 VDD3_3.n516 0.0221276
R1136 VDD3_3.n101 VDD3_3.n94 0.0205448
R1137 VDD3_3.n98 VDD3_3.n92 0.0205448
R1138 VDD3_3.n104 VDD3_3.n93 0.0205448
R1139 VDD3_3.n99 VDD3_3.n95 0.0205448
R1140 VDD3_3.n109 VDD3_3.n107 0.0205448
R1141 VDD3_3.n118 VDD3_3.n108 0.0205448
R1142 VDD3_3.n141 VDD3_3.n140 0.0205448
R1143 VDD3_3.n131 VDD3_3.n129 0.0205448
R1144 VDD3_3.n138 VDD3_3.n136 0.0205448
R1145 VDD3_3.n135 VDD3_3.n134 0.0205448
R1146 VDD3_3.n152 VDD3_3.n146 0.0205448
R1147 VDD3_3.n156 VDD3_3.n145 0.0205448
R1148 VDD3_3.n150 VDD3_3.n147 0.0205448
R1149 VDD3_3.n153 VDD3_3.n144 0.0205448
R1150 VDD3_3.n175 VDD3_3.n170 0.0205448
R1151 VDD3_3.n179 VDD3_3.n168 0.0205448
R1152 VDD3_3.n173 VDD3_3.n167 0.0205448
R1153 VDD3_3.n174 VDD3_3.n171 0.0205448
R1154 VDD3_3.n190 VDD3_3.n185 0.0205448
R1155 VDD3_3.n194 VDD3_3.n183 0.0205448
R1156 VDD3_3.n191 VDD3_3.n184 0.0205448
R1157 VDD3_3.n191 VDD3_3.n182 0.0205448
R1158 VDD3_3.n218 VDD3_3.n217 0.0205448
R1159 VDD3_3.n209 VDD3_3.n208 0.0205448
R1160 VDD3_3.n216 VDD3_3.n206 0.0205448
R1161 VDD3_3.n215 VDD3_3.n214 0.0205448
R1162 VDD3_3.n211 VDD3_3.n210 0.0205448
R1163 VDD3_3.n207 VDD3_3.n205 0.0205448
R1164 VDD3_3.n223 VDD3_3.n221 0.0205448
R1165 VDD3_3.n232 VDD3_3.n222 0.0205448
R1166 VDD3_3.n91 VDD3_3.t40 2.17574
R1167 VDD3_3.n128 VDD3_3.t45 2.17574
R1168 VDD3_3.n166 VDD3_3.t49 2.17574
R1169 VDD3_3.n204 VDD3_3.t42 2.17574
R1170 VDD3_3.n24 VDD3_3.n19 0.162006
R1171 VDD3_3.t19 VDD3_3.t66 0.11226
R1172 VDD3_3.n78 VDD3_3.n452 0.056333
R1173 VDD3_3.n74 VDD3_3.n461 0.056333
R1174 VDD3_3.n376 VDD3_3.n72 0.056333
R1175 VDD3_3.n386 VDD3_3.n68 0.056333
R1176 VDD3_3.n62 VDD3_3.n342 0.056333
R1177 VDD3_3.n58 VDD3_3.n351 0.056333
R1178 VDD3_3.n56 VDD3_3.n641 0.056333
R1179 VDD3_3.n52 VDD3_3.n81 0.056333
R1180 VDD3_3.n259 VDD3_3.n48 0.056333
R1181 VDD3_3.n271 VDD3_3.n44 0.056333
R1182 VDD3_3.n38 VDD3_3.n294 0.056333
R1183 VDD3_3.n34 VDD3_3.n303 0.056333
R1184 VDD3_3.n485 VDD3_3.n32 0.056333
R1185 VDD3_3.n495 VDD3_3.n28 0.056333
R1186 VDD3_3.t20 VDD3_3.n17 8.89267
R1187 VDD3_3.t21 VDD3_3.n18 8.89267
R1188 VDD3_3.n20 VDD3_3.t0 8.89267
R1189 VDD3_3.n312 VDD3_3.n8 1.15308
R1190 VDD3_3.n409 VDD3_3.n3 1.15308
R1191 VDD3_3.n405 VDD3_3.n3 1.10494
R1192 VDD3_3.n290 VDD3_3.n8 1.10494
R1193 VDD3_3.n24 VDD3_3.n13 1.07957
R1194 VSS.n1480 VSS.n1479 177837
R1195 VSS.n862 VSS.t245 177237
R1196 VSS.n1271 VSS.t246 53990.7
R1197 VSS.n1272 VSS.n1271 38678.6
R1198 VSS.n1273 VSS.n574 30227.5
R1199 VSS.n1276 VSS.n571 25941
R1200 VSS.n68 VSS.n836 18093.2
R1201 VSS.n23 VSS.n1191 17635
R1202 VSS.n620 VSS.n265 17615.4
R1203 VSS.n1271 VSS.n574 15966.8
R1204 VSS.n1003 VSS.t285 12114.1
R1205 VSS.n1272 VSS.n575 11497.7
R1206 VSS.n1469 VSS.n411 10509.8
R1207 VSS.n1275 VSS.n572 9605.42
R1208 VSS.n1480 VSS.t47 7467.59
R1209 VSS.n1610 VSS.t342 7403.48
R1210 VSS.n1470 VSS.t119 7226.03
R1211 VSS.n1270 VSS.n576 6676.29
R1212 VSS.t243 VSS.n579 6009.75
R1213 VSS.t273 VSS.n1611 6009.75
R1214 VSS.n1267 VSS.t374 6009.43
R1215 VSS.n1276 VSS.n1275 5868.73
R1216 VSS.t49 VSS.n570 5823.8
R1217 VSS.n572 VSS.n570 5245.48
R1218 VSS.n1463 VSS.t378 4511.45
R1219 VSS.n496 VSS.t379 4511.45
R1220 VSS.n712 VSS.t380 4511.45
R1221 VSS.t331 VSS.t442 4376.03
R1222 VSS.t385 VSS.t331 4376.03
R1223 VSS.t402 VSS.t242 4376.03
R1224 VSS.t333 VSS.t402 4376.03
R1225 VSS.t371 VSS.t251 4376.03
R1226 VSS.t2 VSS.t371 4376.03
R1227 VSS.t337 VSS.t419 4376.03
R1228 VSS.t409 VSS.t337 4376.03
R1229 VSS.n715 VSS.t285 4226.62
R1230 VSS.t246 VSS.t49 4111.45
R1231 VSS.n65 VSS.n64 0.0010001
R1232 VSS.n1265 VSS.n677 3904.73
R1233 VSS.n1269 VSS.t409 3870.19
R1234 VSS.n1463 VSS.t404 3778.63
R1235 VSS.n496 VSS.t377 3778.63
R1236 VSS.n712 VSS.t34 3778.63
R1237 VSS.t251 VSS.n1266 3662.49
R1238 VSS.t419 VSS.n1268 3662.49
R1239 VSS.t442 VSS.n130 3658.76
R1240 VSS.n1467 VSS.n1462 3281.25
R1241 VSS.n710 VSS.n709 3281.25
R1242 VSS.n1331 VSS.n498 3281.25
R1243 VSS.n1464 VSS.n1463 3250
R1244 VSS.n497 VSS.n496 3250
R1245 VSS.n713 VSS.n712 3250
R1246 VSS.n862 VSS.n861 3248.16
R1247 VSS.n1462 VSS.t349 3203.12
R1248 VSS.n709 VSS.t440 3203.12
R1249 VSS.n498 VSS.t29 3203.12
R1250 VSS.n1466 VSS.t344 2866.4
R1251 VSS.n1332 VSS.t397 2866.4
R1252 VSS.n1004 VSS.t252 2866.4
R1253 VSS.n579 VSS.t385 2755.65
R1254 VSS.n1611 VSS.t333 2755.65
R1255 VSS.n1267 VSS.t2 2755.65
R1256 VSS.t100 VSS.t233 2697.04
R1257 VSS.t240 VSS.t391 2697.04
R1258 VSS.n1005 VSS.t127 2573.12
R1259 VSS.n17 VSS.n1572 2561.84
R1260 VSS.n345 VSS.n344 2561.75
R1261 VSS.n36 VSS.n1574 2561.84
R1262 VSS.t119 VSS.t420 2500
R1263 VSS.t436 VSS.t6 2500
R1264 VSS.n861 VSS.n65 2497.58
R1265 VSS.n1610 VSS.t406 2477.67
R1266 VSS.n1275 VSS.n1274 2397.37
R1267 VSS.n866 VSS.n865 2257.84
R1268 VSS.n1573 VSS.n17 2251.52
R1269 VSS.n184 VSS.n181 2251.5
R1270 VSS.t242 VSS.n1610 2241.14
R1271 VSS.n1488 VSS.t100 2238.92
R1272 VSS.n710 VSS.t437 2191.9
R1273 VSS.n711 VSS.t142 2165.18
R1274 VSS.n1462 VSS.t346 2056.03
R1275 VSS.n709 VSS.t254 2056.03
R1276 VSS.n498 VSS.t399 2056.03
R1277 VSS.n1274 VSS.n573 2052.15
R1278 VSS.n1274 VSS.n1273 1982.06
R1279 VSS.n1469 VSS.n1468 1858.59
R1280 VSS.n1467 VSS.t351 1687.5
R1281 VSS.n710 VSS.t438 1687.5
R1282 VSS.n1331 VSS.t31 1687.5
R1283 VSS.n1330 VSS.n499 1637.33
R1284 VSS.t395 VSS.t400 1587.91
R1285 VSS.n1270 VSS.n575 1540.92
R1286 VSS.n1464 VSS.t403 1524.29
R1287 VSS.n497 VSS.t376 1524.29
R1288 VSS.n713 VSS.t33 1524.29
R1289 VSS.n711 VSS.n571 1462.71
R1290 VSS.n344 VSS.n54 1375.97
R1291 VSS.n65 VSS.n1568 2251.5
R1292 VSS.n1489 VSS.n1488 1365.69
R1293 VSS.n1462 VSS.t115 1325.43
R1294 VSS.n709 VSS.t146 1325.43
R1295 VSS.n498 VSS.t134 1325.43
R1296 VSS.n156 VSS.n38 1304.94
R1297 VSS.t233 VSS.t235 1300.49
R1298 VSS.t235 VSS.t237 1300.49
R1299 VSS.t237 VSS.t238 1300.49
R1300 VSS.t238 VSS.t240 1300.49
R1301 VSS.n1276 VSS.n570 1255.09
R1302 VSS.n1609 VSS.n1608 1250.06
R1303 VSS.n1569 VSS.n265 1218.96
R1304 VSS.n1191 VSS.n183 1218.96
R1305 VSS.n17 VSS.n29 8.24331
R1306 VSS.n1470 VSS.n1469 1212.33
R1307 VSS.t420 VSS.t431 1205.48
R1308 VSS.t431 VSS.t433 1205.48
R1309 VSS.t433 VSS.t434 1205.48
R1310 VSS.t434 VSS.t436 1205.48
R1311 VSS.n577 VSS.n575 1194.78
R1312 VSS.t48 VSS.n1003 1082.19
R1313 VSS.t334 VSS.t205 1077.97
R1314 VSS.t416 VSS.t334 1077.97
R1315 VSS.t386 VSS.t209 1077.97
R1316 VSS.t418 VSS.t386 1077.97
R1317 VSS.t213 VSS.t3 1077.97
R1318 VSS.t3 VSS.t417 1077.97
R1319 VSS.t217 VSS.t410 1077.97
R1320 VSS.t410 VSS.t415 1077.97
R1321 VSS.t275 VSS.t138 1077.76
R1322 VSS.t8 VSS.t232 1021.88
R1323 VSS.n1266 VSS.n1265 1018.03
R1324 VSS.t430 VSS.t35 1016.04
R1325 VSS.t342 VSS.n1609 1015.53
R1326 VSS.t374 VSS.n265 996.332
R1327 VSS.n1191 VSS.t243 996.332
R1328 VSS.n1612 VSS.t273 996.332
R1329 VSS.n864 VSS.n715 984.803
R1330 VSS.n1263 VSS.t416 974.145
R1331 VSS.n1265 VSS.t418 974.145
R1332 VSS.t417 VSS.n578 974.145
R1333 VSS.n864 VSS.t255 968.885
R1334 VSS.n866 VSS.t138 946.813
R1335 VSS.t400 VSS.n863 897.702
R1336 VSS.n1268 VSS.n578 857.787
R1337 VSS.n1263 VSS.n130 857.149
R1338 VSS.n1271 VSS.n1270 783.172
R1339 VSS.n3 VSS.n27 773.753
R1340 VSS.n1132 VSS.n577 754.476
R1341 VSS.n838 VSS.n576 750
R1342 VSS.t390 VSS.t8 740.625
R1343 VSS.t35 VSS.t5 740.625
R1344 VSS.n1570 VSS.n51 740.119
R1345 VSS.n574 VSS.n573 735.609
R1346 VSS.t44 VSS.t48 734.202
R1347 VSS.n715 VSS.t45 696.888
R1348 VSS.t209 VSS.t388 683.428
R1349 VSS.t412 VSS.t213 683.428
R1350 VSS.t222 VSS.t217 683.428
R1351 VSS.n865 VSS.n499 682.087
R1352 VSS.n717 VSS.n59 680.643
R1353 VSS.n573 VSS.n572 638.889
R1354 VSS.t348 VSS.t93 610.428
R1355 VSS.t108 VSS.t28 610.428
R1356 VSS.t415 VSS.n1132 609.534
R1357 VSS.t42 VSS.n1477 588.636
R1358 VSS.n715 VSS.t291 584.646
R1359 VSS.t142 VSS.n710 570.423
R1360 VSS.t205 VSS.n95 557.538
R1361 VSS.n1488 VSS.t0 548.976
R1362 VSS.t286 VSS.t275 519.686
R1363 VSS.t288 VSS.t286 519.686
R1364 VSS.t289 VSS.t288 519.686
R1365 VSS.t291 VSS.t289 519.686
R1366 VSS.n864 VSS.t395 500.726
R1367 VSS.t36 VSS.t470 496.382
R1368 VSS.n1611 VSS.n130 482.61
R1369 VSS.n1268 VSS.n1267 480.745
R1370 VSS.n1266 VSS.n579 478.882
R1371 VSS.t470 VSS.t42 475.634
R1372 VSS.n1480 VSS.t328 426.495
R1373 VSS.n1270 VSS.t332 417.55
R1374 VSS.n1273 VSS.n1272 404.317
R1375 VSS.t9 VSS.n346 399.659
R1376 VSS.t332 VSS.n1269 390.899
R1377 VSS.t328 VSS.n156 388.154
R1378 VSS.n1608 VSS.n38 377.529
R1379 VSS.n1265 VSS.t412 364.007
R1380 VSS.n1568 VSS.n345 344.829
R1381 VSS.n1572 VSS.n181 344.829
R1382 VSS.n1574 VSS.n1573 344.829
R1383 VSS.n1333 VSS.t405 335.329
R1384 VSS.n1002 VSS.t241 335.329
R1385 VSS.n1568 VSS.n1567 319.584
R1386 VSS.n1479 VSS.n181 319.584
R1387 VSS.n1573 VSS.n156 319.584
R1388 VSS.n409 VSS.t43 294.844
R1389 VSS.n1478 VSS.n1470 288.854
R1390 VSS.n1133 VSS.n578 273.541
R1391 VSS.n1269 VSS.n577 248.031
R1392 VSS.n620 VSS.n51 234.345
R1393 VSS.t93 VSS.n1466 221.25
R1394 VSS.n1332 VSS.t108 221.25
R1395 VSS.t127 VSS.n1004 219.332
R1396 VSS.n1264 VSS.n1263 218.573
R1397 VSS.n1478 VSS.t36 217.067
R1398 VSS.n836 VSS.n717 216.871
R1399 VSS.t250 VSS.t9 212.918
R1400 VSS.t327 VSS.t326 203.157
R1401 VSS.n1468 VSS.t104 191.167
R1402 VSS.t123 VSS.n1330 191.167
R1403 VSS.n1467 VSS.t348 189.326
R1404 VSS.t28 VSS.n1331 189.326
R1405 VSS.n1566 VSS.t154 176.208
R1406 VSS.n1489 VSS.n409 175.138
R1407 VSS.t224 VSS.t81 171.095
R1408 VSS.t232 VSS.t231 171.095
R1409 VSS.t85 VSS.t422 166.516
R1410 VSS.t429 VSS.t430 166.516
R1411 VSS.t277 VSS.t89 166.516
R1412 VSS.t81 VSS.n1465 154.138
R1413 VSS.t51 VSS.t327 151.642
R1414 VSS.t326 VSS.t384 151.642
R1415 VSS.n1474 VSS.t154 150.671
R1416 VSS.n1333 VSS.t85 150.108
R1417 VSS.t89 VSS.n1002 150.108
R1418 VSS.t245 VSS.t78 130.88
R1419 VSS.t372 VSS.t373 129.298
R1420 VSS.t241 VSS.n499 123.175
R1421 VSS.t0 VSS.t347 122.951
R1422 VSS.n1466 VSS.t390 118.126
R1423 VSS.t5 VSS.n1332 118.126
R1424 VSS.n1004 VSS.t44 117.1
R1425 VSS.t388 VSS.n1264 115.968
R1426 VSS.n865 VSS.n864 104.37
R1427 VSS.t373 VSS.t443 96.5103
R1428 VSS.t382 VSS.t372 96.5103
R1429 VSS.t406 VSS.n95 96.4238
R1430 VSS.n20 VSS.n23 5.4211
R1431 VSS.n1003 VSS.t284 90.7852
R1432 VSS.n621 VSS.n620 88.7698
R1433 VSS.n836 VSS.n835 82.8923
R1434 VSS.t226 VSS.t224 82.5005
R1435 VSS.t228 VSS.t226 82.5005
R1436 VSS.t229 VSS.t228 82.5005
R1437 VSS.t231 VSS.t229 82.5005
R1438 VSS.t422 VSS.t424 80.2925
R1439 VSS.t424 VSS.t426 80.2925
R1440 VSS.t426 VSS.t427 80.2925
R1441 VSS.t427 VSS.t429 80.2925
R1442 VSS.t279 VSS.t277 80.2925
R1443 VSS.t281 VSS.t279 80.2925
R1444 VSS.t282 VSS.t281 80.2925
R1445 VSS.t284 VSS.t282 80.2925
R1446 VSS.t408 VSS.t255 76.8597
R1447 VSS.t383 VSS.t408 74.7824
R1448 VSS.t68 VSS.t69 73.1206
R1449 VSS.t66 VSS.t65 73.1206
R1450 VSS.t65 VSS.t63 73.1206
R1451 VSS.t63 VSS.t62 73.1206
R1452 VSS.t62 VSS.t60 73.1206
R1453 VSS.t60 VSS.t59 73.1206
R1454 VSS.t59 VSS.t57 73.1206
R1455 VSS.t57 VSS.t56 73.1206
R1456 VSS.t56 VSS.t54 73.1206
R1457 VSS.t54 VSS.t53 73.1206
R1458 VSS.t53 VSS.t51 73.1206
R1459 VSS.t384 VSS.t383 73.1206
R1460 VSS.n36 VSS.n38 71.5847
R1461 VSS.t75 VSS.t340 68.966
R1462 VSS.t77 VSS.n1280 67.7197
R1463 VSS.n737 VSS.n327 67.0812
R1464 VSS.n1246 VSS.n1178 67.0812
R1465 VSS.n1589 VSS.n122 67.0812
R1466 VSS.n635 VSS.n250 67.0812
R1467 VSS.n863 VSS.t68 66.4733
R1468 VSS.n1281 VSS.t338 66.0578
R1469 VSS.t71 VSS.t158 63.5651
R1470 VSS.n1133 VSS.t222 61.6105
R1471 VSS.n1469 VSS.t405 56.1136
R1472 VSS.t69 VSS.t393 53.5942
R1473 VSS.n1465 VSS.n409 49.6077
R1474 VSS.t104 VSS.n1467 49.2706
R1475 VSS.n1331 VSS.t123 49.2706
R1476 VSS.t347 VSS.t248 48.9164
R1477 VSS.n756 VSS.n343 48.4477
R1478 VSS.n722 VSS.n342 48.4477
R1479 VSS.n723 VSS.n341 48.4477
R1480 VSS.n724 VSS.n340 48.4477
R1481 VSS.n726 VSS.n338 48.4477
R1482 VSS.n727 VSS.n337 48.4477
R1483 VSS.n728 VSS.n336 48.4477
R1484 VSS.n729 VSS.n335 48.4477
R1485 VSS.n731 VSS.n333 48.4477
R1486 VSS.n732 VSS.n332 48.4477
R1487 VSS.n733 VSS.n331 48.4477
R1488 VSS.n734 VSS.n330 48.4477
R1489 VSS.n736 VSS.n328 48.4477
R1490 VSS.n20 VSS.n19 1.28785
R1491 VSS.n1257 VSS.n1167 48.4477
R1492 VSS.n1256 VSS.n1168 48.4477
R1493 VSS.n1255 VSS.n1169 48.4477
R1494 VSS.n1254 VSS.n1170 48.4477
R1495 VSS.n1252 VSS.n1172 48.4477
R1496 VSS.n1251 VSS.n1173 48.4477
R1497 VSS.n1250 VSS.n1174 48.4477
R1498 VSS.n1249 VSS.n1175 48.4477
R1499 VSS.n1247 VSS.n1177 48.4477
R1500 VSS.n1607 VSS.n1606 48.4477
R1501 VSS.n1605 VSS.n1604 48.4477
R1502 VSS.n1603 VSS.n115 48.4477
R1503 VSS.n1602 VSS.n114 48.4477
R1504 VSS.n1600 VSS.n113 48.4477
R1505 VSS.n1599 VSS.n117 48.4477
R1506 VSS.n1598 VSS.n112 48.4477
R1507 VSS.n1597 VSS.n118 48.4477
R1508 VSS.n1595 VSS.n119 48.4477
R1509 VSS.n1594 VSS.n110 48.4477
R1510 VSS.n1593 VSS.n120 48.4477
R1511 VSS.n1592 VSS.n109 48.4477
R1512 VSS.n1590 VSS.n108 48.4477
R1513 VSS.n655 VSS.n234 48.4477
R1514 VSS.n650 VSS.n235 48.4477
R1515 VSS.n649 VSS.n236 48.4477
R1516 VSS.n648 VSS.n237 48.4477
R1517 VSS.n646 VSS.n239 48.4477
R1518 VSS.n645 VSS.n240 48.4477
R1519 VSS.n644 VSS.n241 48.4477
R1520 VSS.n643 VSS.n242 48.4477
R1521 VSS.n641 VSS.n244 48.4477
R1522 VSS.n640 VSS.n245 48.4477
R1523 VSS.n639 VSS.n246 48.4477
R1524 VSS.n638 VSS.n247 48.4477
R1525 VSS.n636 VSS.n249 48.4477
R1526 VSS.t72 VSS.n567 47.7778
R1527 VSS.t248 VSS.t381 47.5944
R1528 VSS.t460 VSS.t461 46.5367
R1529 VSS.t458 VSS.t460 46.5367
R1530 VSS.t457 VSS.t458 46.5367
R1531 VSS.t455 VSS.t457 46.5367
R1532 VSS.t454 VSS.t455 46.5367
R1533 VSS.t452 VSS.t454 46.5367
R1534 VSS.t451 VSS.t452 46.5367
R1535 VSS.t449 VSS.t451 46.5367
R1536 VSS.t448 VSS.t449 46.5367
R1537 VSS.t446 VSS.t448 46.5367
R1538 VSS.t443 VSS.t445 46.5367
R1539 VSS.t381 VSS.t382 46.5367
R1540 VSS.t467 VSS.t40 43.8926
R1541 VSS.t469 VSS.n1484 43.0994
R1542 VSS.n1485 VSS.t38 42.0417
R1543 VSS.n738 VSS.n326 40.9943
R1544 VSS.n739 VSS.n325 40.9943
R1545 VSS.n741 VSS.n323 40.9943
R1546 VSS.n742 VSS.n322 40.9943
R1547 VSS.n743 VSS.n321 40.9943
R1548 VSS.n744 VSS.n320 40.9943
R1549 VSS.n746 VSS.n318 40.9943
R1550 VSS.n747 VSS.n317 40.9943
R1551 VSS.n748 VSS.n316 40.9943
R1552 VSS.n750 VSS.n315 40.9943
R1553 VSS.n1245 VSS.n1179 40.9943
R1554 VSS.n1244 VSS.n1180 40.9943
R1555 VSS.n1242 VSS.n1182 40.9943
R1556 VSS.n1241 VSS.n1183 40.9943
R1557 VSS.n1240 VSS.n1184 40.9943
R1558 VSS.n1239 VSS.n1185 40.9943
R1559 VSS.n1237 VSS.n1187 40.9943
R1560 VSS.n1236 VSS.n1188 40.9943
R1561 VSS.n1235 VSS.n1189 40.9943
R1562 VSS.n1234 VSS.n1190 40.9943
R1563 VSS.n1588 VSS.n107 40.9943
R1564 VSS.n1587 VSS.n123 40.9943
R1565 VSS.n1585 VSS.n124 40.9943
R1566 VSS.n1584 VSS.n105 40.9943
R1567 VSS.n1583 VSS.n125 40.9943
R1568 VSS.n1582 VSS.n104 40.9943
R1569 VSS.n1580 VSS.n103 40.9943
R1570 VSS.n1579 VSS.n127 40.9943
R1571 VSS.n1578 VSS.n102 40.9943
R1572 VSS.n1577 VSS.n128 40.9943
R1573 VSS.n634 VSS.n251 40.9943
R1574 VSS.n633 VSS.n252 40.9943
R1575 VSS.n631 VSS.n254 40.9943
R1576 VSS.n630 VSS.n255 40.9943
R1577 VSS.n629 VSS.n256 40.9943
R1578 VSS.n628 VSS.n257 40.9943
R1579 VSS.n626 VSS.n259 40.9943
R1580 VSS.n625 VSS.n260 40.9943
R1581 VSS.n624 VSS.n261 40.9943
R1582 VSS.n623 VSS.n262 40.9943
R1583 VSS.t445 VSS.t414 40.9841
R1584 VSS.t463 VSS.t150 40.4553
R1585 VSS.t261 VSS.n324 39.1309
R1586 VSS.t360 VSS.n1181 39.1309
R1587 VSS.n1586 VSS.t316 39.1309
R1588 VSS.t299 VSS.n253 39.1309
R1589 VSS.n1479 VSS.n1478 36.3912
R1590 VSS.t78 VSS.t250 36.072
R1591 VSS.n863 VSS.n862 36.0328
R1592 VSS.t263 VSS.n319 35.4042
R1593 VSS.t362 VSS.n1186 35.4042
R1594 VSS.n1581 VSS.t312 35.4042
R1595 VSS.t295 VSS.n258 35.4042
R1596 VSS.t461 VSS.t220 34.1094
R1597 VSS.t256 VSS.n339 31.6775
R1598 VSS.t353 VSS.n1166 31.6775
R1599 VSS.n1259 VSS.t181 31.6775
R1600 VSS.n1601 VSS.t309 31.6775
R1601 VSS.n1576 VSS.t173 31.6775
R1602 VSS.t292 VSS.n238 31.6775
R1603 VSS.t189 VSS.n263 31.6775
R1604 VSS.n801 VSS.t268 30.7923
R1605 VSS.n783 VSS.t258 30.7923
R1606 VSS.n1205 VSS.t355 30.7923
R1607 VSS.n1226 VSS.t357 30.7923
R1608 VSS.n99 VSS.t319 30.7923
R1609 VSS.n96 VSS.t311 30.7923
R1610 VSS.n611 VSS.t302 30.7923
R1611 VSS.n593 VSS.t294 30.7923
R1612 VSS.t464 VSS.n1487 30.4077
R1613 VSS.n803 VSS.t272 30.3719
R1614 VSS.n802 VSS.t270 30.3719
R1615 VSS.n801 VSS.t266 30.3719
R1616 VSS.n785 VSS.t264 30.3719
R1617 VSS.n784 VSS.t262 30.3719
R1618 VSS.n783 VSS.t260 30.3719
R1619 VSS.n1207 VSS.t365 30.3719
R1620 VSS.n1206 VSS.t369 30.3719
R1621 VSS.n1205 VSS.t367 30.3719
R1622 VSS.n1228 VSS.t363 30.3719
R1623 VSS.n1227 VSS.t361 30.3719
R1624 VSS.n1226 VSS.t359 30.3719
R1625 VSS.n101 VSS.t325 30.3719
R1626 VSS.n100 VSS.t323 30.3719
R1627 VSS.n99 VSS.t321 30.3719
R1628 VSS.n98 VSS.t313 30.3719
R1629 VSS.n97 VSS.t317 30.3719
R1630 VSS.n96 VSS.t315 30.3719
R1631 VSS.n613 VSS.t308 30.3719
R1632 VSS.n612 VSS.t306 30.3719
R1633 VSS.n611 VSS.t304 30.3719
R1634 VSS.n595 VSS.t296 30.3719
R1635 VSS.n594 VSS.t300 30.3719
R1636 VSS.n593 VSS.t298 30.3719
R1637 VSS.n1612 VSS.n17 28.8703
R1638 VSS.n1609 VSS.n32 29.7763
R1639 VSS.n61 VSS.n265 29.7763
R1640 VSS.n1191 VSS.n232 29.7754
R1641 VSS.n1606 VSS.n32 28.8447
R1642 VSS.n655 VSS.n232 28.8447
R1643 VSS.n756 VSS.n61 28.8436
R1644 VSS.n368 VSS.n367 28.0665
R1645 VSS.n561 VSS.n560 28.0665
R1646 VSS.n474 VSS.n473 28.0665
R1647 VSS.t257 VSS.n334 27.9508
R1648 VSS.t356 VSS.n1171 27.9508
R1649 VSS.n1596 VSS.t310 27.9508
R1650 VSS.t293 VSS.n243 27.9508
R1651 VSS.n804 VSS.n803 27.4209
R1652 VSS.n786 VSS.n785 27.4209
R1653 VSS.n1208 VSS.n1207 27.4209
R1654 VSS.n1229 VSS.n1228 27.4209
R1655 VSS.n9 VSS.n101 27.4209
R1656 VSS.n16 VSS.n98 27.4209
R1657 VSS.n614 VSS.n613 27.4209
R1658 VSS.n596 VSS.n595 27.4209
R1659 VSS.n1277 VSS.t341 25.7587
R1660 VSS.n1278 VSS.n1277 25.7587
R1661 VSS.n1280 VSS.n568 25.7587
R1662 VSS.t162 VSS.n1480 25.6483
R1663 VSS.n345 VSS.n266 25.3955
R1664 VSS.n1572 VSS.n1571 25.3955
R1665 VSS.n1574 VSS.n30 25.3955
R1666 VSS.t74 VSS.n567 25.3433
R1667 VSS.n1138 VSS.n1137 25.1353
R1668 VSS.n1149 VSS.n1148 25.1071
R1669 VSS.n1164 VSS.n1163 25.1064
R1670 VSS.n1619 VSS.n1618 25.0184
R1671 VSS.t259 VSS.n329 24.2241
R1672 VSS.t358 VSS.n1176 24.2241
R1673 VSS.n1591 VSS.t314 24.2241
R1674 VSS.t297 VSS.n248 24.2241
R1675 VSS.n738 VSS.n327 22.3607
R1676 VSS.n739 VSS.n326 22.3607
R1677 VSS.n741 VSS.n324 22.3607
R1678 VSS.n742 VSS.n323 22.3607
R1679 VSS.n743 VSS.n322 22.3607
R1680 VSS.n744 VSS.n321 22.3607
R1681 VSS.n745 VSS.n320 22.3607
R1682 VSS.n746 VSS.n319 22.3607
R1683 VSS.n747 VSS.n318 22.3607
R1684 VSS.n748 VSS.n317 22.3607
R1685 VSS.n750 VSS.n316 22.3607
R1686 VSS.n1245 VSS.n1178 22.3607
R1687 VSS.n1244 VSS.n1179 22.3607
R1688 VSS.n1242 VSS.n1181 22.3607
R1689 VSS.n1241 VSS.n1182 22.3607
R1690 VSS.n1240 VSS.n1183 22.3607
R1691 VSS.n1239 VSS.n1184 22.3607
R1692 VSS.n1238 VSS.n1185 22.3607
R1693 VSS.n1237 VSS.n1186 22.3607
R1694 VSS.n1236 VSS.n1187 22.3607
R1695 VSS.n1235 VSS.n1188 22.3607
R1696 VSS.n1234 VSS.n1189 22.3607
R1697 VSS.n1258 VSS.n1190 22.3607
R1698 VSS.n1589 VSS.n107 22.3607
R1699 VSS.n1588 VSS.n123 22.3607
R1700 VSS.n1586 VSS.n124 22.3607
R1701 VSS.n1585 VSS.n105 22.3607
R1702 VSS.n1584 VSS.n125 22.3607
R1703 VSS.n1583 VSS.n104 22.3607
R1704 VSS.n1582 VSS.n126 22.3607
R1705 VSS.n1581 VSS.n103 22.3607
R1706 VSS.n1580 VSS.n127 22.3607
R1707 VSS.n1579 VSS.n102 22.3607
R1708 VSS.n1578 VSS.n128 22.3607
R1709 VSS.n1577 VSS.n129 22.3607
R1710 VSS.n634 VSS.n250 22.3607
R1711 VSS.n633 VSS.n251 22.3607
R1712 VSS.n631 VSS.n253 22.3607
R1713 VSS.n630 VSS.n254 22.3607
R1714 VSS.n629 VSS.n255 22.3607
R1715 VSS.n628 VSS.n256 22.3607
R1716 VSS.n627 VSS.n257 22.3607
R1717 VSS.n626 VSS.n258 22.3607
R1718 VSS.n625 VSS.n259 22.3607
R1719 VSS.n624 VSS.n260 22.3607
R1720 VSS.n623 VSS.n261 22.3607
R1721 VSS.n622 VSS.n262 22.3607
R1722 VSS.n54 VSS.n184 22.1791
R1723 VSS.n861 VSS.n576 21.9441
R1724 VSS.n290 VSS.n289 21.6013
R1725 VSS.n289 VSS.n288 21.6013
R1726 VSS.n207 VSS.n206 21.6013
R1727 VSS.n206 VSS.n205 21.6013
R1728 VSS.n168 VSS.n144 21.6013
R1729 VSS.n167 VSS.n144 21.6013
R1730 VSS.n735 VSS.t265 21.4291
R1731 VSS.t269 VSS.n325 21.4291
R1732 VSS.n1248 VSS.t366 21.4291
R1733 VSS.t368 VSS.n1180 21.4291
R1734 VSS.t320 VSS.n121 21.4291
R1735 VSS.n1587 VSS.t322 21.4291
R1736 VSS.n637 VSS.t303 21.4291
R1737 VSS.t305 VSS.n252 21.4291
R1738 VSS.n310 VSS.n309 21.3762
R1739 VSS.n308 VSS.n307 21.3762
R1740 VSS.n302 VSS.n301 21.3762
R1741 VSS.n296 VSS.n295 21.3762
R1742 VSS.n288 VSS.n287 21.3762
R1743 VSS.n284 VSS.n283 21.3762
R1744 VSS.n280 VSS.n279 21.3762
R1745 VSS.n278 VSS.n277 21.3762
R1746 VSS.n276 VSS.n275 21.3762
R1747 VSS.n272 VSS.n271 21.3762
R1748 VSS.n314 VSS.n57 22.8866
R1749 VSS.n314 VSS.n313 21.3762
R1750 VSS.n313 VSS.n312 21.3762
R1751 VSS.n312 VSS.n311 21.3762
R1752 VSS.n311 VSS.n310 21.3762
R1753 VSS.n309 VSS.n308 21.3762
R1754 VSS.n307 VSS.n306 21.3762
R1755 VSS.n306 VSS.n305 21.3762
R1756 VSS.n305 VSS.n304 21.3762
R1757 VSS.n304 VSS.n303 21.3762
R1758 VSS.n303 VSS.n302 21.3762
R1759 VSS.n301 VSS.n300 21.3762
R1760 VSS.n300 VSS.n299 21.3762
R1761 VSS.n299 VSS.n298 21.3762
R1762 VSS.n298 VSS.n297 21.3762
R1763 VSS.n297 VSS.n296 21.3762
R1764 VSS.n295 VSS.n294 21.3762
R1765 VSS.n294 VSS.n293 21.3762
R1766 VSS.n293 VSS.n292 21.3762
R1767 VSS.n292 VSS.n291 21.3762
R1768 VSS.n291 VSS.n290 21.3762
R1769 VSS.n287 VSS.n286 21.3762
R1770 VSS.n286 VSS.n285 21.3762
R1771 VSS.n285 VSS.n284 21.3762
R1772 VSS.n283 VSS.n282 21.3762
R1773 VSS.n282 VSS.n281 21.3762
R1774 VSS.n281 VSS.n280 21.3762
R1775 VSS.n279 VSS.n278 21.3762
R1776 VSS.n277 VSS.n276 21.3762
R1777 VSS.n275 VSS.n274 21.3762
R1778 VSS.n274 VSS.n273 21.3762
R1779 VSS.n273 VSS.n272 21.3762
R1780 VSS.n271 VSS.n270 21.3762
R1781 VSS.n270 VSS.n269 21.3762
R1782 VSS.n269 VSS.n268 21.3762
R1783 VSS.n268 VSS.n267 21.3762
R1784 VSS.n231 VSS.n230 21.3762
R1785 VSS.n229 VSS.n228 21.3762
R1786 VSS.n225 VSS.n224 21.3762
R1787 VSS.n223 VSS.n222 21.3762
R1788 VSS.n219 VSS.n218 21.3762
R1789 VSS.n217 VSS.n216 21.3762
R1790 VSS.n213 VSS.n212 21.3762
R1791 VSS.n211 VSS.n210 21.3762
R1792 VSS.n209 VSS.n208 21.3762
R1793 VSS.n195 VSS.n194 21.3762
R1794 VSS.n189 VSS.n188 21.3762
R1795 VSS.n187 VSS.n186 21.3762
R1796 VSS.n231 VSS.n31 22.8866
R1797 VSS.n230 VSS.n229 21.3762
R1798 VSS.n228 VSS.n227 21.3762
R1799 VSS.n227 VSS.n226 21.3762
R1800 VSS.n226 VSS.n225 21.3762
R1801 VSS.n224 VSS.n223 21.3762
R1802 VSS.n222 VSS.n221 21.3762
R1803 VSS.n221 VSS.n220 21.3762
R1804 VSS.n220 VSS.n219 21.3762
R1805 VSS.n218 VSS.n217 21.3762
R1806 VSS.n216 VSS.n215 21.3762
R1807 VSS.n215 VSS.n214 21.3762
R1808 VSS.n214 VSS.n213 21.3762
R1809 VSS.n212 VSS.n211 21.3762
R1810 VSS.n210 VSS.n209 21.3762
R1811 VSS.n208 VSS.n207 21.3762
R1812 VSS.n205 VSS.n204 21.3762
R1813 VSS.n204 VSS.n203 21.3762
R1814 VSS.n203 VSS.n202 21.3762
R1815 VSS.n202 VSS.n201 21.3762
R1816 VSS.n201 VSS.n200 21.3762
R1817 VSS.n200 VSS.n199 21.3762
R1818 VSS.n199 VSS.n198 21.3762
R1819 VSS.n198 VSS.n197 21.3762
R1820 VSS.n197 VSS.n196 21.3762
R1821 VSS.n196 VSS.n195 21.3762
R1822 VSS.n194 VSS.n193 21.3762
R1823 VSS.n193 VSS.n192 21.3762
R1824 VSS.n192 VSS.n191 21.3762
R1825 VSS.n191 VSS.n190 21.3762
R1826 VSS.n190 VSS.n189 21.3762
R1827 VSS.n188 VSS.n187 21.3762
R1828 VSS.n186 VSS.n185 21.3762
R1829 VSS.n185 VSS.n182 21.3762
R1830 VSS.n180 VSS.n132 21.3762
R1831 VSS.n179 VSS.n133 21.3762
R1832 VSS.n177 VSS.n135 21.3762
R1833 VSS.n176 VSS.n136 21.3762
R1834 VSS.n175 VSS.n137 21.3762
R1835 VSS.n174 VSS.n138 21.3762
R1836 VSS.n173 VSS.n139 21.3762
R1837 VSS.n172 VSS.n140 21.3762
R1838 VSS.n171 VSS.n141 21.3762
R1839 VSS.n170 VSS.n142 21.3762
R1840 VSS.n169 VSS.n143 21.3762
R1841 VSS.n167 VSS.n145 21.3762
R1842 VSS.n166 VSS.n146 21.3762
R1843 VSS.n165 VSS.n147 21.3762
R1844 VSS.n164 VSS.n148 21.3762
R1845 VSS.n162 VSS.n150 21.3762
R1846 VSS.n161 VSS.n151 21.3762
R1847 VSS.n160 VSS.n152 21.3762
R1848 VSS.n159 VSS.n153 21.3762
R1849 VSS.n157 VSS.n155 21.3762
R1850 VSS.n180 VSS.n131 21.3762
R1851 VSS.n179 VSS.n132 21.3762
R1852 VSS.n178 VSS.n133 21.3762
R1853 VSS.n178 VSS.n134 21.3762
R1854 VSS.n177 VSS.n134 21.3762
R1855 VSS.n176 VSS.n135 21.3762
R1856 VSS.n175 VSS.n136 21.3762
R1857 VSS.n174 VSS.n137 21.3762
R1858 VSS.n173 VSS.n138 21.3762
R1859 VSS.n172 VSS.n139 21.3762
R1860 VSS.n171 VSS.n140 21.3762
R1861 VSS.n170 VSS.n141 21.3762
R1862 VSS.n169 VSS.n142 21.3762
R1863 VSS.n168 VSS.n143 21.3762
R1864 VSS.n166 VSS.n145 21.3762
R1865 VSS.n165 VSS.n146 21.3762
R1866 VSS.n164 VSS.n147 21.3762
R1867 VSS.n163 VSS.n148 21.3762
R1868 VSS.n163 VSS.n149 21.3762
R1869 VSS.n162 VSS.n149 21.3762
R1870 VSS.n161 VSS.n150 21.3762
R1871 VSS.n160 VSS.n151 21.3762
R1872 VSS.n159 VSS.n152 21.3762
R1873 VSS.n158 VSS.n153 21.3762
R1874 VSS.n158 VSS.n154 21.3762
R1875 VSS.n157 VSS.n154 21.3762
R1876 VSS.n836 VSS.t201 19.5657
R1877 VSS.t393 VSS.t71 19.5269
R1878 VSS.n1013 VSS.n1012 18.5263
R1879 VSS.n507 VSS.n506 18.5263
R1880 VSS.n419 VSS.n418 18.5263
R1881 VSS.n1013 VSS.n1009 18.0005
R1882 VSS.n1017 VSS.n1016 18.0005
R1883 VSS.n507 VSS.n503 18.0005
R1884 VSS.n1326 VSS.n1325 18.0005
R1885 VSS.n1321 VSS.n1320 18.0005
R1886 VSS.n419 VSS.n415 18.0005
R1887 VSS.n1458 VSS.n1457 18.0005
R1888 VSS.n1453 VSS.n1452 18.0005
R1889 VSS.n1024 VSS.n1022 18.0005
R1890 VSS.n730 VSS.t267 17.7024
R1891 VSS.n1253 VSS.t354 17.7024
R1892 VSS.t318 VSS.n111 17.7024
R1893 VSS.n642 VSS.t301 17.7024
R1894 VSS.n1012 VSS.t441 17.2621
R1895 VSS.n1009 VSS.t439 17.2621
R1896 VSS.n1016 VSS.t253 17.2621
R1897 VSS.n506 VSS.t30 17.2621
R1898 VSS.n503 VSS.t32 17.2621
R1899 VSS.n1325 VSS.t398 17.2621
R1900 VSS.n418 VSS.t350 17.2621
R1901 VSS.n415 VSS.t352 17.2621
R1902 VSS.n1457 VSS.t345 17.2621
R1903 VSS.n64 VSS.n266 17.0005
R1904 VSS.n1010 VSS.t148 17.0005
R1905 VSS.n1010 VSS.t147 17.0005
R1906 VSS.n1007 VSS.t144 17.0005
R1907 VSS.n1007 VSS.t143 17.0005
R1908 VSS.n1014 VSS.t129 17.0005
R1909 VSS.n1014 VSS.t128 17.0005
R1910 VSS.t167 VSS.n541 17.0005
R1911 VSS.n544 VSS.t166 17.0005
R1912 VSS.n504 VSS.t136 17.0005
R1913 VSS.n504 VSS.t135 17.0005
R1914 VSS.n501 VSS.t125 17.0005
R1915 VSS.n501 VSS.t124 17.0005
R1916 VSS.n1323 VSS.t110 17.0005
R1917 VSS.n1323 VSS.t109 17.0005
R1918 VSS.n1318 VSS.t113 17.0005
R1919 VSS.t113 VSS.n1316 17.0005
R1920 VSS.t164 VSS.n1420 17.0005
R1921 VSS.n1423 VSS.t163 17.0005
R1922 VSS.n416 VSS.t117 17.0005
R1923 VSS.n416 VSS.t116 17.0005
R1924 VSS.n413 VSS.t106 17.0005
R1925 VSS.n413 VSS.t105 17.0005
R1926 VSS.n1455 VSS.t95 17.0005
R1927 VSS.n1455 VSS.t94 17.0005
R1928 VSS.n1450 VSS.t98 17.0005
R1929 VSS.t98 VSS.n1448 17.0005
R1930 VSS.n365 VSS.t152 17.0005
R1931 VSS.t151 VSS.n362 17.0005
R1932 VSS.n834 VSS.n833 17.0005
R1933 VSS.n833 VSS.n750 17.0005
R1934 VSS.n833 VSS.n748 17.0005
R1935 VSS.n833 VSS.n747 17.0005
R1936 VSS.n833 VSS.n746 17.0005
R1937 VSS.n833 VSS.n745 17.0005
R1938 VSS.n833 VSS.n744 17.0005
R1939 VSS.n833 VSS.n743 17.0005
R1940 VSS.n833 VSS.n742 17.0005
R1941 VSS.n833 VSS.n741 17.0005
R1942 VSS.n833 VSS.n740 17.0005
R1943 VSS.n833 VSS.n739 17.0005
R1944 VSS.n833 VSS.n738 17.0005
R1945 VSS.n833 VSS.n737 17.0005
R1946 VSS.n833 VSS.n736 17.0005
R1947 VSS.n833 VSS.n735 17.0005
R1948 VSS.n833 VSS.n734 17.0005
R1949 VSS.n833 VSS.n733 17.0005
R1950 VSS.n833 VSS.n732 17.0005
R1951 VSS.n833 VSS.n731 17.0005
R1952 VSS.n833 VSS.n730 17.0005
R1953 VSS.n833 VSS.n729 17.0005
R1954 VSS.n833 VSS.n728 17.0005
R1955 VSS.n833 VSS.n727 17.0005
R1956 VSS.n833 VSS.n726 17.0005
R1957 VSS.n833 VSS.n725 17.0005
R1958 VSS.n833 VSS.n724 17.0005
R1959 VSS.n833 VSS.n723 17.0005
R1960 VSS.n833 VSS.n722 17.0005
R1961 VSS.n793 VSS.n718 17.0005
R1962 VSS.n796 VSS.n718 17.0005
R1963 VSS.n799 VSS.n718 17.0005
R1964 VSS.n798 VSS.n718 17.0005
R1965 VSS.n806 VSS.n718 17.0005
R1966 VSS.n805 VSS.n718 17.0005
R1967 VSS.n775 VSS.n718 17.0005
R1968 VSS.n778 VSS.n718 17.0005
R1969 VSS.n781 VSS.n718 17.0005
R1970 VSS.n780 VSS.n718 17.0005
R1971 VSS.n788 VSS.n718 17.0005
R1972 VSS.n787 VSS.n718 17.0005
R1973 VSS.n774 VSS.n718 17.0005
R1974 VSS.n750 VSS.n718 17.0005
R1975 VSS.n790 VSS.t199 17.0005
R1976 VSS.t199 VSS.n779 17.0005
R1977 VSS.t199 VSS.n777 17.0005
R1978 VSS.t199 VSS.n782 17.0005
R1979 VSS.t199 VSS.n776 17.0005
R1980 VSS.t199 VSS.n789 17.0005
R1981 VSS.n790 VSS.t198 17.0005
R1982 VSS.n779 VSS.t198 17.0005
R1983 VSS.n777 VSS.t198 17.0005
R1984 VSS.n782 VSS.t198 17.0005
R1985 VSS.n776 VSS.t198 17.0005
R1986 VSS.n789 VSS.t198 17.0005
R1987 VSS.n808 VSS.t203 17.0005
R1988 VSS.t203 VSS.n797 17.0005
R1989 VSS.t203 VSS.n795 17.0005
R1990 VSS.t203 VSS.n800 17.0005
R1991 VSS.t203 VSS.n794 17.0005
R1992 VSS.t203 VSS.n807 17.0005
R1993 VSS.n808 VSS.t202 17.0005
R1994 VSS.n797 VSS.t202 17.0005
R1995 VSS.n795 VSS.t202 17.0005
R1996 VSS.n800 VSS.t202 17.0005
R1997 VSS.n794 VSS.t202 17.0005
R1998 VSS.n807 VSS.t202 17.0005
R1999 VSS.n748 VSS.n718 17.0005
R2000 VSS.n747 VSS.n718 17.0005
R2001 VSS.n746 VSS.n718 17.0005
R2002 VSS.n745 VSS.n718 17.0005
R2003 VSS.n744 VSS.n718 17.0005
R2004 VSS.n743 VSS.n718 17.0005
R2005 VSS.n742 VSS.n718 17.0005
R2006 VSS.n741 VSS.n718 17.0005
R2007 VSS.n740 VSS.n718 17.0005
R2008 VSS.n739 VSS.n718 17.0005
R2009 VSS.n738 VSS.n718 17.0005
R2010 VSS.n737 VSS.n718 17.0005
R2011 VSS.n736 VSS.n718 17.0005
R2012 VSS.n735 VSS.n718 17.0005
R2013 VSS.n734 VSS.n718 17.0005
R2014 VSS.n733 VSS.n718 17.0005
R2015 VSS.n732 VSS.n718 17.0005
R2016 VSS.n731 VSS.n718 17.0005
R2017 VSS.n730 VSS.n718 17.0005
R2018 VSS.n729 VSS.n718 17.0005
R2019 VSS.n728 VSS.n718 17.0005
R2020 VSS.n727 VSS.n718 17.0005
R2021 VSS.n726 VSS.n718 17.0005
R2022 VSS.n725 VSS.n718 17.0005
R2023 VSS.n724 VSS.n718 17.0005
R2024 VSS.n723 VSS.n718 17.0005
R2025 VSS.n722 VSS.n718 17.0005
R2026 VSS.n64 VSS.n315 17.0005
R2027 VSS.n64 VSS.n316 17.0005
R2028 VSS.n64 VSS.n317 17.0005
R2029 VSS.n64 VSS.n318 17.0005
R2030 VSS.n64 VSS.n319 17.0005
R2031 VSS.n64 VSS.n320 17.0005
R2032 VSS.n64 VSS.n321 17.0005
R2033 VSS.n64 VSS.n322 17.0005
R2034 VSS.n64 VSS.n323 17.0005
R2035 VSS.n64 VSS.n324 17.0005
R2036 VSS.n64 VSS.n325 17.0005
R2037 VSS.n64 VSS.n326 17.0005
R2038 VSS.n64 VSS.n327 17.0005
R2039 VSS.n64 VSS.n328 17.0005
R2040 VSS.n64 VSS.n329 17.0005
R2041 VSS.n64 VSS.n330 17.0005
R2042 VSS.n64 VSS.n331 17.0005
R2043 VSS.n64 VSS.n332 17.0005
R2044 VSS.n64 VSS.n333 17.0005
R2045 VSS.n64 VSS.n334 17.0005
R2046 VSS.n64 VSS.n335 17.0005
R2047 VSS.n64 VSS.n336 17.0005
R2048 VSS.n64 VSS.n337 17.0005
R2049 VSS.n64 VSS.n338 17.0005
R2050 VSS.n64 VSS.n339 17.0005
R2051 VSS.n64 VSS.n340 17.0005
R2052 VSS.n64 VSS.n341 17.0005
R2053 VSS.n64 VSS.n342 17.0005
R2054 VSS.n64 VSS.n343 17.0005
R2055 VSS.n1571 VSS.n1570 17.0005
R2056 VSS.n17 VSS.n30 17.0005
R2057 VSS.n17 VSS.n1259 17.0005
R2058 VSS.n17 VSS.n1190 17.0005
R2059 VSS.n17 VSS.n1189 17.0005
R2060 VSS.n17 VSS.n1188 17.0005
R2061 VSS.n17 VSS.n1187 17.0005
R2062 VSS.n17 VSS.n1186 17.0005
R2063 VSS.n17 VSS.n1185 17.0005
R2064 VSS.n17 VSS.n1184 17.0005
R2065 VSS.n17 VSS.n1183 17.0005
R2066 VSS.n17 VSS.n1182 17.0005
R2067 VSS.n17 VSS.n1181 17.0005
R2068 VSS.n17 VSS.n1180 17.0005
R2069 VSS.n17 VSS.n1179 17.0005
R2070 VSS.n17 VSS.n1178 17.0005
R2071 VSS.n17 VSS.n1177 17.0005
R2072 VSS.n17 VSS.n1176 17.0005
R2073 VSS.n17 VSS.n1175 17.0005
R2074 VSS.n17 VSS.n1174 17.0005
R2075 VSS.n17 VSS.n1173 17.0005
R2076 VSS.n17 VSS.n1172 17.0005
R2077 VSS.n17 VSS.n1171 17.0005
R2078 VSS.n17 VSS.n1170 17.0005
R2079 VSS.n17 VSS.n1169 17.0005
R2080 VSS.n17 VSS.n1168 17.0005
R2081 VSS.n17 VSS.n1167 17.0005
R2082 VSS.n17 VSS.n1166 17.0005
R2083 VSS.n23 VSS.n1259 24.7741
R2084 VSS.n1258 VSS.n20 8.50075
R2085 VSS.n1234 VSS.n20 17.0005
R2086 VSS.n1235 VSS.n20 17.0005
R2087 VSS.n1236 VSS.n20 17.0005
R2088 VSS.n1237 VSS.n20 17.0005
R2089 VSS.n1238 VSS.n20 17.0005
R2090 VSS.n1239 VSS.n20 17.0005
R2091 VSS.n1240 VSS.n20 17.0005
R2092 VSS.n1241 VSS.n20 17.0005
R2093 VSS.n1242 VSS.n20 17.0005
R2094 VSS.n1243 VSS.n21 8.50189
R2095 VSS.n1244 VSS.n20 8.49553
R2096 VSS.n1245 VSS.n20 8.49577
R2097 VSS.n1246 VSS.n20 8.49602
R2098 VSS.n1247 VSS.n20 8.49975
R2099 VSS.n1248 VSS.n20 8.49627
R2100 VSS.n1249 VSS.n20 8.49651
R2101 VSS.n1250 VSS.n20 8.49676
R2102 VSS.n1251 VSS.n20 8.49701
R2103 VSS.n1252 VSS.n20 8.49726
R2104 VSS.n1253 VSS.n20 8.49751
R2105 VSS.n1254 VSS.n20 8.49776
R2106 VSS.n1255 VSS.n20 8.49801
R2107 VSS.n1256 VSS.n20 8.49825
R2108 VSS.n1257 VSS.n20 8.4985
R2109 VSS.n24 VSS.n1234 17.0005
R2110 VSS.n24 VSS.n1235 17.0005
R2111 VSS.n24 VSS.n1236 17.0005
R2112 VSS.n24 VSS.n1237 17.0005
R2113 VSS.n24 VSS.n1238 17.0005
R2114 VSS.n24 VSS.n1239 17.0005
R2115 VSS.n24 VSS.n1240 17.0005
R2116 VSS.n24 VSS.n1241 17.0005
R2117 VSS.n24 VSS.n1242 17.0005
R2118 VSS.n24 VSS.n21 0.00321757
R2119 VSS.n20 VSS.n1193 17.0005
R2120 VSS.n20 VSS.n1194 17.0005
R2121 VSS.n20 VSS.n1195 17.0005
R2122 VSS.n20 VSS.n1196 17.0005
R2123 VSS.n20 VSS.n1197 17.0005
R2124 VSS.n20 VSS.n1204 17.0005
R2125 VSS.n20 VSS.n1214 17.0005
R2126 VSS.n20 VSS.n1215 17.0005
R2127 VSS.n20 VSS.n1216 17.0005
R2128 VSS.n20 VSS.n1217 17.0005
R2129 VSS.n20 VSS.n1218 17.0005
R2130 VSS.n20 VSS.n1225 17.0005
R2131 VSS.n20 VSS.n1230 17.0005
R2132 VSS.t183 VSS.n1221 17.0005
R2133 VSS.t183 VSS.n1222 17.0005
R2134 VSS.t183 VSS.n1220 17.0005
R2135 VSS.t183 VSS.n1223 17.0005
R2136 VSS.t183 VSS.n1219 17.0005
R2137 VSS.n1224 VSS.t183 17.0005
R2138 VSS.n1221 VSS.t182 17.0005
R2139 VSS.n1222 VSS.t182 17.0005
R2140 VSS.n1220 VSS.t182 17.0005
R2141 VSS.n1223 VSS.t182 17.0005
R2142 VSS.n1219 VSS.t182 17.0005
R2143 VSS.n1224 VSS.t182 17.0005
R2144 VSS.t187 VSS.n1200 17.0005
R2145 VSS.t187 VSS.n1201 17.0005
R2146 VSS.t187 VSS.n1199 17.0005
R2147 VSS.t187 VSS.n1202 17.0005
R2148 VSS.t187 VSS.n1198 17.0005
R2149 VSS.n1203 VSS.t187 17.0005
R2150 VSS.n1200 VSS.t186 17.0005
R2151 VSS.n1201 VSS.t186 17.0005
R2152 VSS.n1199 VSS.t186 17.0005
R2153 VSS.n1202 VSS.t186 17.0005
R2154 VSS.n1198 VSS.t186 17.0005
R2155 VSS.n1203 VSS.t186 17.0005
R2156 VSS.n2 VSS.n3 0.443295
R2157 VSS.n4 VSS.n1 0.0657667
R2158 VSS.n5 VSS.n4 0.0115956
R2159 VSS.n6 VSS.n5 0.0120688
R2160 VSS.n7 VSS.n6 0.0127176
R2161 VSS.n13 VSS.n3 8.4874
R2162 VSS.n15 VSS.n3 0.0549111
R2163 VSS.n129 VSS.n3 8.49965
R2164 VSS.n3 VSS.n18 6.86326
R2165 VSS.n3 VSS.n128 8.50075
R2166 VSS.n12 VSS.t175 4.2008
R2167 VSS.n12 VSS.n13 0.0442051
R2168 VSS.n13 VSS.n14 0.140063
R2169 VSS.t175 VSS.n16 8.29145
R2170 VSS.n11 VSS.t174 8.46986
R2171 VSS.n12 VSS.n11 0.0481031
R2172 VSS.n14 VSS.t174 4.11979
R2173 VSS.n15 VSS.n14 0.17397
R2174 VSS.n16 VSS.n15 0.411433
R2175 VSS.n0 VSS.t179 17.0005
R2176 VSS.t179 VSS.n4 8.49853
R2177 VSS.t179 VSS.n6 8.49829
R2178 VSS.t179 VSS.n8 17.0005
R2179 VSS.n0 VSS.n1 0.0603203
R2180 VSS.n1 VSS.t178 8.47134
R2181 VSS.n5 VSS.t178 8.49843
R2182 VSS.n7 VSS.t178 8.4981
R2183 VSS.n8 VSS.n7 0.00679799
R2184 VSS.n3 VSS.n117 8.50064
R2185 VSS.n3 VSS.n113 8.50075
R2186 VSS.n37 VSS.n1576 17.0005
R2187 VSS.n37 VSS.n1577 17.0005
R2188 VSS.n37 VSS.n1578 17.0005
R2189 VSS.n37 VSS.n1579 17.0005
R2190 VSS.n37 VSS.n1580 17.0005
R2191 VSS.n37 VSS.n1581 17.0005
R2192 VSS.n37 VSS.n1582 17.0005
R2193 VSS.n37 VSS.n1583 17.0005
R2194 VSS.n37 VSS.n1584 17.0005
R2195 VSS.n37 VSS.n1585 17.0005
R2196 VSS.n37 VSS.n1586 17.0005
R2197 VSS.n37 VSS.n1587 17.0005
R2198 VSS.n37 VSS.n1588 17.0005
R2199 VSS.n37 VSS.n1589 17.0005
R2200 VSS.n37 VSS.n1590 17.0005
R2201 VSS.n37 VSS.n1591 17.0005
R2202 VSS.n37 VSS.n1592 17.0005
R2203 VSS.n37 VSS.n1593 17.0005
R2204 VSS.n37 VSS.n1594 17.0005
R2205 VSS.n37 VSS.n1595 17.0005
R2206 VSS.n37 VSS.n1596 17.0005
R2207 VSS.n37 VSS.n1597 17.0005
R2208 VSS.n37 VSS.n1598 17.0005
R2209 VSS.n37 VSS.n1599 17.0005
R2210 VSS.n37 VSS.n1600 17.0005
R2211 VSS.n37 VSS.n1601 17.0005
R2212 VSS.n37 VSS.n1602 17.0005
R2213 VSS.n37 VSS.n1603 17.0005
R2214 VSS.n37 VSS.n1604 17.0005
R2215 VSS.n37 VSS.n1607 17.0005
R2216 VSS.n102 VSS.n3 8.49518
R2217 VSS.n127 VSS.n3 8.4994
R2218 VSS.n103 VSS.n3 8.49543
R2219 VSS.n126 VSS.n3 8.50075
R2220 VSS.n104 VSS.n3 8.49567
R2221 VSS.n125 VSS.n3 8.49915
R2222 VSS.n105 VSS.n3 8.49592
R2223 VSS.n124 VSS.n3 8.50075
R2224 VSS.n106 VSS.n3 8.49617
R2225 VSS.n123 VSS.n3 8.50075
R2226 VSS.n107 VSS.n3 8.49642
R2227 VSS.n122 VSS.n3 8.4989
R2228 VSS.n108 VSS.n3 8.50053
R2229 VSS.n121 VSS.n3 8.49865
R2230 VSS.n109 VSS.n3 8.50203
R2231 VSS.n120 VSS.n3 8.4984
R2232 VSS.n110 VSS.n3 8.50075
R2233 VSS.n119 VSS.n3 8.49815
R2234 VSS.n111 VSS.n3 8.49666
R2235 VSS.n118 VSS.n3 8.4979
R2236 VSS.n112 VSS.n3 8.49691
R2237 VSS.n116 VSS.n3 8.49765
R2238 VSS.n114 VSS.n3 8.49716
R2239 VSS.n115 VSS.n3 8.49741
R2240 VSS.n657 VSS.n622 17.0005
R2241 VSS.n657 VSS.n623 17.0005
R2242 VSS.n657 VSS.n624 17.0005
R2243 VSS.n657 VSS.n625 17.0005
R2244 VSS.n657 VSS.n626 17.0005
R2245 VSS.n657 VSS.n627 17.0005
R2246 VSS.n657 VSS.n628 17.0005
R2247 VSS.n657 VSS.n629 17.0005
R2248 VSS.n657 VSS.n630 17.0005
R2249 VSS.n657 VSS.n631 17.0005
R2250 VSS.n657 VSS.n632 17.0005
R2251 VSS.n657 VSS.n633 17.0005
R2252 VSS.n657 VSS.n634 17.0005
R2253 VSS.n657 VSS.n635 17.0005
R2254 VSS.n657 VSS.n636 17.0005
R2255 VSS.n657 VSS.n637 17.0005
R2256 VSS.n657 VSS.n638 17.0005
R2257 VSS.n657 VSS.n639 17.0005
R2258 VSS.n657 VSS.n640 17.0005
R2259 VSS.n657 VSS.n641 17.0005
R2260 VSS.n657 VSS.n642 17.0005
R2261 VSS.n657 VSS.n643 17.0005
R2262 VSS.n657 VSS.n644 17.0005
R2263 VSS.n657 VSS.n645 17.0005
R2264 VSS.n657 VSS.n646 17.0005
R2265 VSS.n657 VSS.n647 17.0005
R2266 VSS.n657 VSS.n648 17.0005
R2267 VSS.n657 VSS.n649 17.0005
R2268 VSS.n657 VSS.n650 17.0005
R2269 VSS.n603 VSS.n50 17.0005
R2270 VSS.n606 VSS.n50 17.0005
R2271 VSS.n609 VSS.n50 17.0005
R2272 VSS.n608 VSS.n50 17.0005
R2273 VSS.n616 VSS.n50 17.0005
R2274 VSS.n615 VSS.n50 17.0005
R2275 VSS.n585 VSS.n50 17.0005
R2276 VSS.n588 VSS.n50 17.0005
R2277 VSS.n591 VSS.n50 17.0005
R2278 VSS.n590 VSS.n50 17.0005
R2279 VSS.n598 VSS.n50 17.0005
R2280 VSS.n597 VSS.n50 17.0005
R2281 VSS.n584 VSS.n50 17.0005
R2282 VSS.n622 VSS.n50 17.0005
R2283 VSS.n623 VSS.n50 17.0005
R2284 VSS.n600 VSS.t191 17.0005
R2285 VSS.t191 VSS.n589 17.0005
R2286 VSS.t191 VSS.n587 17.0005
R2287 VSS.t191 VSS.n592 17.0005
R2288 VSS.t191 VSS.n586 17.0005
R2289 VSS.t191 VSS.n599 17.0005
R2290 VSS.n600 VSS.t190 17.0005
R2291 VSS.n589 VSS.t190 17.0005
R2292 VSS.n587 VSS.t190 17.0005
R2293 VSS.n592 VSS.t190 17.0005
R2294 VSS.n586 VSS.t190 17.0005
R2295 VSS.n599 VSS.t190 17.0005
R2296 VSS.n618 VSS.t195 17.0005
R2297 VSS.t195 VSS.n607 17.0005
R2298 VSS.t195 VSS.n605 17.0005
R2299 VSS.t195 VSS.n610 17.0005
R2300 VSS.t195 VSS.n604 17.0005
R2301 VSS.t195 VSS.n617 17.0005
R2302 VSS.n618 VSS.t194 17.0005
R2303 VSS.n607 VSS.t194 17.0005
R2304 VSS.n605 VSS.t194 17.0005
R2305 VSS.n610 VSS.t194 17.0005
R2306 VSS.n604 VSS.t194 17.0005
R2307 VSS.n617 VSS.t194 17.0005
R2308 VSS.n624 VSS.n50 17.0005
R2309 VSS.n625 VSS.n50 17.0005
R2310 VSS.n626 VSS.n50 17.0005
R2311 VSS.n627 VSS.n50 17.0005
R2312 VSS.n628 VSS.n50 17.0005
R2313 VSS.n629 VSS.n50 17.0005
R2314 VSS.n630 VSS.n50 17.0005
R2315 VSS.n631 VSS.n50 17.0005
R2316 VSS.n632 VSS.n50 17.0005
R2317 VSS.n633 VSS.n50 17.0005
R2318 VSS.n634 VSS.n50 17.0005
R2319 VSS.n635 VSS.n50 17.0005
R2320 VSS.n636 VSS.n50 17.0005
R2321 VSS.n637 VSS.n50 17.0005
R2322 VSS.n638 VSS.n50 17.0005
R2323 VSS.n639 VSS.n50 17.0005
R2324 VSS.n640 VSS.n50 17.0005
R2325 VSS.n641 VSS.n50 17.0005
R2326 VSS.n642 VSS.n50 17.0005
R2327 VSS.n643 VSS.n50 17.0005
R2328 VSS.n644 VSS.n50 17.0005
R2329 VSS.n645 VSS.n50 17.0005
R2330 VSS.n646 VSS.n50 17.0005
R2331 VSS.n647 VSS.n50 17.0005
R2332 VSS.n648 VSS.n50 17.0005
R2333 VSS.n649 VSS.n50 17.0005
R2334 VSS.n650 VSS.n50 17.0005
R2335 VSS.n1570 VSS.n263 17.0005
R2336 VSS.n1570 VSS.n262 17.0005
R2337 VSS.n1570 VSS.n261 17.0005
R2338 VSS.n1570 VSS.n260 17.0005
R2339 VSS.n1570 VSS.n259 17.0005
R2340 VSS.n1570 VSS.n258 17.0005
R2341 VSS.n1570 VSS.n257 17.0005
R2342 VSS.n1570 VSS.n256 17.0005
R2343 VSS.n1570 VSS.n255 17.0005
R2344 VSS.n1570 VSS.n254 17.0005
R2345 VSS.n1570 VSS.n253 17.0005
R2346 VSS.n1570 VSS.n252 17.0005
R2347 VSS.n1570 VSS.n251 17.0005
R2348 VSS.n1570 VSS.n250 17.0005
R2349 VSS.n1570 VSS.n249 17.0005
R2350 VSS.n1570 VSS.n248 17.0005
R2351 VSS.n1570 VSS.n247 17.0005
R2352 VSS.n1570 VSS.n246 17.0005
R2353 VSS.n1570 VSS.n245 17.0005
R2354 VSS.n1570 VSS.n244 17.0005
R2355 VSS.n1570 VSS.n243 17.0005
R2356 VSS.n1570 VSS.n242 17.0005
R2357 VSS.n1570 VSS.n241 17.0005
R2358 VSS.n1570 VSS.n240 17.0005
R2359 VSS.n1570 VSS.n239 17.0005
R2360 VSS.n1570 VSS.n238 17.0005
R2361 VSS.n1570 VSS.n237 17.0005
R2362 VSS.n1570 VSS.n236 17.0005
R2363 VSS.n1570 VSS.n235 17.0005
R2364 VSS.n1570 VSS.n234 17.0005
R2365 VSS.n1020 VSS.t132 17.0005
R2366 VSS.t132 VSS.n1018 17.0005
R2367 VSS.t90 VSS.n963 17.0005
R2368 VSS.n969 VSS.t90 17.0005
R2369 VSS.t139 VSS.n949 17.0005
R2370 VSS.n955 VSS.t139 17.0005
R2371 VSS.n558 VSS.t160 17.0005
R2372 VSS.t159 VSS.n555 17.0005
R2373 VSS.t171 VSS.n1049 17.0005
R2374 VSS.n1052 VSS.t170 17.0005
R2375 VSS.n471 VSS.t156 17.0005
R2376 VSS.t155 VSS.n468 17.0005
R2377 VSS.t86 VSS.n449 17.0005
R2378 VSS.n455 VSS.t86 17.0005
R2379 VSS.t120 VSS.n435 17.0005
R2380 VSS.n441 VSS.t120 17.0005
R2381 VSS.t82 VSS.n392 17.0005
R2382 VSS.n398 VSS.t82 17.0005
R2383 VSS.t101 VSS.n378 17.0005
R2384 VSS.n384 VSS.t101 17.0005
R2385 VSS.n1481 VSS.t41 16.3939
R2386 VSS.n1481 VSS.n410 16.3939
R2387 VSS.n1484 VSS.n1483 16.3939
R2388 VSS.n1487 VSS.t466 16.1295
R2389 VSS.n48 VSS.n621 20.3584
R2390 VSS.n835 VSS.n834 16.0389
R2391 VSS.t169 VSS.n1276 15.3723
R2392 VSS.n1002 VSS.n1001 15.3543
R2393 VSS.n1334 VSS.n1333 15.3525
R2394 VSS.n1465 VSS.n408 15.3262
R2395 VSS.t165 VSS.n544 15.0513
R2396 VSS.t111 VSS.n1318 15.0513
R2397 VSS.t161 VSS.n1423 15.0513
R2398 VSS.t96 VSS.n1450 15.0513
R2399 VSS.t149 VSS.n365 15.0513
R2400 VSS.t130 VSS.n1020 15.0513
R2401 VSS.t88 VSS.n969 15.0513
R2402 VSS.t137 VSS.n955 15.0513
R2403 VSS.t157 VSS.n558 15.0513
R2404 VSS.t168 VSS.n1052 15.0513
R2405 VSS.t153 VSS.n471 15.0513
R2406 VSS.t84 VSS.n455 15.0513
R2407 VSS.t118 VSS.n441 15.0513
R2408 VSS.t80 VSS.n398 15.0513
R2409 VSS.t99 VSS.n384 15.0513
R2410 VSS.n1490 VSS.n1489 15.0218
R2411 VSS.n545 VSS.t165 15.0005
R2412 VSS.n1319 VSS.t111 15.0005
R2413 VSS.n1424 VSS.t161 15.0005
R2414 VSS.n1451 VSS.t96 15.0005
R2415 VSS.n366 VSS.t149 15.0005
R2416 VSS.t196 VSS.n814 15.0005
R2417 VSS.n815 VSS.t196 15.0005
R2418 VSS.t200 VSS.n811 15.0005
R2419 VSS.n812 VSS.t200 15.0005
R2420 VSS.t180 VSS.n1231 15.0005
R2421 VSS.n1232 VSS.t180 15.0005
R2422 VSS.t184 VSS.n1210 15.0005
R2423 VSS.n1211 VSS.t184 15.0005
R2424 VSS.t172 VSS.n11 15.0005
R2425 VSS.n16 VSS.t172 15.0005
R2426 VSS.n10 VSS.t176 15.0005
R2427 VSS.t188 VSS.n663 15.0005
R2428 VSS.n664 VSS.t188 15.0005
R2429 VSS.t192 VSS.n660 15.0005
R2430 VSS.n661 VSS.t192 15.0005
R2431 VSS.n1021 VSS.t130 15.0005
R2432 VSS.n970 VSS.t88 15.0005
R2433 VSS.n956 VSS.t137 15.0005
R2434 VSS.n559 VSS.t157 15.0005
R2435 VSS.n1053 VSS.t168 15.0005
R2436 VSS.n472 VSS.t153 15.0005
R2437 VSS.n456 VSS.t84 15.0005
R2438 VSS.n442 VSS.t118 15.0005
R2439 VSS.n399 VSS.t80 15.0005
R2440 VSS.n385 VSS.t99 15.0005
R2441 VSS.n540 VSS.t24 14.9929
R2442 VSS.n539 VSS.t22 14.9929
R2443 VSS.n521 VSS.t20 14.9929
R2444 VSS.n533 VSS.t18 14.9929
R2445 VSS.n532 VSS.t16 14.9929
R2446 VSS.n531 VSS.t14 14.9929
R2447 VSS.n525 VSS.t12 14.9929
R2448 VSS.n527 VSS.t10 14.9929
R2449 VSS.n1419 VSS.t465 14.9929
R2450 VSS.n1418 VSS.t462 14.9929
R2451 VSS.n1400 VSS.t459 14.9929
R2452 VSS.n1412 VSS.t456 14.9929
R2453 VSS.n1411 VSS.t453 14.9929
R2454 VSS.n1410 VSS.t450 14.9929
R2455 VSS.n1404 VSS.t447 14.9929
R2456 VSS.n1406 VSS.t444 14.9929
R2457 VSS.n1074 VSS.t73 14.9929
R2458 VSS.n1075 VSS.t70 14.9929
R2459 VSS.n1073 VSS.t67 14.9929
R2460 VSS.n1072 VSS.t64 14.9929
R2461 VSS.n1060 VSS.t61 14.9929
R2462 VSS.n1066 VSS.t58 14.9929
R2463 VSS.n1065 VSS.t55 14.9929
R2464 VSS.n1064 VSS.t52 14.9929
R2465 VSS.n722 VSS.n343 14.9073
R2466 VSS.n723 VSS.n342 14.9073
R2467 VSS.n724 VSS.n341 14.9073
R2468 VSS.n725 VSS.n340 14.9073
R2469 VSS.n726 VSS.n339 14.9073
R2470 VSS.n727 VSS.n338 14.9073
R2471 VSS.n728 VSS.n337 14.9073
R2472 VSS.n729 VSS.n336 14.9073
R2473 VSS.n730 VSS.n335 14.9073
R2474 VSS.n731 VSS.n334 14.9073
R2475 VSS.n732 VSS.n333 14.9073
R2476 VSS.n733 VSS.n332 14.9073
R2477 VSS.n734 VSS.n331 14.9073
R2478 VSS.n735 VSS.n330 14.9073
R2479 VSS.n736 VSS.n329 14.9073
R2480 VSS.n737 VSS.n328 14.9073
R2481 VSS.n19 VSS.n17 5.53118
R2482 VSS.n1257 VSS.n1166 14.9073
R2483 VSS.n1256 VSS.n1167 14.9073
R2484 VSS.n1255 VSS.n1168 14.9073
R2485 VSS.n1254 VSS.n1169 14.9073
R2486 VSS.n1253 VSS.n1170 14.9073
R2487 VSS.n1252 VSS.n1171 14.9073
R2488 VSS.n1251 VSS.n1172 14.9073
R2489 VSS.n1250 VSS.n1173 14.9073
R2490 VSS.n1249 VSS.n1174 14.9073
R2491 VSS.n1248 VSS.n1175 14.9073
R2492 VSS.n1247 VSS.n1176 14.9073
R2493 VSS.n1246 VSS.n1177 14.9073
R2494 VSS.n1607 VSS.n1605 14.9073
R2495 VSS.n1604 VSS.n115 14.9073
R2496 VSS.n1603 VSS.n114 14.9073
R2497 VSS.n1602 VSS.n116 14.9073
R2498 VSS.n1601 VSS.n113 14.9073
R2499 VSS.n1600 VSS.n117 14.9073
R2500 VSS.n1599 VSS.n112 14.9073
R2501 VSS.n1598 VSS.n118 14.9073
R2502 VSS.n1597 VSS.n111 14.9073
R2503 VSS.n1596 VSS.n119 14.9073
R2504 VSS.n1595 VSS.n110 14.9073
R2505 VSS.n1594 VSS.n120 14.9073
R2506 VSS.n1593 VSS.n109 14.9073
R2507 VSS.n1592 VSS.n121 14.9073
R2508 VSS.n1591 VSS.n108 14.9073
R2509 VSS.n1590 VSS.n122 14.9073
R2510 VSS.n650 VSS.n234 14.9073
R2511 VSS.n649 VSS.n235 14.9073
R2512 VSS.n648 VSS.n236 14.9073
R2513 VSS.n647 VSS.n237 14.9073
R2514 VSS.n646 VSS.n238 14.9073
R2515 VSS.n645 VSS.n239 14.9073
R2516 VSS.n644 VSS.n240 14.9073
R2517 VSS.n643 VSS.n241 14.9073
R2518 VSS.n642 VSS.n242 14.9073
R2519 VSS.n641 VSS.n243 14.9073
R2520 VSS.n640 VSS.n244 14.9073
R2521 VSS.n639 VSS.n245 14.9073
R2522 VSS.n638 VSS.n246 14.9073
R2523 VSS.n637 VSS.n247 14.9073
R2524 VSS.n636 VSS.n248 14.9073
R2525 VSS.n635 VSS.n249 14.9073
R2526 VSS.n1477 VSS.n1471 14.6845
R2527 VSS.n1475 VSS.n1474 14.6845
R2528 VSS.n867 VSS.n866 14.149
R2529 VSS.n346 VSS.t249 14.046
R2530 VSS.n725 VSS.t336 13.9757
R2531 VSS.n19 VSS.t330 19.4459
R2532 VSS.t401 VSS.n116 13.9757
R2533 VSS.n647 VSS.t370 13.9757
R2534 VSS.n1565 VSS.n349 13.5665
R2535 VSS.n1552 VSS.n358 13.5665
R2536 VSS.n1279 VSS.n569 13.5665
R2537 VSS.n1132 VSS.n1131 13.321
R2538 VSS.n1506 VSS.t329 12.6948
R2539 VSS.t220 VSS.t463 12.4278
R2540 VSS.n961 VSS.t283 12.3721
R2541 VSS.n962 VSS.t280 12.3721
R2542 VSS.n947 VSS.t290 12.3721
R2543 VSS.n948 VSS.t287 12.3721
R2544 VSS.n447 VSS.t428 12.3721
R2545 VSS.n448 VSS.t425 12.3721
R2546 VSS.n433 VSS.t435 12.3721
R2547 VSS.n434 VSS.t432 12.3721
R2548 VSS.n390 VSS.t230 12.3721
R2549 VSS.n391 VSS.t227 12.3721
R2550 VSS.n376 VSS.t239 12.3721
R2551 VSS.n377 VSS.t236 12.3721
R2552 VSS.n995 VSS.t396 11.9225
R2553 VSS.n490 VSS.t37 11.9225
R2554 VSS.n1496 VSS.t1 11.9225
R2555 VSS.n1154 VSS.t389 11.5379
R2556 VSS.n1125 VSS.t223 11.5361
R2557 VSS.n1143 VSS.t413 11.5306
R2558 VSS.n1155 VSS.t407 11.5291
R2559 VSS.n68 VSS.n838 2.84701
R2560 VSS.n267 VSS.n266 10.6883
R2561 VSS.n1569 VSS.n57 4.06684
R2562 VSS.n1571 VSS.n182 10.6883
R2563 VSS.n131 VSS.n29 10.6883
R2564 VSS.n30 VSS.n155 10.6883
R2565 VSS.n1468 VSS.n1461 10.2696
R2566 VSS.n1330 VSS.n1329 10.2696
R2567 VSS.n1023 VSS.n1017 9.5943
R2568 VSS.n1327 VSS.n1326 9.5943
R2569 VSS.n1459 VSS.n1458 9.5943
R2570 VSS.t158 VSS.t72 9.55596
R2571 VSS.n1024 VSS.n1023 9.3655
R2572 VSS.n1327 VSS.n1321 9.3655
R2573 VSS.n1459 VSS.n1453 9.3655
R2574 VSS.n836 VSS.n315 9.31727
R2575 VSS.n961 VSS.n960 9.177
R2576 VSS.n947 VSS.n945 9.177
R2577 VSS.n447 VSS.n446 9.177
R2578 VSS.n433 VSS.n431 9.177
R2579 VSS.n390 VSS.n389 9.177
R2580 VSS.n376 VSS.n374 9.177
R2581 VSS.n1064 VSS.n1062 9.06527
R2582 VSS.n528 VSS.n527 9.06527
R2583 VSS.n1407 VSS.n1406 9.06527
R2584 VSS.n1068 VSS.n1067 9.0005
R2585 VSS.n1069 VSS.n1061 9.0005
R2586 VSS.n1071 VSS.n1070 9.0005
R2587 VSS.n1059 VSS.n1058 9.0005
R2588 VSS.n1077 VSS.n1076 9.0005
R2589 VSS.n1078 VSS.n1057 9.0005
R2590 VSS.n1086 VSS.n1085 9.0005
R2591 VSS.n1086 VSS.n1055 9.0005
R2592 VSS.n1074 VSS.n1057 9.0005
R2593 VSS.n1076 VSS.n1075 9.0005
R2594 VSS.n1073 VSS.n1059 9.0005
R2595 VSS.n1072 VSS.n1071 9.0005
R2596 VSS.n1061 VSS.n1060 9.0005
R2597 VSS.n1067 VSS.n1066 9.0005
R2598 VSS.n1065 VSS.n1063 9.0005
R2599 VSS.n1055 VSS.n1054 9.0005
R2600 VSS.n530 VSS.n529 9.0005
R2601 VSS.n524 VSS.n523 9.0005
R2602 VSS.n535 VSS.n534 9.0005
R2603 VSS.n536 VSS.n522 9.0005
R2604 VSS.n538 VSS.n537 9.0005
R2605 VSS.n520 VSS.n519 9.0005
R2606 VSS.n549 VSS.n548 9.0005
R2607 VSS.n548 VSS.n547 9.0005
R2608 VSS.n540 VSS.n520 9.0005
R2609 VSS.n539 VSS.n538 9.0005
R2610 VSS.n522 VSS.n521 9.0005
R2611 VSS.n534 VSS.n533 9.0005
R2612 VSS.n532 VSS.n524 9.0005
R2613 VSS.n531 VSS.n530 9.0005
R2614 VSS.n526 VSS.n525 9.0005
R2615 VSS.n547 VSS.n546 9.0005
R2616 VSS.n1409 VSS.n1408 9.0005
R2617 VSS.n1403 VSS.n1402 9.0005
R2618 VSS.n1414 VSS.n1413 9.0005
R2619 VSS.n1415 VSS.n1401 9.0005
R2620 VSS.n1417 VSS.n1416 9.0005
R2621 VSS.n1399 VSS.n1398 9.0005
R2622 VSS.n1428 VSS.n1427 9.0005
R2623 VSS.n1427 VSS.n1426 9.0005
R2624 VSS.n1419 VSS.n1399 9.0005
R2625 VSS.n1418 VSS.n1417 9.0005
R2626 VSS.n1401 VSS.n1400 9.0005
R2627 VSS.n1413 VSS.n1412 9.0005
R2628 VSS.n1411 VSS.n1403 9.0005
R2629 VSS.n1410 VSS.n1409 9.0005
R2630 VSS.n1405 VSS.n1404 9.0005
R2631 VSS.n1426 VSS.n1425 9.0005
R2632 VSS.n975 VSS.n974 9.0005
R2633 VSS.n973 VSS.n944 9.0005
R2634 VSS.n973 VSS.n972 9.0005
R2635 VSS.n962 VSS.n959 9.0005
R2636 VSS.n948 VSS.n946 9.0005
R2637 VSS.n974 VSS.n958 9.0005
R2638 VSS.n958 VSS.n957 9.0005
R2639 VSS.n972 VSS.n971 9.0005
R2640 VSS.n461 VSS.n460 9.0005
R2641 VSS.n459 VSS.n430 9.0005
R2642 VSS.n459 VSS.n458 9.0005
R2643 VSS.n448 VSS.n445 9.0005
R2644 VSS.n434 VSS.n432 9.0005
R2645 VSS.n460 VSS.n444 9.0005
R2646 VSS.n444 VSS.n443 9.0005
R2647 VSS.n458 VSS.n457 9.0005
R2648 VSS.n404 VSS.n403 9.0005
R2649 VSS.n402 VSS.n373 9.0005
R2650 VSS.n402 VSS.n401 9.0005
R2651 VSS.n391 VSS.n388 9.0005
R2652 VSS.n377 VSS.n375 9.0005
R2653 VSS.n403 VSS.n387 9.0005
R2654 VSS.n387 VSS.n386 9.0005
R2655 VSS.n401 VSS.n400 9.0005
R2656 VSS.n1027 VSS.n1006 8.7643
R2657 VSS.n1320 VSS.t7 8.76153
R2658 VSS.n1452 VSS.t392 8.76153
R2659 VSS.n1022 VSS.t46 8.76153
R2660 VSS.n56 VSS.n57 1.20191
R2661 VSS.n68 VSS.n67 0.313582
R2662 VSS.n69 VSS.n71 0.00214918
R2663 VSS.n71 VSS.n72 0.00172539
R2664 VSS.n72 VSS.n73 0.00171613
R2665 VSS.n73 VSS.n74 0.00169968
R2666 VSS.n74 VSS.n75 0.00166651
R2667 VSS.n75 VSS.n77 0.00158329
R2668 VSS.n78 VSS.n80 0.00214918
R2669 VSS.n80 VSS.n81 0.00172539
R2670 VSS.n81 VSS.n82 0.00171613
R2671 VSS.n82 VSS.n83 0.00169968
R2672 VSS.n83 VSS.n84 0.00166651
R2673 VSS.n84 VSS.n86 0.00158329
R2674 VSS.n838 VSS.n90 3.40102
R2675 VSS.n772 VSS.n756 8.501
R2676 VSS.n771 VSS.n756 8.501
R2677 VSS.n769 VSS.n756 8.501
R2678 VSS.n767 VSS.n756 8.501
R2679 VSS.n763 VSS.n756 8.501
R2680 VSS.n761 VSS.n756 8.501
R2681 VSS.n759 VSS.n756 8.501
R2682 VSS.n827 VSS.n756 8.501
R2683 VSS.n753 VSS.n751 8.501
R2684 VSS.n753 VSS.n752 8.501
R2685 VSS.n31 VSS.n183 4.06684
R2686 VSS.n1605 VSS.n3 8.501
R2687 VSS.n655 VSS.n47 3.40102
R2688 VSS.n655 VSS.n45 3.4011
R2689 VSS.n42 VSS.n40 0.00158329
R2690 VSS.n655 VSS.n42 2.83428
R2691 VSS.n659 VSS.n52 0.0202345
R2692 VSS.n659 VSS.n49 4.251
R2693 VSS.n1565 VSS.n346 8.5005
R2694 VSS.n1566 VSS.n1565 8.5005
R2695 VSS.n1476 VSS.n1475 8.5005
R2696 VSS.n1477 VSS.n1476 8.5005
R2697 VSS.n1474 VSS.n1473 8.5005
R2698 VSS.n1473 VSS.n1471 8.5005
R2699 VSS.n1569 VSS.n64 8.5005
R2700 VSS.n1486 VSS.n1485 8.5005
R2701 VSS.n1487 VSS.n1486 8.5005
R2702 VSS.n410 VSS.n358 8.5005
R2703 VSS.n1484 VSS.n358 8.5005
R2704 VSS.n1482 VSS.n1481 8.5005
R2705 VSS.n1483 VSS.n1482 8.5005
R2706 VSS.n1006 VSS.n1005 8.5005
R2707 VSS.n1282 VSS.n1281 8.5005
R2708 VSS.n1282 VSS.n567 8.5005
R2709 VSS.n1279 VSS.n1278 8.5005
R2710 VSS.n1280 VSS.n1279 8.5005
R2711 VSS.n1277 VSS.n566 8.5005
R2712 VSS.n568 VSS.n566 8.5005
R2713 VSS.n834 VSS.n719 8.5005
R2714 VSS.n834 VSS.n720 8.5005
R2715 VSS.n1570 VSS.n183 8.5005
R2716 VSS.n48 VSS.n49 0.00149996
R2717 VSS.n809 VSS.n718 8.49709
R2718 VSS.n792 VSS.n718 8.49709
R2719 VSS.n791 VSS.n718 8.49709
R2720 VSS.n20 VSS.n1192 8.49709
R2721 VSS.n20 VSS.n1209 8.49709
R2722 VSS.n20 VSS.n1213 8.49709
R2723 VSS.n9 VSS.n8 0.0132193
R2724 VSS.n11 VSS.n10 0.0580715
R2725 VSS.n619 VSS.n50 8.49709
R2726 VSS.n602 VSS.n50 8.49709
R2727 VSS.n601 VSS.n50 8.49709
R2728 VSS.n813 VSS.n718 8.49502
R2729 VSS.n20 VSS.n1212 8.49502
R2730 VSS.n10 VSS.n9 0.0319588
R2731 VSS.n662 VSS.n50 8.49502
R2732 VSS.t91 VSS.n967 8.49202
R2733 VSS.t91 VSS.n965 8.49202
R2734 VSS.n968 VSS.t91 8.49202
R2735 VSS.n966 VSS.t90 8.49202
R2736 VSS.n964 VSS.t90 8.49202
R2737 VSS.t140 VSS.n953 8.49202
R2738 VSS.t140 VSS.n951 8.49202
R2739 VSS.n954 VSS.t140 8.49202
R2740 VSS.n952 VSS.t139 8.49202
R2741 VSS.n950 VSS.t139 8.49202
R2742 VSS.t87 VSS.n453 8.49202
R2743 VSS.t87 VSS.n451 8.49202
R2744 VSS.n454 VSS.t87 8.49202
R2745 VSS.n452 VSS.t86 8.49202
R2746 VSS.n450 VSS.t86 8.49202
R2747 VSS.t121 VSS.n439 8.49202
R2748 VSS.t121 VSS.n437 8.49202
R2749 VSS.n440 VSS.t121 8.49202
R2750 VSS.n438 VSS.t120 8.49202
R2751 VSS.n436 VSS.t120 8.49202
R2752 VSS.t83 VSS.n396 8.49202
R2753 VSS.t83 VSS.n394 8.49202
R2754 VSS.n397 VSS.t83 8.49202
R2755 VSS.n395 VSS.t82 8.49202
R2756 VSS.n393 VSS.t82 8.49202
R2757 VSS.t102 VSS.n382 8.49202
R2758 VSS.t102 VSS.n380 8.49202
R2759 VSS.n383 VSS.t102 8.49202
R2760 VSS.n381 VSS.t101 8.49202
R2761 VSS.n379 VSS.t101 8.49202
R2762 VSS.n543 VSS.t167 8.49176
R2763 VSS.n542 VSS.t166 8.49176
R2764 VSS.n1422 VSS.t164 8.49176
R2765 VSS.n1421 VSS.t163 8.49176
R2766 VSS.t152 VSS.n364 8.49176
R2767 VSS.n363 VSS.t151 8.49176
R2768 VSS.t160 VSS.n557 8.49176
R2769 VSS.n556 VSS.t159 8.49176
R2770 VSS.n1051 VSS.t171 8.49176
R2771 VSS.n1050 VSS.t170 8.49176
R2772 VSS.t156 VSS.n470 8.49176
R2773 VSS.n469 VSS.t155 8.49176
R2774 VSS.n1317 VSS.t112 8.49044
R2775 VSS.n1449 VSS.t97 8.49044
R2776 VSS.n1019 VSS.t131 8.49044
R2777 VSS.n840 VSS.n66 8.46995
R2778 VSS.n842 VSS.n71 8.46995
R2779 VSS.n843 VSS.n72 8.46995
R2780 VSS.n844 VSS.n73 8.46995
R2781 VSS.n845 VSS.n74 8.46995
R2782 VSS.n846 VSS.n75 8.46995
R2783 VSS.n847 VSS.n77 8.46995
R2784 VSS.n848 VSS.n76 8.46995
R2785 VSS.n850 VSS.n80 8.46995
R2786 VSS.n852 VSS.n82 8.46995
R2787 VSS.n853 VSS.n83 8.46995
R2788 VSS.n854 VSS.n84 8.46995
R2789 VSS.n855 VSS.n86 8.46995
R2790 VSS.n856 VSS.n85 8.46995
R2791 VSS.n859 VSS.n89 8.46995
R2792 VSS.n860 VSS.n88 8.46995
R2793 VSS.n817 VSS.n773 8.46995
R2794 VSS.n818 VSS.n770 8.46995
R2795 VSS.n819 VSS.n768 8.46995
R2796 VSS.n821 VSS.n764 8.46995
R2797 VSS.n822 VSS.n762 8.46995
R2798 VSS.n823 VSS.n760 8.46995
R2799 VSS.n826 VSS.n825 8.46995
R2800 VSS.n1575 VSS.n27 8.46995
R2801 VSS.n25 VSS.n22 2.31164
R2802 VSS.n667 VSS.n46 8.46995
R2803 VSS.n668 VSS.n43 8.46995
R2804 VSS.n670 VSS.n39 8.46995
R2805 VSS.n670 VSS.n41 0.440001
R2806 VSS.n41 VSS.n40 4.17416
R2807 VSS.n851 VSS.n81 8.46813
R2808 VSS.n1005 VSS.n571 7.82319
R2809 VSS.n1011 VSS.t145 7.501
R2810 VSS.n1008 VSS.t141 7.501
R2811 VSS.n1015 VSS.t126 7.501
R2812 VSS.n505 VSS.t133 7.501
R2813 VSS.n502 VSS.t122 7.501
R2814 VSS.n1324 VSS.t107 7.501
R2815 VSS.n417 VSS.t114 7.501
R2816 VSS.n414 VSS.t103 7.501
R2817 VSS.n1456 VSS.t92 7.501
R2818 VSS.n1135 VSS.t216 7.5005
R2819 VSS.n1161 VSS.t208 7.5005
R2820 VSS.n1616 VSS.t204 7.5005
R2821 VSS.n1146 VSS.t212 7.5005
R2822 VSS.n1269 VSS.n576 7.4818
R2823 VSS.n1475 VSS.n1471 7.02327
R2824 VSS.n863 VSS.t66 6.64778
R2825 VSS.t185 VSS.n1258 6.52224
R2826 VSS.t177 VSS.n129 6.52224
R2827 VSS.n622 VSS.t193 6.52224
R2828 VSS.n554 VSS.n553 6.1798
R2829 VSS.t150 VSS.t464 6.08194
R2830 VSS.n1466 VSS.n1464 6.07337
R2831 VSS.n1332 VSS.n497 6.07337
R2832 VSS.n1004 VSS.n713 6.07337
R2833 VSS.n1567 VSS.n1566 6.06562
R2834 VSS.n367 VSS.t39 5.99337
R2835 VSS.n560 VSS.t339 5.99337
R2836 VSS.n473 VSS.t471 5.99337
R2837 VSS.n546 VSS.t26 5.99293
R2838 VSS.n1425 VSS.t468 5.99293
R2839 VSS.n1054 VSS.t76 5.99293
R2840 VSS.n1612 VSS.n18 17621.4
R2841 VSS.n1134 VSS.n1133 5.74822
R2842 VSS.n1615 VSS.n95 5.74272
R2843 VSS.n1264 VSS.n1262 5.67581
R2844 VSS.n838 VSS.n69 1
R2845 VSS.n838 VSS.n78 1
R2846 VSS.n838 VSS.n837 5.66778
R2847 VSS.n90 VSS.n716 0.00229996
R2848 VSS.n838 VSS.n58 5.66778
R2849 VSS.n829 VSS.n756 5.66778
R2850 VSS.n765 VSS.n756 5.66778
R2851 VSS.n757 VSS.n756 5.66778
R2852 VSS.n753 VSS.n749 5.66778
R2853 VSS.n655 VSS.n653 5.66778
R2854 VSS.n655 VSS.n654 5.66778
R2855 VSS.n47 VSS.n583 0.00229996
R2856 VSS.n45 VSS.n39 0.00249999
R2857 VSS.n655 VSS.n652 5.66778
R2858 VSS.n21 VSS.n20 0.0105413
R2859 VSS.n831 VSS.n830 5.66717
R2860 VSS.n20 VSS.n26 0.113698
R2861 VSS.n810 VSS.n718 5.66083
R2862 VSS.n52 VSS.n50 3.39111
R2863 VSS.n841 VSS.n70 5.61281
R2864 VSS.n849 VSS.n79 5.61281
R2865 VSS.n857 VSS.n87 5.61281
R2866 VSS.n858 VSS.n716 5.61281
R2867 VSS.n820 VSS.n766 5.61281
R2868 VSS.n824 VSS.n758 5.61281
R2869 VSS.n828 VSS.n754 5.61281
R2870 VSS.n22 VSS.n20 0.648372
R2871 VSS.n666 VSS.n583 5.61281
R2872 VSS.n669 VSS.n44 5.61281
R2873 VSS.n671 VSS.n582 5.61281
R2874 VSS.n672 VSS.n581 5.61281
R2875 VSS.t414 VSS.t446 5.55312
R2876 VSS.n1472 VSS.n352 5.05801
R2877 VSS.n1548 VSS.n360 5.05801
R2878 VSS.n1284 VSS.n1283 5.05801
R2879 VSS.n975 VSS.n945 4.853
R2880 VSS.n960 VSS.n944 4.853
R2881 VSS.n461 VSS.n431 4.853
R2882 VSS.n446 VSS.n430 4.853
R2883 VSS.n404 VSS.n374 4.853
R2884 VSS.n389 VSS.n373 4.853
R2885 VSS.n1150 VSS.n1149 4.74103
R2886 VSS.n1139 VSS.n1138 4.73759
R2887 VSS.n1620 VSS.n1619 4.73583
R2888 VSS.n1164 VSS.n1160 4.73062
R2889 VSS.n529 VSS.n528 4.62953
R2890 VSS.n1408 VSS.n1407 4.62953
R2891 VSS.n1068 VSS.n1062 4.62953
R2892 VSS.n1473 VSS.n1472 4.50285
R2893 VSS.n1482 VSS.n360 4.50285
R2894 VSS.n1283 VSS.n566 4.50204
R2895 VSS.n756 VSS.n721 4.25119
R2896 VSS.n656 VSS.n655 4.251
R2897 VSS.n651 VSS.n580 4.24619
R2898 VSS.n1476 VSS.n1472 4.24341
R2899 VSS.n1486 VSS.n360 4.24341
R2900 VSS.n1283 VSS.n1282 4.24341
R2901 VSS.t341 VSS.t169 4.15505
R2902 VSS.t340 VSS.t77 4.15505
R2903 VSS.t338 VSS.t75 4.15505
R2904 VSS.n1090 VSS.t394 4.03726
R2905 VSS.n516 VSS.t79 4.03726
R2906 VSS.n1396 VSS.t221 4.03726
R2907 VSS.n24 VSS.n25 0.112529
R2908 VSS.n26 VSS.n1210 0.722073
R2909 VSS.n20 VSS.n1233 3.39091
R2910 VSS.n1137 VSS.t411 3.37096
R2911 VSS.n1163 VSS.t387 3.37096
R2912 VSS.n1618 VSS.t335 3.37096
R2913 VSS.n1148 VSS.t4 3.37096
R2914 VSS.n971 VSS.t278 3.37096
R2915 VSS.n957 VSS.t276 3.37096
R2916 VSS.n457 VSS.t423 3.37096
R2917 VSS.n443 VSS.t421 3.37096
R2918 VSS.n400 VSS.t225 3.37096
R2919 VSS.n386 VSS.t234 3.37096
R2920 VSS.n839 VSS.n67 3.31185
R2921 VSS.n313 VSS.n56 3.15733
R2922 VSS.n311 VSS.n56 3.15733
R2923 VSS.n309 VSS.n56 3.15733
R2924 VSS.n307 VSS.n56 3.15733
R2925 VSS.n305 VSS.n56 3.15733
R2926 VSS.n303 VSS.n56 3.15733
R2927 VSS.n301 VSS.n56 3.15733
R2928 VSS.n299 VSS.n56 3.15733
R2929 VSS.n297 VSS.n56 3.15733
R2930 VSS.n295 VSS.n56 3.15733
R2931 VSS.n293 VSS.n56 3.15733
R2932 VSS.n291 VSS.n56 3.15733
R2933 VSS.n287 VSS.n56 3.15733
R2934 VSS.n285 VSS.n56 3.15733
R2935 VSS.n283 VSS.n56 3.15733
R2936 VSS.n281 VSS.n56 3.15733
R2937 VSS.n279 VSS.n56 3.15733
R2938 VSS.n277 VSS.n56 3.15733
R2939 VSS.n275 VSS.n56 3.15733
R2940 VSS.n273 VSS.n56 3.15733
R2941 VSS.n271 VSS.n56 3.15733
R2942 VSS.n269 VSS.n56 3.15733
R2943 VSS.n267 VSS.n56 3.15733
R2944 VSS.n64 VSS.n268 3.15733
R2945 VSS.n64 VSS.n270 3.15733
R2946 VSS.n64 VSS.n272 3.15733
R2947 VSS.n64 VSS.n274 3.15733
R2948 VSS.n64 VSS.n276 3.15733
R2949 VSS.n64 VSS.n278 3.15733
R2950 VSS.n64 VSS.n280 3.15733
R2951 VSS.n64 VSS.n282 3.15733
R2952 VSS.n64 VSS.n284 3.15733
R2953 VSS.n64 VSS.n286 3.15733
R2954 VSS.n64 VSS.n288 3.15733
R2955 VSS.n64 VSS.n290 3.15733
R2956 VSS.n64 VSS.n292 3.15733
R2957 VSS.n64 VSS.n294 3.15733
R2958 VSS.n64 VSS.n296 3.15733
R2959 VSS.n64 VSS.n298 3.15733
R2960 VSS.n64 VSS.n300 3.15733
R2961 VSS.n64 VSS.n302 3.15733
R2962 VSS.n64 VSS.n304 3.15733
R2963 VSS.n64 VSS.n306 3.15733
R2964 VSS.n64 VSS.n308 3.15733
R2965 VSS.n64 VSS.n310 3.15733
R2966 VSS.n64 VSS.n312 3.15733
R2967 VSS.n64 VSS.n314 3.15733
R2968 VSS.n230 VSS.n17 3.15733
R2969 VSS.n228 VSS.n17 3.15733
R2970 VSS.n226 VSS.n17 3.15733
R2971 VSS.n224 VSS.n17 3.15733
R2972 VSS.n222 VSS.n17 3.15733
R2973 VSS.n220 VSS.n17 3.15733
R2974 VSS.n218 VSS.n17 3.15733
R2975 VSS.n216 VSS.n17 3.15733
R2976 VSS.n214 VSS.n17 3.15733
R2977 VSS.n212 VSS.n17 3.15733
R2978 VSS.n210 VSS.n17 3.15733
R2979 VSS.n208 VSS.n17 3.15733
R2980 VSS.n204 VSS.n17 3.15733
R2981 VSS.n202 VSS.n17 3.15733
R2982 VSS.n200 VSS.n17 3.15733
R2983 VSS.n198 VSS.n17 3.15733
R2984 VSS.n196 VSS.n17 3.15733
R2985 VSS.n194 VSS.n17 3.15733
R2986 VSS.n192 VSS.n17 3.15733
R2987 VSS.n190 VSS.n17 3.15733
R2988 VSS.n188 VSS.n17 3.15733
R2989 VSS.n186 VSS.n17 3.15733
R2990 VSS.n182 VSS.n17 3.15733
R2991 VSS.n1570 VSS.n185 3.15733
R2992 VSS.n1570 VSS.n187 3.15733
R2993 VSS.n1570 VSS.n189 3.15733
R2994 VSS.n1570 VSS.n191 3.15733
R2995 VSS.n1570 VSS.n193 3.15733
R2996 VSS.n1570 VSS.n195 3.15733
R2997 VSS.n1570 VSS.n197 3.15733
R2998 VSS.n1570 VSS.n199 3.15733
R2999 VSS.n1570 VSS.n201 3.15733
R3000 VSS.n1570 VSS.n203 3.15733
R3001 VSS.n1570 VSS.n205 3.15733
R3002 VSS.n1570 VSS.n207 3.15733
R3003 VSS.n1570 VSS.n209 3.15733
R3004 VSS.n1570 VSS.n211 3.15733
R3005 VSS.n1570 VSS.n213 3.15733
R3006 VSS.n1570 VSS.n215 3.15733
R3007 VSS.n1570 VSS.n217 3.15733
R3008 VSS.n1570 VSS.n219 3.15733
R3009 VSS.n1570 VSS.n221 3.15733
R3010 VSS.n1570 VSS.n223 3.15733
R3011 VSS.n1570 VSS.n225 3.15733
R3012 VSS.n1570 VSS.n227 3.15733
R3013 VSS.n1570 VSS.n229 3.15733
R3014 VSS.n1570 VSS.n231 3.15733
R3015 VSS.n37 VSS.n131 3.15733
R3016 VSS.n37 VSS.n132 3.15733
R3017 VSS.n37 VSS.n133 3.15733
R3018 VSS.n37 VSS.n134 3.15733
R3019 VSS.n37 VSS.n135 3.15733
R3020 VSS.n37 VSS.n136 3.15733
R3021 VSS.n37 VSS.n137 3.15733
R3022 VSS.n37 VSS.n138 3.15733
R3023 VSS.n37 VSS.n139 3.15733
R3024 VSS.n37 VSS.n140 3.15733
R3025 VSS.n37 VSS.n141 3.15733
R3026 VSS.n37 VSS.n142 3.15733
R3027 VSS.n37 VSS.n143 3.15733
R3028 VSS.n37 VSS.n145 3.15733
R3029 VSS.n37 VSS.n146 3.15733
R3030 VSS.n37 VSS.n147 3.15733
R3031 VSS.n37 VSS.n148 3.15733
R3032 VSS.n37 VSS.n149 3.15733
R3033 VSS.n37 VSS.n150 3.15733
R3034 VSS.n37 VSS.n151 3.15733
R3035 VSS.n37 VSS.n152 3.15733
R3036 VSS.n37 VSS.n153 3.15733
R3037 VSS.n37 VSS.n154 3.15733
R3038 VSS.n37 VSS.n155 3.15733
R3039 VSS.n17 VSS.n157 3.15733
R3040 VSS.n17 VSS.n158 3.15733
R3041 VSS.n17 VSS.n159 3.15733
R3042 VSS.n17 VSS.n160 3.15733
R3043 VSS.n17 VSS.n161 3.15733
R3044 VSS.n17 VSS.n162 3.15733
R3045 VSS.n17 VSS.n163 3.15733
R3046 VSS.n17 VSS.n164 3.15733
R3047 VSS.n17 VSS.n165 3.15733
R3048 VSS.n17 VSS.n166 3.15733
R3049 VSS.n17 VSS.n167 3.15733
R3050 VSS.n17 VSS.n168 3.15733
R3051 VSS.n17 VSS.n169 3.15733
R3052 VSS.n17 VSS.n170 3.15733
R3053 VSS.n17 VSS.n171 3.15733
R3054 VSS.n17 VSS.n172 3.15733
R3055 VSS.n17 VSS.n173 3.15733
R3056 VSS.n17 VSS.n174 3.15733
R3057 VSS.n17 VSS.n175 3.15733
R3058 VSS.n17 VSS.n176 3.15733
R3059 VSS.n17 VSS.n177 3.15733
R3060 VSS.n17 VSS.n178 3.15733
R3061 VSS.n17 VSS.n179 3.15733
R3062 VSS.n17 VSS.n180 3.15733
R3063 VSS.n1083 VSS.n1056 3.0638
R3064 VSS.n1137 VSS.n1136 3.05532
R3065 VSS.n1163 VSS.n1162 3.05532
R3066 VSS.n1618 VSS.n1617 3.05532
R3067 VSS.n1148 VSS.n1147 3.05532
R3068 VSS.n289 VSS.n56 3.04477
R3069 VSS.n206 VSS.n17 3.04477
R3070 VSS.n37 VSS.n144 3.04477
R3071 VSS.n1543 VSS.n1542 3.03156
R3072 VSS.n1295 VSS.n551 3.02231
R3073 VSS.n1557 VSS.n354 3.02231
R3074 VSS.n1492 VSS.n1491 3.0005
R3075 VSS.n1494 VSS.n1493 3.0005
R3076 VSS.n1495 VSS.n372 3.0005
R3077 VSS.n1498 VSS.n1497 3.0005
R3078 VSS.n1499 VSS.n371 3.0005
R3079 VSS.n1501 VSS.n1500 3.0005
R3080 VSS.n1502 VSS.n370 3.0005
R3081 VSS.n1504 VSS.n1503 3.0005
R3082 VSS.n1541 VSS.n1505 3.0005
R3083 VSS.n1540 VSS.n1539 3.0005
R3084 VSS.n1538 VSS.n1509 3.0005
R3085 VSS.n1508 VSS.n1507 3.0005
R3086 VSS.n1537 VSS.n1536 3.0005
R3087 VSS.n1535 VSS.n1510 3.0005
R3088 VSS.n1534 VSS.n1533 3.0005
R3089 VSS.n1532 VSS.n1511 3.0005
R3090 VSS.n1531 VSS.n1530 3.0005
R3091 VSS.n1529 VSS.n1512 3.0005
R3092 VSS.n1528 VSS.n1527 3.0005
R3093 VSS.n1526 VSS.n1513 3.0005
R3094 VSS.n1525 VSS.n1524 3.0005
R3095 VSS.n1523 VSS.n1514 3.0005
R3096 VSS.n1522 VSS.n1521 3.0005
R3097 VSS.n1520 VSS.n1515 3.0005
R3098 VSS.n1519 VSS.n1518 3.0005
R3099 VSS.n1517 VSS.n1516 3.0005
R3100 VSS.n94 VSS.n93 3.0005
R3101 VSS.n1623 VSS.n1622 3.0005
R3102 VSS.n1363 VSS.n1362 3.0005
R3103 VSS.n1361 VSS.n1355 3.0005
R3104 VSS.n1360 VSS.n1359 3.0005
R3105 VSS.n1358 VSS.n1357 3.0005
R3106 VSS.n1356 VSS.n407 3.0005
R3107 VSS.n1345 VSS.n1344 3.0005
R3108 VSS.n924 VSS.n910 3.0005
R3109 VSS.n913 VSS.n911 3.0005
R3110 VSS.n912 VSS.n921 3.0005
R3111 VSS.n920 VSS.n914 3.0005
R3112 VSS.n919 VSS.n918 3.0005
R3113 VSS.n917 VSS.n915 3.0005
R3114 VSS.n916 VSS.n426 3.0005
R3115 VSS.n1372 VSS.n1351 3.0005
R3116 VSS.n1374 VSS.n1373 3.0005
R3117 VSS.n1375 VSS.n1350 3.0005
R3118 VSS.n1377 VSS.n1376 3.0005
R3119 VSS.n1378 VSS.n1349 3.0005
R3120 VSS.n1348 VSS.n1347 3.0005
R3121 VSS.n1346 VSS.n424 3.0005
R3122 VSS.n1380 VSS.n1379 3.0005
R3123 VSS.n1365 VSS.n1364 3.0005
R3124 VSS.n1366 VSS.n1353 3.0005
R3125 VSS.n1368 VSS.n1367 3.0005
R3126 VSS.n1369 VSS.n1352 3.0005
R3127 VSS.n1371 VSS.n1370 3.0005
R3128 VSS.n923 VSS.n922 3.0005
R3129 VSS.n926 VSS.n925 3.0005
R3130 VSS.n927 VSS.n909 3.0005
R3131 VSS.n929 VSS.n928 3.0005
R3132 VSS.n1342 VSS.n1341 3.0005
R3133 VSS.n1340 VSS.n427 3.0005
R3134 VSS.n1339 VSS.n1338 3.0005
R3135 VSS.n1337 VSS.n428 3.0005
R3136 VSS.n1336 VSS.n1335 3.0005
R3137 VSS.n495 VSS.n494 3.0005
R3138 VSS.n493 VSS.n492 3.0005
R3139 VSS.n491 VSS.n429 3.0005
R3140 VSS.n489 VSS.n488 3.0005
R3141 VSS.n487 VSS.n464 3.0005
R3142 VSS.n486 VSS.n485 3.0005
R3143 VSS.n484 VSS.n465 3.0005
R3144 VSS.n483 VSS.n482 3.0005
R3145 VSS.n481 VSS.n466 3.0005
R3146 VSS.n480 VSS.n479 3.0005
R3147 VSS.n478 VSS.n467 3.0005
R3148 VSS.n477 VSS.n476 3.0005
R3149 VSS.n351 VSS.n347 3.0005
R3150 VSS.n348 VSS.n1564 3.0005
R3151 VSS.n982 VSS.n565 3.0005
R3152 VSS.n983 VSS.n981 3.0005
R3153 VSS.n1287 VSS.n1286 3.0005
R3154 VSS.n563 VSS.n562 3.0005
R3155 VSS.n1082 VSS.n1081 3.0005
R3156 VSS.n1080 VSS.n1079 3.0005
R3157 VSS.n1088 VSS.n1047 3.0005
R3158 VSS.n1089 VSS.n1088 3.0005
R3159 VSS.n985 VSS.n984 3.0005
R3160 VSS.n986 VSS.n980 3.0005
R3161 VSS.n988 VSS.n987 3.0005
R3162 VSS.n989 VSS.n979 3.0005
R3163 VSS.n991 VSS.n990 3.0005
R3164 VSS.n992 VSS.n978 3.0005
R3165 VSS.n994 VSS.n993 3.0005
R3166 VSS.n996 VSS.n943 3.0005
R3167 VSS.n998 VSS.n997 3.0005
R3168 VSS.n1000 VSS.n999 3.0005
R3169 VSS.n942 VSS.n714 3.0005
R3170 VSS.n941 VSS.n940 3.0005
R3171 VSS.n939 VSS.n868 3.0005
R3172 VSS.n938 VSS.n937 3.0005
R3173 VSS.n899 VSS.n898 3.0005
R3174 VSS.n897 VSS.n870 3.0005
R3175 VSS.n896 VSS.n895 3.0005
R3176 VSS.n894 VSS.n871 3.0005
R3177 VSS.n891 VSS.n872 3.0005
R3178 VSS.n890 VSS.n889 3.0005
R3179 VSS.n888 VSS.n873 3.0005
R3180 VSS.n887 VSS.n886 3.0005
R3181 VSS.n885 VSS.n874 3.0005
R3182 VSS.n875 VSS.n884 3.0005
R3183 VSS.n893 VSS.n892 3.0005
R3184 VSS.n933 VSS.n900 3.0005
R3185 VSS.n935 VSS.n934 3.0005
R3186 VSS.n932 VSS.n931 3.0005
R3187 VSS.n1030 VSS.n1029 3.0005
R3188 VSS.n708 VSS.n707 3.0005
R3189 VSS.n880 VSS.n879 3.0005
R3190 VSS.n882 VSS.n881 3.0005
R3191 VSS.n876 VSS.n878 3.0005
R3192 VSS.n883 VSS.n877 3.0005
R3193 VSS.n903 VSS.n509 3.0005
R3194 VSS.n905 VSS.n904 3.0005
R3195 VSS.n906 VSS.n902 3.0005
R3196 VSS.n908 VSS.n907 3.0005
R3197 VSS.n1314 VSS.n1313 3.0005
R3198 VSS.n1312 VSS.n510 3.0005
R3199 VSS.n1303 VSS.n513 3.0005
R3200 VSS.n1305 VSS.n1304 3.0005
R3201 VSS.n1306 VSS.n512 3.0005
R3202 VSS.n1308 VSS.n1307 3.0005
R3203 VSS.n1309 VSS.n511 3.0005
R3204 VSS.n1311 VSS.n1310 3.0005
R3205 VSS.n1302 VSS.n1301 3.0005
R3206 VSS.n1299 VSS.n1298 3.0005
R3207 VSS.n1299 VSS.n517 3.0005
R3208 VSS.n1294 VSS.n1293 3.0005
R3209 VSS.n1289 VSS.n554 3.0005
R3210 VSS.n1291 VSS.n1290 3.0005
R3211 VSS.n1292 VSS.n552 3.0005
R3212 VSS.n1389 VSS.n1388 3.0005
R3213 VSS.n1387 VSS.n421 3.0005
R3214 VSS.n1386 VSS.n1385 3.0005
R3215 VSS.n1384 VSS.n422 3.0005
R3216 VSS.n1383 VSS.n1382 3.0005
R3217 VSS.n1446 VSS.n1445 3.0005
R3218 VSS.n1444 VSS.n1390 3.0005
R3219 VSS.n1435 VSS.n1393 3.0005
R3220 VSS.n1437 VSS.n1436 3.0005
R3221 VSS.n1438 VSS.n1392 3.0005
R3222 VSS.n1440 VSS.n1439 3.0005
R3223 VSS.n1441 VSS.n1391 3.0005
R3224 VSS.n1443 VSS.n1442 3.0005
R3225 VSS.n1434 VSS.n1433 3.0005
R3226 VSS.n1431 VSS.n1430 3.0005
R3227 VSS.n1431 VSS.n1397 3.0005
R3228 VSS.n1559 VSS.n1558 3.0005
R3229 VSS.n1560 VSS.n353 3.0005
R3230 VSS.n1562 VSS.n1561 3.0005
R3231 VSS.n1553 VSS.n356 3.0005
R3232 VSS.n1549 VSS.n359 3.0005
R3233 VSS.n1551 VSS.n1550 3.0005
R3234 VSS.n1555 VSS.n1554 3.0005
R3235 VSS.n1546 VSS.n361 3.0005
R3236 VSS.n1545 VSS.n1544 3.0005
R3237 VSS.n1158 VSS.n679 3.0005
R3238 VSS.n1153 VSS.n678 3.0005
R3239 VSS.n1145 VSS.n1144 3.0005
R3240 VSS.n1141 VSS.n1140 3.0005
R3241 VSS.n1129 VSS.n686 3.0005
R3242 VSS.n1124 VSS.n685 3.0005
R3243 VSS.n1152 VSS.n1151 3.0005
R3244 VSS.n1157 VSS.n1156 3.0005
R3245 VSS.n1142 VSS.n681 3.0005
R3246 VSS.n1120 VSS.n1119 3.0005
R3247 VSS.n1118 VSS.n688 3.0005
R3248 VSS.n1117 VSS.n1116 3.0005
R3249 VSS.n1121 VSS.n687 3.0005
R3250 VSS.n1123 VSS.n1122 3.0005
R3251 VSS.n1126 VSS.n683 3.0005
R3252 VSS.n1128 VSS.n1127 3.0005
R3253 VSS.n92 VSS.n91 3.0005
R3254 VSS.n1131 VSS.n1130 3.0005
R3255 VSS.n1621 VSS.n92 3.0005
R3256 VSS.n1115 VSS.n1114 3.0005
R3257 VSS.n1113 VSS.n690 3.0005
R3258 VSS.n1112 VSS.n1111 3.0005
R3259 VSS.n1110 VSS.n691 3.0005
R3260 VSS.n1109 VSS.n1108 3.0005
R3261 VSS.n1107 VSS.n692 3.0005
R3262 VSS.n1106 VSS.n1105 3.0005
R3263 VSS.n1104 VSS.n693 3.0005
R3264 VSS.n1103 VSS.n1102 3.0005
R3265 VSS.n1101 VSS.n694 3.0005
R3266 VSS.n696 VSS.n1100 3.0005
R3267 VSS.n1099 VSS.n697 3.0005
R3268 VSS.n695 VSS.n698 3.0005
R3269 VSS.n1098 VSS.n1097 3.0005
R3270 VSS.n1096 VSS.n699 3.0005
R3271 VSS.n1094 VSS.n1093 3.0005
R3272 VSS.n1044 VSS.n701 3.0005
R3273 VSS.n1043 VSS.n1042 3.0005
R3274 VSS.n1041 VSS.n702 3.0005
R3275 VSS.n1040 VSS.n1039 3.0005
R3276 VSS.n1038 VSS.n703 3.0005
R3277 VSS.n1037 VSS.n1036 3.0005
R3278 VSS.n1035 VSS.n704 3.0005
R3279 VSS.n1034 VSS.n1033 3.0005
R3280 VSS.n1032 VSS.n705 3.0005
R3281 VSS.n1045 VSS.n700 3.0005
R3282 VSS.n1135 VSS.t219 2.91522
R3283 VSS.n1161 VSS.t211 2.91522
R3284 VSS.n1616 VSS.t207 2.91522
R3285 VSS.n1146 VSS.t215 2.91522
R3286 VSS.n1281 VSS.t74 2.90868
R3287 VSS.n53 VSS.n233 2.88049
R3288 VSS.n35 VSS.n34 1.21839
R3289 VSS.n1136 VSS.t218 2.83383
R3290 VSS.n1162 VSS.t210 2.83383
R3291 VSS.n1617 VSS.t206 2.83383
R3292 VSS.n1147 VSS.t214 2.83383
R3293 VSS.n1260 VSS.n17 1.47016
R3294 VSS.n53 VSS.n264 2.82294
R3295 VSS.t336 VSS.t256 2.79553
R3296 VSS.t267 VSS.t257 2.79553
R3297 VSS.t265 VSS.t259 2.79553
R3298 VSS.n745 VSS.t271 2.79553
R3299 VSS.t271 VSS.t263 2.79553
R3300 VSS.t201 VSS.t197 2.79553
R3301 VSS.t330 VSS.t353 2.79553
R3302 VSS.t354 VSS.t356 2.79553
R3303 VSS.t366 VSS.t358 2.79553
R3304 VSS.n1238 VSS.t364 2.79553
R3305 VSS.t364 VSS.t362 2.79553
R3306 VSS.t181 VSS.t185 2.79553
R3307 VSS.t309 VSS.t401 2.79553
R3308 VSS.t310 VSS.t318 2.79553
R3309 VSS.t314 VSS.t320 2.79553
R3310 VSS.t324 VSS.n126 2.79553
R3311 VSS.t312 VSS.t324 2.79553
R3312 VSS.t173 VSS.t177 2.79553
R3313 VSS.t370 VSS.t292 2.79553
R3314 VSS.t301 VSS.t293 2.79553
R3315 VSS.t303 VSS.t297 2.79553
R3316 VSS.n627 VSS.t307 2.79553
R3317 VSS.t307 VSS.t295 2.79553
R3318 VSS.t193 VSS.t189 2.79553
R3319 VSS.n553 VSS.t50 2.67038
R3320 VSS.t41 VSS.t162 2.6446
R3321 VSS.t40 VSS.t469 2.6446
R3322 VSS.t38 VSS.t467 2.6446
R3323 VSS.n553 VSS.t247 2.61972
R3324 VSS.n684 VSS.t375 2.5005
R3325 VSS.n1261 VSS.t274 2.5005
R3326 VSS.n1614 VSS.t343 2.5005
R3327 VSS.n676 VSS.t244 2.5005
R3328 VSS.n1278 VSS.n568 2.49323
R3329 VSS.n1134 VSS.n684 2.33525
R3330 VSS.n1262 VSS.n1261 2.25367
R3331 VSS.n475 VSS.n352 2.2505
R3332 VSS.n1284 VSS.n564 2.2505
R3333 VSS.n1027 VSS.n706 2.2505
R3334 VSS.n1329 VSS.n1328 2.2505
R3335 VSS.n1461 VSS.n1460 2.2505
R3336 VSS.n1548 VSS.n1547 2.2505
R3337 VSS.n1615 VSS.n1614 2.206
R3338 VSS.n677 VSS.n676 2.11067
R3339 VSS.n977 VSS.n976 2.0165
R3340 VSS.n463 VSS.n462 2.0165
R3341 VSS.n406 VSS.n405 2.0165
R3342 VSS.n63 VSS.n860 1.56074
R3343 VSS.n63 VSS.n62 1.13903
R3344 VSS.n740 VSS.t261 1.86385
R3345 VSS.n1243 VSS.t360 1.86385
R3346 VSS.t316 VSS.n106 1.86385
R3347 VSS.n632 VSS.t299 1.86385
R3348 VSS.n620 VSS.n263 1.86385
R3349 VSS.n1485 VSS.t466 1.85137
R3350 VSS.n839 VSS.n60 1.69201
R3351 VSS.n1092 VSS.n1091 1.64855
R3352 VSS.n515 VSS.n514 1.64855
R3353 VSS.n1395 VSS.n1394 1.64855
R3354 VSS.n1567 VSS.t249 1.59658
R3355 VSS.n1483 VSS.n410 1.58696
R3356 VSS.n33 VSS.n1575 1.52196
R3357 VSS.n1091 VSS.n1090 1.5005
R3358 VSS.n516 VSS.n515 1.5005
R3359 VSS.n1396 VSS.n1395 1.5005
R3360 VSS.n1150 VSS.n680 1.5005
R3361 VSS.n1139 VSS.n682 1.5005
R3362 VSS.n1160 VSS.n1159 1.5005
R3363 VSS.n666 VSS.n665 1.48633
R3364 VSS.n817 VSS.n816 1.40627
R3365 VSS.n62 VSS.n60 1.3634
R3366 VSS.n1165 VSS.n26 1.09024
R3367 VSS.n658 VSS.n580 1.27768
R3368 VSS.n674 VSS.n264 1.26934
R3369 VSS.n1292 VSS.n1291 1.2658
R3370 VSS.n1290 VSS.n552 1.2658
R3371 VSS.n33 VSS.n34 1.26258
R3372 VSS.n546 VSS.n545 1.2585
R3373 VSS.n1425 VSS.n1424 1.2585
R3374 VSS.n367 VSS.n366 1.2585
R3375 VSS.n560 VSS.n559 1.2585
R3376 VSS.n1054 VSS.n1053 1.2585
R3377 VSS.n473 VSS.n472 1.2585
R3378 VSS.n832 VSS.n753 1.23682
R3379 VSS.n25 VSS.n1233 0.936035
R3380 VSS.n674 VSS.n233 1.21566
R3381 VSS.n832 VSS.n831 1.16614
R3382 VSS.n659 VSS.n658 1.12209
R3383 VSS.n974 VSS.n973 1.0935
R3384 VSS.n972 VSS.n958 1.0935
R3385 VSS.n460 VSS.n459 1.0935
R3386 VSS.n458 VSS.n444 1.0935
R3387 VSS.n403 VSS.n402 1.0935
R3388 VSS.n401 VSS.n387 1.0935
R3389 VSS.n18 VSS.n1576 23.127
R3390 VSS.n1562 VSS.n353 0.986338
R3391 VSS.n1561 VSS.n1560 0.986338
R3392 VSS.n976 VSS.n944 0.9645
R3393 VSS.n462 VSS.n430 0.9645
R3394 VSS.n405 VSS.n373 0.9645
R3395 VSS.n740 VSS.t269 0.932177
R3396 VSS.n1243 VSS.t368 0.932177
R3397 VSS.t322 VSS.n106 0.932177
R3398 VSS.n632 VSS.t305 0.932177
R3399 VSS.n1558 VSS.n353 0.82223
R3400 VSS.n1560 VSS.n1559 0.82223
R3401 VSS.n755 VSS.n62 0.820917
R3402 VSS.n1613 VSS.n34 0.820917
R3403 VSS.n675 VSS.n674 0.820917
R3404 VSS.n1293 VSS.n1292 0.813311
R3405 VSS.n1294 VSS.n552 0.813311
R3406 VSS.n1563 VSS.n1562 0.797575
R3407 VSS.n1561 VSS.n350 0.797575
R3408 VSS.n1006 VSS.n711 0.736079
R3409 VSS.t176 VSS.n2 15.0154
R3410 VSS.n665 VSS.n664 0.705065
R3411 VSS.n816 VSS.n815 0.695038
R3412 VSS.n1012 VSS.n1011 0.684547
R3413 VSS.n1009 VSS.n1008 0.684547
R3414 VSS.n1016 VSS.n1015 0.684547
R3415 VSS.n506 VSS.n505 0.684547
R3416 VSS.n503 VSS.n502 0.684547
R3417 VSS.n1325 VSS.n1324 0.684547
R3418 VSS.n418 VSS.n417 0.684547
R3419 VSS.n415 VSS.n414 0.684547
R3420 VSS.n1457 VSS.n1456 0.684547
R3421 VSS.n1160 VSS.n679 0.6814
R3422 VSS.n1159 VSS.n1158 0.6814
R3423 VSS.n1320 VSS.n1319 0.653499
R3424 VSS.n1452 VSS.n1451 0.653499
R3425 VSS.n1022 VSS.n1021 0.653499
R3426 VSS.n971 VSS.n970 0.653499
R3427 VSS.n957 VSS.n956 0.653499
R3428 VSS.n457 VSS.n456 0.653499
R3429 VSS.n443 VSS.n442 0.653499
R3430 VSS.n400 VSS.n399 0.653499
R3431 VSS.n386 VSS.n385 0.653499
R3432 VSS.n1023 VSS.n706 0.628233
R3433 VSS.n1328 VSS.n1327 0.628233
R3434 VSS.n1460 VSS.n1459 0.628233
R3435 VSS.n1546 VSS.n1545 0.608218
R3436 VSS.n1544 VSS.n361 0.608218
R3437 VSS.n1544 VSS.n1543 0.602006
R3438 VSS.n1025 VSS.n1017 0.5943
R3439 VSS.n1326 VSS.n1322 0.5943
R3440 VSS.n1458 VSS.n1454 0.5943
R3441 VSS.n1606 VSS.n3 0.586707
R3442 VSS.n1026 VSS.n1013 0.57082
R3443 VSS.n508 VSS.n507 0.57082
R3444 VSS.n420 VSS.n419 0.57082
R3445 VSS.n1545 VSS.n369 0.558006
R3446 VSS.n1311 VSS.n511 0.527465
R3447 VSS.n1310 VSS.n1309 0.527465
R3448 VSS.n1443 VSS.n1391 0.527465
R3449 VSS.n1442 VSS.n1441 0.527465
R3450 VSS.n1028 VSS.n705 0.524359
R3451 VSS.n1032 VSS.n1031 0.524359
R3452 VSS.n1151 VSS.n678 0.521533
R3453 VSS.n1153 VSS.n1152 0.521533
R3454 VSS.n1526 VSS.n1525 0.503135
R3455 VSS.n1524 VSS.n1513 0.503135
R3456 VSS.n755 VSS.n684 0.491833
R3457 VSS.n1261 VSS.n1260 0.491833
R3458 VSS.n1614 VSS.n1613 0.491833
R3459 VSS.n676 VSS.n675 0.491833
R3460 VSS.n938 VSS.n869 0.485535
R3461 VSS.n937 VSS.n936 0.485535
R3462 VSS.n1105 VSS.n692 0.473629
R3463 VSS.n1107 VSS.n1106 0.473629
R3464 VSS.n1111 VSS.n1110 0.461724
R3465 VSS.n1112 VSS.n691 0.461724
R3466 VSS.n1131 VSS.n685 0.4614
R3467 VSS.n1130 VSS.n1124 0.4614
R3468 VSS.n1145 VSS.n681 0.459933
R3469 VSS.n1144 VSS.n1142 0.459933
R3470 VSS.n1307 VSS.n1306 0.446194
R3471 VSS.n1308 VSS.n512 0.446194
R3472 VSS.n1439 VSS.n1438 0.446194
R3473 VSS.n1440 VSS.n1392 0.446194
R3474 VSS.n1140 VSS.n681 0.441967
R3475 VSS.n1142 VSS.n1141 0.441967
R3476 VSS.n1160 VSS.n678 0.439033
R3477 VSS.n1026 VSS.n1025 0.436467
R3478 VSS.n1322 VSS.n508 0.436467
R3479 VSS.n1454 VSS.n420 0.436467
R3480 VSS.n1122 VSS.n685 0.436467
R3481 VSS.n1124 VSS.n1123 0.436467
R3482 VSS.n1127 VSS.n683 0.429133
R3483 VSS.n1128 VSS.n1126 0.429133
R3484 VSS.n1293 VSS.n551 0.425635
R3485 VSS.n1295 VSS.n1294 0.425635
R3486 VSS.n802 VSS.n801 0.420944
R3487 VSS.n803 VSS.n802 0.420944
R3488 VSS.n784 VSS.n783 0.420944
R3489 VSS.n785 VSS.n784 0.420944
R3490 VSS.n1206 VSS.n1205 0.420944
R3491 VSS.n1207 VSS.n1206 0.420944
R3492 VSS.n1227 VSS.n1226 0.420944
R3493 VSS.n1228 VSS.n1227 0.420944
R3494 VSS.n100 VSS.n99 0.420944
R3495 VSS.n101 VSS.n100 0.420944
R3496 VSS.n97 VSS.n96 0.420944
R3497 VSS.n98 VSS.n97 0.420944
R3498 VSS.n612 VSS.n611 0.420944
R3499 VSS.n613 VSS.n612 0.420944
R3500 VSS.n594 VSS.n593 0.420944
R3501 VSS.n595 VSS.n594 0.420944
R3502 VSS.n1156 VSS.n679 0.4185
R3503 VSS.n1158 VSS.n1157 0.4185
R3504 VSS.n1111 VSS.n690 0.4141
R3505 VSS.n1113 VSS.n1112 0.4141
R3506 VSS.n1364 VSS.n1363 0.406853
R3507 VSS.n1564 VSS.n351 0.3965
R3508 VSS.n1301 VSS.n1300 0.3943
R3509 VSS.n1302 VSS.n514 0.3943
R3510 VSS.n1433 VSS.n1432 0.3943
R3511 VSS.n1434 VSS.n1394 0.3943
R3512 VSS.n1048 VSS.n700 0.3943
R3513 VSS.n1045 VSS.n1092 0.3943
R3514 VSS.n840 VSS.n839 0.391377
R3515 VSS.n1115 VSS.n690 0.388735
R3516 VSS.n1114 VSS.n1113 0.388735
R3517 VSS.n1103 VSS.n694 0.381488
R3518 VSS.n1102 VSS.n1101 0.381488
R3519 VSS.n1527 VSS.n1526 0.380453
R3520 VSS.n1528 VSS.n1513 0.380453
R3521 VSS.n672 VSS.n671 0.374678
R3522 VSS.n858 VSS.n857 0.374678
R3523 VSS.n1104 VSS.n1103 0.372171
R3524 VSS.n1102 VSS.n693 0.372171
R3525 VSS.n1025 VSS.n1024 0.3655
R3526 VSS.n1322 VSS.n1321 0.3655
R3527 VSS.n1454 VSS.n1453 0.3655
R3528 VSS.n1531 VSS.n1512 0.365441
R3529 VSS.n1530 VSS.n1529 0.365441
R3530 VSS.n1127 VSS.n686 0.3624
R3531 VSS.n1129 VSS.n1128 0.3624
R3532 VSS.n1532 VSS.n1531 0.362335
R3533 VSS.n1530 VSS.n1511 0.362335
R3534 VSS.n1286 VSS.n563 0.361818
R3535 VSS.n1287 VSS.n562 0.361818
R3536 VSS.n1149 VSS.n677 0.353417
R3537 VSS.n973 VSS.n959 0.3525
R3538 VSS.n974 VSS.n946 0.3525
R3539 VSS.n958 VSS.n948 0.3525
R3540 VSS.n948 VSS.n947 0.3525
R3541 VSS.n972 VSS.n962 0.3525
R3542 VSS.n962 VSS.n961 0.3525
R3543 VSS.n459 VSS.n445 0.3525
R3544 VSS.n460 VSS.n432 0.3525
R3545 VSS.n444 VSS.n434 0.3525
R3546 VSS.n434 VSS.n433 0.3525
R3547 VSS.n458 VSS.n448 0.3525
R3548 VSS.n448 VSS.n447 0.3525
R3549 VSS.n402 VSS.n388 0.3525
R3550 VSS.n403 VSS.n375 0.3525
R3551 VSS.n387 VSS.n377 0.3525
R3552 VSS.n377 VSS.n376 0.3525
R3553 VSS.n401 VSS.n391 0.3525
R3554 VSS.n391 VSS.n390 0.3525
R3555 VSS.n882 VSS.n879 0.350947
R3556 VSS.n881 VSS.n880 0.350947
R3557 VSS.n904 VSS.n902 0.350947
R3558 VSS.n906 VSS.n905 0.350947
R3559 VSS.n1387 VSS.n1386 0.350947
R3560 VSS.n1385 VSS.n421 0.350947
R3561 VSS.n478 VSS.n477 0.349394
R3562 VSS.n981 VSS.n565 0.349394
R3563 VSS.n983 VSS.n982 0.349394
R3564 VSS.n476 VSS.n467 0.349394
R3565 VSS.n1362 VSS.n1361 0.345771
R3566 VSS.n1341 VSS.n1340 0.345771
R3567 VSS.n1342 VSS.n427 0.345771
R3568 VSS.n1363 VSS.n1355 0.345771
R3569 VSS.n1097 VSS.n1096 0.344218
R3570 VSS.n1098 VSS.n699 0.344218
R3571 VSS.n1373 VSS.n1350 0.338006
R3572 VSS.n922 VSS.n910 0.338006
R3573 VSS.n1375 VSS.n1374 0.338006
R3574 VSS.n924 VSS.n923 0.338006
R3575 VSS.n1549 VSS.n1548 0.337405
R3576 VSS.n349 VSS.n348 0.334722
R3577 VSS.n1623 VSS.n93 0.333347
R3578 VSS.n1622 VSS.n94 0.333347
R3579 VSS.n1502 VSS.n1501 0.328171
R3580 VSS.n483 VSS.n466 0.328171
R3581 VSS.n988 VSS.n980 0.328171
R3582 VSS.n987 VSS.n986 0.328171
R3583 VSS.n482 VSS.n481 0.328171
R3584 VSS.n1500 VSS.n370 0.328171
R3585 VSS.n1361 VSS.n1360 0.326618
R3586 VSS.n1340 VSS.n1339 0.326618
R3587 VSS.n939 VSS.n938 0.326618
R3588 VSS.n937 VSS.n868 0.326618
R3589 VSS.n1338 VSS.n427 0.326618
R3590 VSS.n1359 VSS.n1355 0.326618
R3591 VSS.n930 VSS.n908 0.3261
R3592 VSS.n907 VSS.n901 0.3261
R3593 VSS.n1558 VSS.n1557 0.324554
R3594 VSS.n1559 VSS.n354 0.324554
R3595 VSS.n1100 VSS.n694 0.323512
R3596 VSS.n1101 VSS.n696 0.323512
R3597 VSS.n1509 VSS.n1508 0.322476
R3598 VSS.n1538 VSS.n1507 0.322476
R3599 VSS.n1121 VSS.n1120 0.3217
R3600 VSS.n1154 VSS.n1153 0.3217
R3601 VSS.n1119 VSS.n687 0.3217
R3602 VSS.n1501 VSS.n371 0.321441
R3603 VSS.n1500 VSS.n1499 0.321441
R3604 VSS.n1100 VSS.n1099 0.321441
R3605 VSS.n697 VSS.n696 0.321441
R3606 VSS.n823 VSS.n822 0.316378
R3607 VSS.n1373 VSS.n1372 0.315229
R3608 VSS.n922 VSS.n913 0.315229
R3609 VSS.n879 VSS.n707 0.315229
R3610 VSS.n880 VSS.n708 0.315229
R3611 VSS.n904 VSS.n903 0.315229
R3612 VSS.n905 VSS.n509 0.315229
R3613 VSS.n1374 VSS.n1351 0.315229
R3614 VSS.n923 VSS.n911 0.315229
R3615 VSS.n1388 VSS.n1387 0.315229
R3616 VSS.n1389 VSS.n421 0.315229
R3617 VSS.n825 VSS.n824 0.312698
R3618 VSS.n821 VSS.n820 0.312698
R3619 VSS.n670 VSS.n669 0.312698
R3620 VSS.n667 VSS.n666 0.312698
R3621 VSS.n842 VSS.n841 0.312698
R3622 VSS.n850 VSS.n849 0.312698
R3623 VSS.n859 VSS.n858 0.312698
R3624 VSS.n825 VSS.n754 0.312358
R3625 VSS.n824 VSS.n823 0.312358
R3626 VSS.n820 VSS.n819 0.312358
R3627 VSS.n671 VSS.n41 0.435981
R3628 VSS.n669 VSS.n668 0.312358
R3629 VSS.n841 VSS.n840 0.312358
R3630 VSS.n849 VSS.n848 0.312358
R3631 VSS.n857 VSS.n856 0.312358
R3632 VSS.n477 VSS.n475 0.312124
R3633 VSS.n1284 VSS.n565 0.312124
R3634 VSS.n982 VSS.n564 0.312124
R3635 VSS.n476 VSS.n352 0.312124
R3636 VSS.n1547 VSS.n1546 0.312124
R3637 VSS.n1548 VSS.n361 0.312124
R3638 VSS.n1503 VSS.n1502 0.309535
R3639 VSS.n479 VSS.n466 0.309535
R3640 VSS.n984 VSS.n980 0.309535
R3641 VSS.n986 VSS.n985 0.309535
R3642 VSS.n481 VSS.n480 0.309535
R3643 VSS.n1504 VSS.n370 0.309535
R3644 VSS.n1307 VSS.n511 0.307465
R3645 VSS.n1309 VSS.n1308 0.307465
R3646 VSS.n1439 VSS.n1391 0.307465
R3647 VSS.n1441 VSS.n1440 0.307465
R3648 VSS.n1094 VSS.n701 0.301771
R3649 VSS.n1093 VSS.n1044 0.301771
R3650 VSS.n1312 VSS.n1311 0.300735
R3651 VSS.n1310 VSS.n510 0.300735
R3652 VSS.n1444 VSS.n1443 0.300735
R3653 VSS.n1442 VSS.n1390 0.300735
R3654 VSS.n1122 VSS.n1121 0.300067
R3655 VSS.n1123 VSS.n687 0.300067
R3656 VSS.n1497 VSS.n371 0.296076
R3657 VSS.n489 VSS.n464 0.296076
R3658 VSS.n994 VSS.n978 0.296076
R3659 VSS.n993 VSS.n992 0.296076
R3660 VSS.n488 VSS.n487 0.296076
R3661 VSS.n1499 VSS.n1498 0.296076
R3662 VSS.n1109 VSS.n692 0.295041
R3663 VSS.n1108 VSS.n1107 0.295041
R3664 VSS.n484 VSS.n483 0.294524
R3665 VSS.n989 VSS.n988 0.294524
R3666 VSS.n987 VSS.n979 0.294524
R3667 VSS.n482 VSS.n465 0.294524
R3668 VSS.n1305 VSS.n513 0.292453
R3669 VSS.n1304 VSS.n1303 0.292453
R3670 VSS.n1382 VSS.n422 0.292453
R3671 VSS.n1437 VSS.n1393 0.292453
R3672 VSS.n1436 VSS.n1435 0.292453
R3673 VSS.n1384 VSS.n1383 0.292453
R3674 VSS.n1151 VSS.n1150 0.292367
R3675 VSS.n1152 VSS.n680 0.292367
R3676 VSS.n890 VSS.n873 0.290278
R3677 VSS.n889 VSS.n888 0.290278
R3678 VSS.n485 VSS.n484 0.287794
R3679 VSS.n990 VSS.n989 0.287794
R3680 VSS.n991 VSS.n979 0.287794
R3681 VSS.n486 VSS.n465 0.287794
R3682 VSS.n1139 VSS.n683 0.287233
R3683 VSS.n1306 VSS.n1305 0.286241
R3684 VSS.n1304 VSS.n512 0.286241
R3685 VSS.n1438 VSS.n1437 0.286241
R3686 VSS.n1436 VSS.n1392 0.286241
R3687 VSS.n368 VSS.n359 0.284087
R3688 VSS.n1347 VSS.n1346 0.2821
R3689 VSS.n1348 VSS.n424 0.2821
R3690 VSS.n1366 VSS.n1365 0.281582
R3691 VSS.n917 VSS.n916 0.281582
R3692 VSS.n1364 VSS.n1353 0.281582
R3693 VSS.n915 VSS.n426 0.281582
R3694 VSS.n999 VSS.n942 0.281453
R3695 VSS.n1336 VSS.n494 0.281453
R3696 VSS.n1492 VSS.n407 0.281453
R3697 VSS.n1378 VSS.n1377 0.275371
R3698 VSS.n927 VSS.n926 0.275371
R3699 VSS.n1376 VSS.n1349 0.275371
R3700 VSS.n925 VSS.n909 0.275371
R3701 VSS.n1377 VSS.n1350 0.273818
R3702 VSS.n926 VSS.n910 0.273818
R3703 VSS.n1376 VSS.n1375 0.273818
R3704 VSS.n925 VSS.n924 0.273818
R3705 VSS.n891 VSS.n890 0.270722
R3706 VSS.n889 VSS.n872 0.270722
R3707 VSS.n876 VSS.n882 0.270712
R3708 VSS.n881 VSS.n878 0.270712
R3709 VSS.n908 VSS.n902 0.270712
R3710 VSS.n907 VSS.n906 0.270712
R3711 VSS.n1386 VSS.n422 0.270712
R3712 VSS.n1385 VSS.n1384 0.270712
R3713 VSS.n479 VSS.n478 0.267606
R3714 VSS.n984 VSS.n983 0.267606
R3715 VSS.n985 VSS.n981 0.267606
R3716 VSS.n480 VSS.n467 0.267606
R3717 VSS.n1110 VSS.n1109 0.267606
R3718 VSS.n1108 VSS.n691 0.267606
R3719 VSS.n1365 VSS.n1354 0.267088
R3720 VSS.n916 VSS.n425 0.267088
R3721 VSS.n1343 VSS.n426 0.267088
R3722 VSS.n22 VSS.n1165 0.822755
R3723 VSS.n1550 VSS.n356 0.260056
R3724 VSS.n485 VSS.n464 0.256735
R3725 VSS.n990 VSS.n978 0.256735
R3726 VSS.n992 VSS.n991 0.256735
R3727 VSS.n487 VSS.n486 0.256735
R3728 VSS.n1521 VSS.n1514 0.2557
R3729 VSS.n1523 VSS.n1522 0.2557
R3730 VSS.n1120 VSS.n688 0.255333
R3731 VSS.n1119 VSS.n1118 0.255333
R3732 VSS.n1285 VSS.n1284 0.255182
R3733 VSS.n1563 VSS.n352 0.255182
R3734 VSS.n851 VSS.n850 0.254017
R3735 VSS.n852 VSS.n851 0.254017
R3736 VSS.n1346 VSS.n1345 0.253629
R3737 VSS.n1344 VSS.n424 0.253629
R3738 VSS.n822 VSS.n821 0.250378
R3739 VSS.n819 VSS.n818 0.250378
R3740 VSS.n818 VSS.n817 0.250378
R3741 VSS.n668 VSS.n667 0.250378
R3742 VSS.n843 VSS.n842 0.250378
R3743 VSS.n844 VSS.n843 0.250378
R3744 VSS.n845 VSS.n844 0.250378
R3745 VSS.n846 VSS.n845 0.250378
R3746 VSS.n847 VSS.n846 0.250378
R3747 VSS.n848 VSS.n847 0.250378
R3748 VSS.n853 VSS.n852 0.250378
R3749 VSS.n854 VSS.n853 0.250378
R3750 VSS.n855 VSS.n854 0.250378
R3751 VSS.n856 VSS.n855 0.250378
R3752 VSS.n860 VSS.n859 0.250378
R3753 VSS.n1296 VSS.n347 0.248332
R3754 VSS.n550 VSS.n351 0.248332
R3755 VSS.n999 VSS.n998 0.2469
R3756 VSS.n494 VSS.n493 0.2469
R3757 VSS.n1493 VSS.n1492 0.2469
R3758 VSS.n1516 VSS.n93 0.244829
R3759 VSS.n1517 VSS.n94 0.244829
R3760 VSS.n1042 VSS.n1041 0.244829
R3761 VSS.n1043 VSS.n702 0.244829
R3762 VSS.n833 VSS.n832 0.244457
R3763 VSS.n658 VSS.n657 0.244331
R3764 VSS.n898 VSS.n897 0.241833
R3765 VSS.n899 VSS.n870 0.241833
R3766 VSS.n1116 VSS.n688 0.241767
R3767 VSS.n1118 VSS.n1117 0.241767
R3768 VSS.n1301 VSS.n513 0.240688
R3769 VSS.n1303 VSS.n1302 0.240688
R3770 VSS.n1433 VSS.n1393 0.240688
R3771 VSS.n1435 VSS.n1434 0.240688
R3772 VSS.n1040 VSS.n703 0.238618
R3773 VSS.n1039 VSS.n1038 0.238618
R3774 VSS.n886 VSS.n885 0.2365
R3775 VSS.n887 VSS.n874 0.2365
R3776 VSS.n886 VSS.n873 0.235167
R3777 VSS.n888 VSS.n887 0.235167
R3778 VSS.n1089 VSS.n1055 0.233481
R3779 VSS.n547 VSS.n517 0.233481
R3780 VSS.n1426 VSS.n1397 0.233481
R3781 VSS.n1527 VSS.n1512 0.233441
R3782 VSS.n1529 VSS.n1528 0.233441
R3783 VSS.n1541 VSS.n1540 0.232406
R3784 VSS.n1539 VSS.n1505 0.232406
R3785 VSS.n1357 VSS.n1356 0.230853
R3786 VSS.n1360 VSS.n1357 0.230853
R3787 VSS.n1335 VSS.n428 0.230853
R3788 VSS.n1339 VSS.n428 0.230853
R3789 VSS.n940 VSS.n714 0.230853
R3790 VSS.n940 VSS.n939 0.230853
R3791 VSS.n942 VSS.n941 0.230853
R3792 VSS.n941 VSS.n868 0.230853
R3793 VSS.n1337 VSS.n1336 0.230853
R3794 VSS.n1338 VSS.n1337 0.230853
R3795 VSS.n1358 VSS.n407 0.230853
R3796 VSS.n1359 VSS.n1358 0.230853
R3797 VSS.n1036 VSS.n1035 0.230335
R3798 VSS.n1037 VSS.n704 0.230335
R3799 VSS.n898 VSS.n869 0.229389
R3800 VSS.n936 VSS.n899 0.229389
R3801 VSS.n1042 VSS.n701 0.228782
R3802 VSS.n1044 VSS.n1043 0.228782
R3803 VSS.n1356 VSS.n408 0.228135
R3804 VSS.n1335 VSS.n1334 0.228135
R3805 VSS.n1001 VSS.n714 0.228135
R3806 VSS.n934 VSS.n933 0.224056
R3807 VSS.n935 VSS.n900 0.224056
R3808 VSS.n1525 VSS.n1514 0.221535
R3809 VSS.n1524 VSS.n1523 0.221535
R3810 VSS.n1313 VSS.n1312 0.217394
R3811 VSS.n1314 VSS.n510 0.217394
R3812 VSS.n1445 VSS.n1444 0.217394
R3813 VSS.n1446 VSS.n1390 0.217394
R3814 VSS.n1099 VSS.n698 0.217394
R3815 VSS.n697 VSS.n695 0.217394
R3816 VSS.n1105 VSS.n1104 0.216359
R3817 VSS.n1106 VSS.n693 0.216359
R3818 VSS.n1495 VSS.n1494 0.212735
R3819 VSS.n1372 VSS.n1371 0.212735
R3820 VSS.n492 VSS.n491 0.212735
R3821 VSS.n997 VSS.n996 0.212735
R3822 VSS.n998 VSS.n943 0.212735
R3823 VSS.n493 VSS.n429 0.212735
R3824 VSS.n1370 VSS.n1351 0.212735
R3825 VSS.n921 VSS.n911 0.212735
R3826 VSS.n1493 VSS.n372 0.212735
R3827 VSS.n913 VSS.n912 0.212735
R3828 VSS.n1533 VSS.n1532 0.211182
R3829 VSS.n1534 VSS.n1511 0.211182
R3830 VSS.n1520 VSS.n1519 0.210665
R3831 VSS.n1518 VSS.n1515 0.210665
R3832 VSS.n1371 VSS.n1352 0.210147
R3833 VSS.n912 VSS.n914 0.210147
R3834 VSS.n1370 VSS.n1369 0.210147
R3835 VSS.n921 VSS.n920 0.210147
R3836 VSS.n1140 VSS.n1139 0.209867
R3837 VSS.n1141 VSS.n682 0.209867
R3838 VSS.n884 VSS.n883 0.207303
R3839 VSS.n877 VSS.n875 0.207303
R3840 VSS.n1262 VSS.n1164 0.204917
R3841 VSS.n1367 VSS.n1352 0.2029
R3842 VSS.n918 VSS.n914 0.2029
R3843 VSS.n1369 VSS.n1368 0.2029
R3844 VSS.n920 VSS.n919 0.2029
R3845 VSS.n474 VSS.n350 0.201865
R3846 VSS.n1288 VSS.n561 0.201865
R3847 VSS.n877 VSS.n876 0.201347
R3848 VSS.n883 VSS.n878 0.201347
R3849 VSS.n1552 VSS.n1551 0.198278
R3850 VSS.n993 VSS.n943 0.197724
R3851 VSS.n488 VSS.n429 0.197724
R3852 VSS.n1498 VSS.n372 0.197724
R3853 VSS.n1030 VSS.n707 0.192547
R3854 VSS.n1029 VSS.n708 0.192547
R3855 VSS.n1027 VSS.n1026 0.192267
R3856 VSS.n1329 VSS.n508 0.192267
R3857 VSS.n1461 VSS.n420 0.192267
R3858 VSS.n1285 VSS.n554 0.188392
R3859 VSS.n1289 VSS.n1288 0.188392
R3860 VSS.n1090 VSS.n1089 0.187888
R3861 VSS.n517 VSS.n516 0.187888
R3862 VSS.n1397 VSS.n1396 0.187888
R3863 VSS.n1034 VSS.n705 0.187371
R3864 VSS.n1033 VSS.n1032 0.187371
R3865 VSS.n933 VSS.n932 0.183611
R3866 VSS.n931 VSS.n900 0.183611
R3867 VSS.n892 VSS.n891 0.182722
R3868 VSS.n893 VSS.n872 0.182722
R3869 VSS.n1519 VSS.n1516 0.182712
R3870 VSS.n1518 VSS.n1517 0.182712
R3871 VSS.n1533 VSS.n1510 0.182194
R3872 VSS.n1535 VSS.n1534 0.182194
R3873 VSS.n892 VSS.n871 0.1805
R3874 VSS.n894 VSS.n893 0.1805
R3875 VSS.n1096 VSS.n1095 0.180124
R3876 VSS.n1046 VSS.n699 0.180124
R3877 VSS.n1041 VSS.n1040 0.178053
R3878 VSS.n1039 VSS.n702 0.178053
R3879 VSS.n1097 VSS.n698 0.175465
R3880 VSS.n695 VSS.n1098 0.175465
R3881 VSS.n896 VSS.n871 0.174278
R3882 VSS.n895 VSS.n894 0.174278
R3883 VSS.n1081 VSS.n1056 0.174152
R3884 VSS.n1083 VSS.n1082 0.174152
R3885 VSS.n946 VSS.n945 0.170376
R3886 VSS.n960 VSS.n959 0.170376
R3887 VSS.n432 VSS.n431 0.170376
R3888 VSS.n446 VSS.n445 0.170376
R3889 VSS.n375 VSS.n374 0.170376
R3890 VSS.n389 VSS.n388 0.170376
R3891 VSS.n1036 VSS.n703 0.169771
R3892 VSS.n1038 VSS.n1037 0.169771
R3893 VSS.n1367 VSS.n1366 0.166147
R3894 VSS.n918 VSS.n917 0.166147
R3895 VSS.n1368 VSS.n1353 0.166147
R3896 VSS.n919 VSS.n915 0.166147
R3897 VSS.n1542 VSS.n1541 0.163559
R3898 VSS.n831 VSS.n755 0.161833
R3899 VSS.n1260 VSS.n1165 0.161833
R3900 VSS.n1613 VSS.n16 0.722242
R3901 VSS.n675 VSS.n673 0.161833
R3902 VSS.n831 VSS.n754 0.158425
R3903 VSS.n673 VSS.n672 0.158425
R3904 VSS.n1379 VSS.n1378 0.157347
R3905 VSS.n928 VSS.n927 0.157347
R3906 VSS.n1380 VSS.n1349 0.157347
R3907 VSS.n929 VSS.n909 0.157347
R3908 VSS.n1087 VSS.n1086 0.156987
R3909 VSS.n1297 VSS.n549 0.156987
R3910 VSS.n548 VSS.n518 0.156987
R3911 VSS.n1429 VSS.n1428 0.156987
R3912 VSS.n1427 VSS.n355 0.156987
R3913 VSS.n1085 VSS.n1084 0.156987
R3914 VSS.n1554 VSS.n1553 0.156944
R3915 VSS.n1555 VSS.n356 0.156944
R3916 VSS.n1126 VSS.n1125 0.156883
R3917 VSS.n1138 VSS.n1134 0.152667
R3918 VSS.n1297 VSS.n1296 0.151334
R3919 VSS.n550 VSS.n518 0.151334
R3920 VSS.n1429 VSS.n357 0.151334
R3921 VSS.n1556 VSS.n355 0.151334
R3922 VSS.n1091 VSS.n1048 0.148547
R3923 VSS.n1300 VSS.n515 0.148547
R3924 VSS.n1432 VSS.n1395 0.148547
R3925 VSS.n1521 VSS.n1520 0.144924
R3926 VSS.n1522 VSS.n1515 0.144924
R3927 VSS.n1087 VSS.n1056 0.144149
R3928 VSS.n1084 VSS.n1083 0.144149
R3929 VSS.n903 VSS.n500 0.143888
R3930 VSS.n1315 VSS.n509 0.143888
R3931 VSS.n1388 VSS.n412 0.143888
R3932 VSS.n1447 VSS.n1389 0.143888
R3933 VSS.n1291 VSS.n554 0.143797
R3934 VSS.n1290 VSS.n1289 0.143797
R3935 VSS.n897 VSS.n896 0.142722
R3936 VSS.n895 VSS.n870 0.142722
R3937 VSS.n816 VSS.n718 0.142391
R3938 VSS.n1622 VSS.n1621 0.141775
R3939 VSS.n1362 VSS.n1354 0.140265
R3940 VSS.n1341 VSS.n425 0.140265
R3941 VSS.n1343 VSS.n1342 0.140265
R3942 VSS.n1543 VSS.n1505 0.139747
R3943 VSS.n1619 VSS.n1615 0.138
R3944 VSS.n1551 VSS.n359 0.136944
R3945 VSS.n1550 VSS.n1549 0.136944
R3946 VSS.n1496 VSS.n1495 0.136124
R3947 VSS.n491 VSS.n490 0.136124
R3948 VSS.n996 VSS.n995 0.136124
R3949 VSS.n885 VSS.n875 0.135167
R3950 VSS.n884 VSS.n874 0.135167
R3951 VSS.n1150 VSS.n1145 0.133967
R3952 VSS.n1508 VSS.n1537 0.131982
R3953 VSS.n1536 VSS.n1507 0.131982
R3954 VSS.n665 VSS.n50 0.131936
R3955 VSS.n1125 VSS.n682 0.13085
R3956 VSS.n1035 VSS.n1034 0.129912
R3957 VSS.n1033 VSS.n704 0.129912
R3958 VSS.n1095 VSS.n700 0.129567
R3959 VSS.n1046 VSS.n1045 0.129567
R3960 VSS.n976 VSS.n975 0.1295
R3961 VSS.n462 VSS.n461 0.1295
R3962 VSS.n405 VSS.n404 0.1295
R3963 VSS.n1086 VSS.n1057 0.129031
R3964 VSS.n1076 VSS.n1057 0.129031
R3965 VSS.n1076 VSS.n1059 0.129031
R3966 VSS.n1071 VSS.n1059 0.129031
R3967 VSS.n1071 VSS.n1061 0.129031
R3968 VSS.n1067 VSS.n1061 0.129031
R3969 VSS.n1067 VSS.n1063 0.129031
R3970 VSS.n1074 VSS.n1055 0.129031
R3971 VSS.n1075 VSS.n1074 0.129031
R3972 VSS.n1075 VSS.n1073 0.129031
R3973 VSS.n1073 VSS.n1072 0.129031
R3974 VSS.n1072 VSS.n1060 0.129031
R3975 VSS.n1066 VSS.n1060 0.129031
R3976 VSS.n1066 VSS.n1065 0.129031
R3977 VSS.n1065 VSS.n1064 0.129031
R3978 VSS.n549 VSS.n519 0.129031
R3979 VSS.n537 VSS.n519 0.129031
R3980 VSS.n537 VSS.n536 0.129031
R3981 VSS.n536 VSS.n535 0.129031
R3982 VSS.n535 VSS.n523 0.129031
R3983 VSS.n529 VSS.n523 0.129031
R3984 VSS.n548 VSS.n520 0.129031
R3985 VSS.n538 VSS.n520 0.129031
R3986 VSS.n538 VSS.n522 0.129031
R3987 VSS.n534 VSS.n522 0.129031
R3988 VSS.n534 VSS.n524 0.129031
R3989 VSS.n530 VSS.n524 0.129031
R3990 VSS.n530 VSS.n526 0.129031
R3991 VSS.n547 VSS.n540 0.129031
R3992 VSS.n540 VSS.n539 0.129031
R3993 VSS.n539 VSS.n521 0.129031
R3994 VSS.n533 VSS.n521 0.129031
R3995 VSS.n533 VSS.n532 0.129031
R3996 VSS.n532 VSS.n531 0.129031
R3997 VSS.n531 VSS.n525 0.129031
R3998 VSS.n527 VSS.n525 0.129031
R3999 VSS.n1428 VSS.n1398 0.129031
R4000 VSS.n1416 VSS.n1398 0.129031
R4001 VSS.n1416 VSS.n1415 0.129031
R4002 VSS.n1415 VSS.n1414 0.129031
R4003 VSS.n1414 VSS.n1402 0.129031
R4004 VSS.n1408 VSS.n1402 0.129031
R4005 VSS.n1427 VSS.n1399 0.129031
R4006 VSS.n1417 VSS.n1399 0.129031
R4007 VSS.n1417 VSS.n1401 0.129031
R4008 VSS.n1413 VSS.n1401 0.129031
R4009 VSS.n1413 VSS.n1403 0.129031
R4010 VSS.n1409 VSS.n1403 0.129031
R4011 VSS.n1409 VSS.n1405 0.129031
R4012 VSS.n1426 VSS.n1419 0.129031
R4013 VSS.n1419 VSS.n1418 0.129031
R4014 VSS.n1418 VSS.n1400 0.129031
R4015 VSS.n1412 VSS.n1400 0.129031
R4016 VSS.n1412 VSS.n1411 0.129031
R4017 VSS.n1411 VSS.n1410 0.129031
R4018 VSS.n1410 VSS.n1404 0.129031
R4019 VSS.n1406 VSS.n1404 0.129031
R4020 VSS.n1085 VSS.n1078 0.129031
R4021 VSS.n1078 VSS.n1077 0.129031
R4022 VSS.n1077 VSS.n1058 0.129031
R4023 VSS.n1070 VSS.n1058 0.129031
R4024 VSS.n1070 VSS.n1069 0.129031
R4025 VSS.n1069 VSS.n1068 0.129031
R4026 VSS.n1624 VSS.n1623 0.128359
R4027 VSS.n1491 VSS.n1490 0.126806
R4028 VSS.n495 VSS.n411 0.126806
R4029 VSS.n1000 VSS.n867 0.126806
R4030 VSS.n1143 VSS.n680 0.1204
R4031 VSS.n1159 VSS.n1154 0.117833
R4032 VSS.n1539 VSS.n1538 0.116971
R4033 VSS.n1081 VSS.n1080 0.115418
R4034 VSS.n1082 VSS.n1079 0.115418
R4035 VSS.n1156 VSS.n91 0.109767
R4036 VSS.n1116 VSS.n1115 0.106661
R4037 VSS.n1088 VSS.n1087 0.103519
R4038 VSS.n1084 VSS.n1047 0.103519
R4039 VSS.n1299 VSS.n518 0.103519
R4040 VSS.n1298 VSS.n1297 0.103519
R4041 VSS.n1431 VSS.n355 0.103519
R4042 VSS.n1430 VSS.n1429 0.103519
R4043 VSS.n1540 VSS.n1506 0.102218
R4044 VSS.n1080 VSS.n563 0.100406
R4045 VSS.n1131 VSS.n686 0.0991333
R4046 VSS.n1130 VSS.n1129 0.0991333
R4047 VSS.n1345 VSS.n425 0.0983353
R4048 VSS.n1344 VSS.n1343 0.0983353
R4049 VSS.n1286 VSS.n1285 0.0962647
R4050 VSS.n1288 VSS.n1287 0.0962647
R4051 VSS.n1537 VSS.n1510 0.0952294
R4052 VSS.n1536 VSS.n1535 0.0952294
R4053 VSS.n344 VSS.n56 0.0926069
R4054 VSS.n37 VSS.n36 0.00100007
R4055 VSS.n1554 VSS.n357 0.0918876
R4056 VSS.n1556 VSS.n1555 0.0918876
R4057 VSS.n1347 VSS.n423 0.0879824
R4058 VSS.n1381 VSS.n1348 0.0879824
R4059 VSS.n348 VSS.n350 0.0827222
R4060 VSS.n1564 VSS.n1563 0.0827222
R4061 VSS.n1136 VSS.n1135 0.0818851
R4062 VSS.n1162 VSS.n1161 0.0818851
R4063 VSS.n1617 VSS.n1616 0.0818851
R4064 VSS.n1147 VSS.n1146 0.0818851
R4065 VSS.n1379 VSS.n423 0.0791823
R4066 VSS.n1381 VSS.n1380 0.0791823
R4067 VSS.n934 VSS.n869 0.0756111
R4068 VSS.n936 VSS.n935 0.0756111
R4069 VSS.n64 VSS.n60 0.0739569
R4070 VSS.n1328 VSS.n1315 0.0738333
R4071 VSS.n1329 VSS.n500 0.0738333
R4072 VSS.n1460 VSS.n1447 0.0738333
R4073 VSS.n1461 VSS.n412 0.0738333
R4074 VSS.n928 VSS.n901 0.0729601
R4075 VSS.n930 VSS.n929 0.0729601
R4076 VSS.n1079 VSS.n569 0.0724529
R4077 VSS.n1155 VSS.n92 0.072
R4078 VSS.n37 VSS.n33 0.0697001
R4079 VSS.n1117 VSS.n689 0.0657667
R4080 VSS.n1063 VSS.n1062 0.0643607
R4081 VSS.n528 VSS.n526 0.0643607
R4082 VSS.n1407 VSS.n1405 0.0643607
R4083 VSS.n349 VSS.n347 0.0622778
R4084 VSS.n1553 VSS.n1552 0.0622778
R4085 VSS.n1497 VSS.n1496 0.0621
R4086 VSS.n490 VSS.n489 0.0621
R4087 VSS.n995 VSS.n994 0.0621
R4088 VSS.n932 VSS.n901 0.0618333
R4089 VSS.n931 VSS.n930 0.0618333
R4090 VSS.n1490 VSS.n406 0.0610647
R4091 VSS.n463 VSS.n411 0.0610647
R4092 VSS.n977 VSS.n867 0.0610647
R4093 VSS.n1494 VSS.n406 0.0600294
R4094 VSS.n492 VSS.n463 0.0600294
R4095 VSS.n997 VSS.n977 0.0600294
R4096 VSS.n1570 VSS.n264 0.0576428
R4097 VSS.n1503 VSS.n369 0.0558882
R4098 VSS.n1491 VSS.n408 0.0538176
R4099 VSS.n1334 VSS.n495 0.0538176
R4100 VSS.n475 VSS.n474 0.0538176
R4101 VSS.n564 VSS.n561 0.0538176
R4102 VSS.n1001 VSS.n1000 0.0538176
R4103 VSS.n1547 VSS.n368 0.0538176
R4104 VSS.n545 VSS.n541 0.0512692
R4105 VSS.n1319 VSS.n1316 0.0512692
R4106 VSS.n1424 VSS.n1420 0.0512692
R4107 VSS.n1451 VSS.n1448 0.0512692
R4108 VSS.n366 VSS.n362 0.0512692
R4109 VSS.n1021 VSS.n1018 0.0512692
R4110 VSS.n970 VSS.n963 0.0512692
R4111 VSS.n956 VSS.n949 0.0512692
R4112 VSS.n559 VSS.n555 0.0512692
R4113 VSS.n1053 VSS.n1049 0.0512692
R4114 VSS.n472 VSS.n468 0.0512692
R4115 VSS.n456 VSS.n449 0.0512692
R4116 VSS.n442 VSS.n435 0.0512692
R4117 VSS.n399 VSS.n392 0.0512692
R4118 VSS.n385 VSS.n378 0.0512692
R4119 VSS.n1382 VSS.n1381 0.0486412
R4120 VSS.n1383 VSS.n423 0.0486412
R4121 VSS.n1624 VSS.n92 0.0452333
R4122 VSS.n1114 VSS.n689 0.0413941
R4123 VSS.n1088 VSS.n1048 0.0398412
R4124 VSS.n1092 VSS.n1047 0.0398412
R4125 VSS.n1300 VSS.n1299 0.0398412
R4126 VSS.n1298 VSS.n514 0.0398412
R4127 VSS.n1432 VSS.n1431 0.0398412
R4128 VSS.n1430 VSS.n1394 0.0398412
R4129 VSS.n543 VSS.n542 0.038479
R4130 VSS.n1422 VSS.n1421 0.038479
R4131 VSS.n364 VSS.n363 0.038479
R4132 VSS.n557 VSS.n556 0.038479
R4133 VSS.n1051 VSS.n1050 0.038479
R4134 VSS.n470 VSS.n469 0.038479
R4135 VSS.n1157 VSS.n1155 0.0382667
R4136 VSS.n967 VSS.n966 0.0374235
R4137 VSS.n965 VSS.n964 0.0374235
R4138 VSS.n966 VSS.n965 0.0374235
R4139 VSS.n968 VSS.n964 0.0374235
R4140 VSS.n953 VSS.n952 0.0374235
R4141 VSS.n951 VSS.n950 0.0374235
R4142 VSS.n952 VSS.n951 0.0374235
R4143 VSS.n954 VSS.n950 0.0374235
R4144 VSS.n453 VSS.n452 0.0374235
R4145 VSS.n451 VSS.n450 0.0374235
R4146 VSS.n452 VSS.n451 0.0374235
R4147 VSS.n454 VSS.n450 0.0374235
R4148 VSS.n439 VSS.n438 0.0374235
R4149 VSS.n437 VSS.n436 0.0374235
R4150 VSS.n438 VSS.n437 0.0374235
R4151 VSS.n440 VSS.n436 0.0374235
R4152 VSS.n396 VSS.n395 0.0374235
R4153 VSS.n394 VSS.n393 0.0374235
R4154 VSS.n395 VSS.n394 0.0374235
R4155 VSS.n397 VSS.n393 0.0374235
R4156 VSS.n382 VSS.n381 0.0374235
R4157 VSS.n380 VSS.n379 0.0374235
R4158 VSS.n381 VSS.n380 0.0374235
R4159 VSS.n383 VSS.n379 0.0374235
R4160 VSS.n810 VSS.n753 0.0326151
R4161 VSS.n660 VSS.n52 0.0329099
R4162 VSS.n1233 VSS.n1232 0.0319859
R4163 VSS.n1011 VSS.n1010 0.0316731
R4164 VSS.n1008 VSS.n1007 0.0316731
R4165 VSS.n1015 VSS.n1014 0.0316731
R4166 VSS.n505 VSS.n504 0.0316731
R4167 VSS.n502 VSS.n501 0.0316731
R4168 VSS.n1324 VSS.n1323 0.0316731
R4169 VSS.n417 VSS.n416 0.0316731
R4170 VSS.n414 VSS.n413 0.0316731
R4171 VSS.n1456 VSS.n1455 0.0316731
R4172 VSS.n1313 VSS.n500 0.0315588
R4173 VSS.n1315 VSS.n1314 0.0315588
R4174 VSS.n1445 VSS.n412 0.0315588
R4175 VSS.n1447 VSS.n1446 0.0315588
R4176 VSS.n1031 VSS.n706 0.0298333
R4177 VSS.n1028 VSS.n1027 0.0298333
R4178 VSS.n569 VSS.n562 0.0284529
R4179 VSS.n813 VSS.n812 0.0281464
R4180 VSS.n1212 VSS.n1211 0.0281464
R4181 VSS.n662 VSS.n661 0.0281464
R4182 VSS.n56 VSS.n53 0.0251836
R4183 VSS.n1575 VSS.n35 1.56381
R4184 VSS.n814 VSS.n791 0.024009
R4185 VSS.n1231 VSS.n1213 0.024009
R4186 VSS.n663 VSS.n601 0.024009
R4187 VSS.n811 VSS.n809 0.0221679
R4188 VSS.n1210 VSS.n1192 0.0221679
R4189 VSS.n660 VSS.n619 0.0221679
R4190 VSS.n1318 VSS.n1317 0.0221276
R4191 VSS.n1317 VSS.n1316 0.0221276
R4192 VSS.n1450 VSS.n1449 0.0221276
R4193 VSS.n1449 VSS.n1448 0.0221276
R4194 VSS.n1020 VSS.n1019 0.0221276
R4195 VSS.n1019 VSS.n1018 0.0221276
R4196 VSS.n1542 VSS.n369 0.0206882
R4197 VSS.n811 VSS.n810 0.019602
R4198 VSS.n544 VSS.n543 0.0194895
R4199 VSS.n542 VSS.n541 0.0194895
R4200 VSS.n1423 VSS.n1422 0.0194895
R4201 VSS.n1421 VSS.n1420 0.0194895
R4202 VSS.n364 VSS.n362 0.0194895
R4203 VSS.n365 VSS.n363 0.0194895
R4204 VSS.n557 VSS.n555 0.0194895
R4205 VSS.n558 VSS.n556 0.0194895
R4206 VSS.n1052 VSS.n1051 0.0194895
R4207 VSS.n1050 VSS.n1049 0.0194895
R4208 VSS.n470 VSS.n468 0.0194895
R4209 VSS.n471 VSS.n469 0.0194895
R4210 VSS.n969 VSS.n968 0.0189618
R4211 VSS.n967 VSS.n963 0.0189618
R4212 VSS.n955 VSS.n954 0.0189618
R4213 VSS.n953 VSS.n949 0.0189618
R4214 VSS.n455 VSS.n454 0.0189618
R4215 VSS.n453 VSS.n449 0.0189618
R4216 VSS.n441 VSS.n440 0.0189618
R4217 VSS.n439 VSS.n435 0.0189618
R4218 VSS.n398 VSS.n397 0.0189618
R4219 VSS.n396 VSS.n392 0.0189618
R4220 VSS.n384 VSS.n383 0.0189618
R4221 VSS.n382 VSS.n378 0.0189618
R4222 VSS.n809 VSS.n808 0.0180257
R4223 VSS.n1200 VSS.n1192 0.0180257
R4224 VSS.n2 VSS.n0 0.026043
R4225 VSS.n619 VSS.n618 0.0180257
R4226 VSS.n804 VSS.n792 0.0164148
R4227 VSS.n1209 VSS.n1208 0.0164148
R4228 VSS.n614 VSS.n602 0.0164148
R4229 VSS.n791 VSS.n790 0.0161847
R4230 VSS.n1221 VSS.n1213 0.0161847
R4231 VSS.n601 VSS.n600 0.0161847
R4232 VSS VSS.n1624 0.0152529
R4233 VSS.n1509 VSS.n1506 0.0152529
R4234 VSS.n815 VSS.n774 0.0147678
R4235 VSS.n1232 VSS.n1230 0.0147678
R4236 VSS.n664 VSS.n584 0.0147678
R4237 VSS.n1144 VSS.n1143 0.0140667
R4238 VSS.n551 VSS.n550 0.0139807
R4239 VSS.n1296 VSS.n1295 0.0139807
R4240 VSS.n357 VSS.n354 0.0139807
R4241 VSS.n1557 VSS.n1556 0.0139807
R4242 VSS.n814 VSS.n813 0.0134184
R4243 VSS.n1231 VSS.n1212 0.0134184
R4244 VSS.n663 VSS.n662 0.0134184
R4245 VSS.n1354 VSS 0.0126647
R4246 VSS.n1543 VSS.n1504 0.0118882
R4247 VSS.n786 VSS.n774 0.00993515
R4248 VSS.n1230 VSS.n1229 0.00993515
R4249 VSS.n596 VSS.n584 0.00993515
R4250 VSS.n797 VSS.n793 0.00970502
R4251 VSS.n796 VSS.n795 0.00970502
R4252 VSS.n800 VSS.n799 0.00970502
R4253 VSS.n798 VSS.n794 0.00970502
R4254 VSS.n807 VSS.n806 0.00970502
R4255 VSS.n1201 VSS.n1193 0.00970502
R4256 VSS.n1199 VSS.n1194 0.00970502
R4257 VSS.n1202 VSS.n1195 0.00970502
R4258 VSS.n1198 VSS.n1196 0.00970502
R4259 VSS.n1203 VSS.n1197 0.00970502
R4260 VSS.n607 VSS.n603 0.00970502
R4261 VSS.n606 VSS.n605 0.00970502
R4262 VSS.n610 VSS.n609 0.00970502
R4263 VSS.n608 VSS.n604 0.00970502
R4264 VSS.n617 VSS.n616 0.00970502
R4265 VSS.n812 VSS.n792 0.00928092
R4266 VSS.n1211 VSS.n1209 0.00928092
R4267 VSS.n661 VSS.n602 0.00928092
R4268 VSS.n790 VSS.n775 0.00878452
R4269 VSS.n779 VSS.n778 0.00878452
R4270 VSS.n781 VSS.n777 0.00878452
R4271 VSS.n782 VSS.n780 0.00878452
R4272 VSS.n788 VSS.n776 0.00878452
R4273 VSS.n789 VSS.n787 0.00878452
R4274 VSS.n1221 VSS.n1214 0.00878452
R4275 VSS.n1222 VSS.n1215 0.00878452
R4276 VSS.n1220 VSS.n1216 0.00878452
R4277 VSS.n1223 VSS.n1217 0.00878452
R4278 VSS.n1219 VSS.n1218 0.00878452
R4279 VSS.n1225 VSS.n1224 0.00878452
R4280 VSS.n600 VSS.n585 0.00878452
R4281 VSS.n589 VSS.n588 0.00878452
R4282 VSS.n591 VSS.n587 0.00878452
R4283 VSS.n592 VSS.n590 0.00878452
R4284 VSS.n598 VSS.n586 0.00878452
R4285 VSS.n599 VSS.n597 0.00878452
R4286 VSS.n1031 VSS.n1030 0.00878235
R4287 VSS.n1029 VSS.n1028 0.00878235
R4288 VSS.n805 VSS.n804 0.00855439
R4289 VSS.n1208 VSS.n1204 0.00855439
R4290 VSS.n615 VSS.n614 0.00855439
R4291 VSS.n779 VSS.n775 0.00786402
R4292 VSS.n778 VSS.n777 0.00786402
R4293 VSS.n782 VSS.n781 0.00786402
R4294 VSS.n780 VSS.n776 0.00786402
R4295 VSS.n789 VSS.n788 0.00786402
R4296 VSS.n1222 VSS.n1214 0.00786402
R4297 VSS.n1220 VSS.n1215 0.00786402
R4298 VSS.n1223 VSS.n1216 0.00786402
R4299 VSS.n1219 VSS.n1217 0.00786402
R4300 VSS.n1224 VSS.n1218 0.00786402
R4301 VSS.n589 VSS.n585 0.00786402
R4302 VSS.n588 VSS.n587 0.00786402
R4303 VSS.n592 VSS.n591 0.00786402
R4304 VSS.n590 VSS.n586 0.00786402
R4305 VSS.n599 VSS.n598 0.00786402
R4306 VSS.n673 VSS.n580 0.00740941
R4307 VSS.n79 VSS.n78 0.0071972
R4308 VSS.n70 VSS.n69 0.0071972
R4309 VSS.n808 VSS.n793 0.00694351
R4310 VSS.n797 VSS.n796 0.00694351
R4311 VSS.n799 VSS.n795 0.00694351
R4312 VSS.n800 VSS.n798 0.00694351
R4313 VSS.n806 VSS.n794 0.00694351
R4314 VSS.n807 VSS.n805 0.00694351
R4315 VSS.n1200 VSS.n1193 0.00694351
R4316 VSS.n1201 VSS.n1194 0.00694351
R4317 VSS.n1199 VSS.n1195 0.00694351
R4318 VSS.n1202 VSS.n1196 0.00694351
R4319 VSS.n1198 VSS.n1197 0.00694351
R4320 VSS.n1204 VSS.n1203 0.00694351
R4321 VSS.n618 VSS.n603 0.00694351
R4322 VSS.n607 VSS.n606 0.00694351
R4323 VSS.n609 VSS.n605 0.00694351
R4324 VSS.n610 VSS.n608 0.00694351
R4325 VSS.n616 VSS.n604 0.00694351
R4326 VSS.n617 VSS.n615 0.00694351
R4327 VSS.n787 VSS.n786 0.00671339
R4328 VSS.n1229 VSS.n1225 0.00671339
R4329 VSS.n597 VSS.n596 0.00671339
R4330 VSS.n1095 VSS.n1094 0.00464118
R4331 VSS.n1093 VSS.n1046 0.00464118
R4332 VSS.n67 VSS.n59 0.00224999
R4333 VSS.n1570 VSS.n233 0.0018071
R4334 VSS.n657 VSS.n656 0.00175
R4335 VSS.n830 VSS.n829 0.00166667
R4336 VSS.n826 VSS.n757 0.00166667
R4337 VSS.n765 VSS.n764 0.00166667
R4338 VSS.n749 VSS.n720 0.00166667
R4339 VSS.n653 VSS.n651 0.00166667
R4340 VSS.n652 VSS.n581 0.00166667
R4341 VSS.n47 VSS.n46 0.00169993
R4342 VSS.n654 VSS.n583 0.00166667
R4343 VSS.n837 VSS.n716 0.00166667
R4344 VSS.n90 VSS.n89 0.00169993
R4345 VSS.n88 VSS.n58 0.00166667
R4346 VSS.n830 VSS.n721 0.00162501
R4347 VSS.n64 VSS.n61 0.0016187
R4348 VSS.n89 VSS.n88 0.0015
R4349 VSS.n85 VSS.n87 0.0015
R4350 VSS.n76 VSS.n79 0.0015
R4351 VSS.n66 VSS.n70 0.0015
R4352 VSS.n64 VSS.n59 0.0015
R4353 VSS.n1570 VSS.n55 0.00125
R4354 VSS.n37 VSS.n35 0.00100782
R4355 VSS.n64 VSS.n63 0.00146301
R4356 VSS.n833 VSS.n721 0.00137498
R4357 VSS.n1570 VSS.n184 0.00134066
R4358 VSS.n837 VSS.n87 0.00133332
R4359 VSS.n64 VSS.n58 0.00133332
R4360 VSS.n766 VSS.n765 0.00133332
R4361 VSS.n758 VSS.n757 0.00133332
R4362 VSS.n829 VSS.n828 0.00133332
R4363 VSS.n833 VSS.n749 0.00133332
R4364 VSS.n45 VSS.n44 0.00149995
R4365 VSS.n652 VSS.n582 0.00133332
R4366 VSS.n653 VSS.n581 0.00133332
R4367 VSS.n654 VSS.n50 0.00133332
R4368 VSS.n1608 VSS.n37 0.00133072
R4369 VSS.n656 VSS.n651 0.00124998
R4370 VSS.n1620 VSS.n91 0.00118437
R4371 VSS.n1621 VSS.n1620 0.00118228
R4372 VSS.n37 VSS.n32 0.00110503
R4373 VSS.n1570 VSS.n232 0.00110503
R4374 VSS.n689 VSS 0.00105
R4375 VSS.n835 VSS.n718 0.00102999
R4376 VSS.n621 VSS.n50 0.00102771
R4377 VSS.n718 VSS.n717 0.00102039
R4378 VSS.n50 VSS.n51 0.00101879
R4379 VSS.n67 VSS.n66 0.00124999
R4380 VSS.n77 VSS.n76 0.00124999
R4381 VSS.n86 VSS.n85 0.00124999
R4382 VSS.n773 VSS.n771 0.001
R4383 VSS.n770 VSS.n769 0.001
R4384 VSS.n768 VSS.n767 0.001
R4385 VSS.n763 VSS.n762 0.001
R4386 VSS.n762 VSS.n761 0.001
R4387 VSS.n759 VSS.n758 0.001
R4388 VSS.n828 VSS.n827 0.001
R4389 VSS.n827 VSS.n826 0.001
R4390 VSS.n760 VSS.n759 0.001
R4391 VSS.n761 VSS.n760 0.001
R4392 VSS.n764 VSS.n763 0.001
R4393 VSS.n767 VSS.n766 0.001
R4394 VSS.n769 VSS.n768 0.001
R4395 VSS.n771 VSS.n770 0.001
R4396 VSS.n773 VSS.n772 0.001
R4397 VSS.n751 VSS.n719 0.001
R4398 VSS.n752 VSS.n720 0.001
R4399 VSS.n752 VSS.n719 0.001
R4400 VSS.n751 VSS.n718 0.001
R4401 VSS.n772 VSS.n718 0.001
R4402 VSS.n56 VSS.n55 0.00125
R4403 VSS.n55 VSS.n54 3976.59
R4404 VSS.n657 VSS.n48 0.00249997
R4405 VSS.n49 VSS.n50 0.00249996
R4406 VSS.n582 VSS.n42 0.00266647
R4407 VSS.n40 VSS.n39 0.00224999
R4408 VSS.n46 VSS.n43 0.0015
R4409 VSS.n44 VSS.n43 0.0015
R4410 VSS.n28 VSS.n27 0.00133333
R4411 VSS.n37 VSS.n28 0.00133333
R4412 VSS.n29 VSS.n28 8.50183
R4413 VSS.n31 VSS.n17 1.40654
C0 M22_1/pmosHV$1_priv2_0.D a_30336_2222# 0.04136f
C1 M24_0/pmosHV$1_priv4_0.D M15_0/nmosHV$1_priv1_0.D 0.11544f
C2 M21_2/nmosHV$5_priv1_0.D a_34131_8610# 0.13104f
C3 pmosHV_priv24_0.S a_26026_n3082# 0.01246f
C4 vref2 ACC_CAP 2.97761f
C5 GROUP3$1_3.G a_14418_n10689# 0.07762f
C6 a_28486_6382# VDD3_3 0.24165f
C7 GROUP1$3_0.G VDD3_3 8.56044f
C8 M20_0/nmosHV$5_priv2_0.D a_1828_6438# 0.03962f
C9 a_27815_9812# a_32319_9292# 0.87347f
C10 M2_0/nmosHV$3_priv4_0.D M21_0/nmosHV$5_priv1_0.D 0.51067f
C11 M16_2/nmosHV$2_priv1_0.D a_21160_1198# 0.14061f
C12 a_30336_2222# VDD3_3 1.26848f
C13 a_11439_n14164# q1 0.55538f
C14 a_32319_9292# M21_2/nmosHV$5_priv1_0.D 0.43619f
C15 M20_1/nmosHV$5_priv2_0.D M21_1/nmosHV$5_priv1_0.D 2.22862f
C16 vref1 ACC_CAP 3.01505f
C17 M24_2/pmosHV$1_priv4_0.D a_24540_4414# 0.18809f
C18 nmosHV_priv13_2.D pmosHV_priv26_2.S 2.23672f
C19 vref2 vref3 0.10163f
C20 a_17165_9132# a_17166_8209# 0.01044f
C21 a_2773_n13340# a_2834_n14164# 0.096f
C22 a_22419_8300# VDD3_3 0.10511f
C23 a_21258_n10689# VDD3_3 0.52354f
C24 a_34955_8610# a_35579_8610# 0.01052f
C25 a_29255_9076# a_29256_8153# 0.01044f
C26 a_9534_1189# vin 0.03816f
C27 M24_0/pmosHV$1_priv4_0.D VDD3_3 11.7361f
C28 a_25059_n13340# a_25120_n14164# 0.096f
C29 GROUP3_0.G lnaf 0.17637f
C30 nmosHV_priv13_3.D VDD1_5 0.03552f
C31 vref0 ACC_CAP 4.56351f
C32 a_7473_8666# M23_0/pmosHV$1_priv3_0.D 0.03902f
C33 a_34131_8244# a_34955_8244# 0.01052f
C34 M23_0/pmosHV$1_priv3_0.D Cap_M1 1.71633f
C35 a_14418_n10689# GROUP1$1$2_0.G 0.10455f
C36 nmosHV_priv13_1.D a_4538_n11482# 0.03365f
C37 M24_0/pmosHV$1_priv4_0.D a_10250_1877# 0.07959f
C38 GROUP1$1$1_0.G a_11378_n13340# 0.17519f
C39 GROUP1$2_0.nmosHV_priv3$2_0.S VDD1_5 0.06421f
C40 GROUP1_0.G pmosHV_priv16_1.S 2.02427f
C41 GROUP1$1$3_0.G a_25059_n11482# 0.04297f
C42 GROUP1$4_0.G VDD3_3 8.56603f
C43 a_31876_n4617# VDD3_3 0.37776f
C44 vref1 vref2 0.13384f
C45 GROUP1$1$3_0.G q3 7.75533f
C46 GROUP1$1$1_0.G a_9674_n14164# 0.14917f
C47 a_5661_9348# M22_0/pmosHV$1_priv2_0.D 0.16376f
C48 M20_0/nmosHV$5_priv2_0.D a_2598_8209# 0.04173f
C49 a_14655_9868# a_16095_9132# 0.01464f
C50 a_24540_4414# VDD3_3 0.21093f
C51 GROUP1$1$1_0.G a_7872_n17542# 0.15686f
C52 a_34832_5136# a_30336_2222# 0.24633f
C53 a_5094_8188# a_5094_7364# 0.01299f
C54 Cap_M21 vref3 0.03325f
C55 M16_1/nmosHV$2_priv1_0.D Cap_M21 0.49192f
C56 a_35579_8610# VDD3_3 0.10331f
C57 pmosHV_priv24_0.S VDD3_3 4.74951f
C58 GROUP1$4_0.nmosHV_priv3$4_0.S q3 0.28679f
C59 M24_0/pmosHV$1_priv4_0.D a_8174_5192# 0.02126f
C60 GROUP1$4_0.G a_25120_n12306# 0.15119f
C61 M2_2/nmosHV$3_priv4_0.D VDD3_3 0.61332f
C62 a_2834_n12306# VDD3_3 0.02884f
C63 nmosHV_priv13_2.D VDD1_5 0.03552f
C64 vref0 vref1 0.07784f
C65 a_3498_n854# ACC_CAP 0.03716f
C66 a_14418_n10689# pmosHV_priv26_2.S 0.03529f
C67 a_18218_n11482# a_18279_n12306# 0.096f
C68 M15_1/nmosHV$1_priv1_0.D lnaf 0.78168f
C69 a_16453_n11482# GROUP1$3_0.nmosHV_priv3$3_0.S 0.01288f
C70 a_29298_n9896# opm 0.03792f
C71 a_20971_8300# a_21795_8300# 0.01052f
C72 a_1157_9868# VDD3_3 1.65111f
C73 M16_1/nmosHV$2_priv1_0.D a_34320_1683# 0.0665f
C74 a_18592_8188# VDD3_3 0.37348f
C75 GROUP3$1_3.G VDD3_3 6.31824f
C76 a_36859_5885# VDD3_3 0.05468f
C77 a_11378_n11482# VDD3_3 1.56562f
C78 Cap_M2 vref2 0.17852f
C79 GROUP1$1_0.G q0 7.71822f
C80 GROUP1_0.nmosHV_priv3_0.S a_2834_n14164# 0.06026f
C81 a_1157_9868# a_3667_9132# 0.01464f
C82 M20_0/nmosHV$5_priv2_0.D a_2597_9132# 0.04424f
C83 GROUP1$2_0.G a_9674_n12306# 0.14917f
C84 a_4538_n13340# VDD1_5 1.54359f
C85 GROUP1$3_0.nmosHV_priv3$3_0.S a_16514_n12306# 0.42847f
C86 GROUP1$1_0.G a_2773_n11482# 0.38882f
C87 GROUP3_0.G a_31876_n3196# 0.0423f
C88 nmosHV_priv13_1.D ACC_CAP 0.61074f
C89 a_21795_8300# Cap_M11 0.03834f
C90 Cap_M2 vref1 0.11284f
C91 a_2834_n14164# VDD1_5 0.02715f
C92 a_26026_n3082# GROUP3$1_0.G 0.04124f
C93 a_11439_n12306# VDD3_3 0.03079f
C94 a_25120_n14164# VDD1_5 0.03108f
C95 GROUP3$1_2.G VDD3_3 6.31824f
C96 M2_1/nmosHV$3_priv4_0.D M21_1/nmosHV$5_priv1_0.D 0.51067f
C97 a_14655_9868# VDD3_3 1.65533f
C98 nmosHV_priv13_0.D VDD1_5 0.03552f
C99 VDD3_3 a_5506_n3082# 0.62854f
C100 a_11042_8097# Cap_M1 0.06037f
C101 a_3678_2278# M15_0/nmosHV$1_priv1_0.D 0.03799f
C102 GROUP1_0.G a_2773_n11482# 0.14967f
C103 a_36908_1821# lnaf 0.02195f
C104 a_9674_n12306# a_9613_n13340# 0.0643f
C105 GROUP1$2_0.G q1 0.02287f
C106 GROUP1$1$2_0.G VDD3_3 2.26741f
C107 a_9586_8299# a_10109_8300# 0.01289f
C108 M22_2/pmosHV$1_priv2_0.D M23_2/pmosHV$1_priv3_0.D 2.49299f
C109 M21_1/nmosHV$5_priv1_0.D a_17166_8209# 0.15975f
C110 GROUP1$1$1_0.G GROUP1$2_0.nmosHV_priv3$2_0.S 0.52193f
C111 a_24447_n3082# GROUP3$1_0.G 0.30541f
C112 a_35579_8244# lnaf 0.09625f
C113 a_14418_n10689# VDD1_5 0.56391f
C114 a_3498_n854# vref0 0.15362f
C115 vin vref0 0.13744f
C116 a_5094_8188# VDD3_3 0.37348f
C117 GROUP1$3_0.G q2 0.02287f
C118 VDD3_3 opm 2.49814f
C119 a_34832_5136# a_36859_5885# 0.01408f
C120 M24_1/pmosHV$1_priv4_0.D M15_1/nmosHV$1_priv1_0.D 0.11544f
C121 a_34131_8244# VDD3_3 0.1371f
C122 M24_0/pmosHV$1_priv4_0.D a_11042_5836# 0.04219f
C123 M21_0/nmosHV$5_priv1_0.D a_8921_8666# 0.03711f
C124 GROUP3$1_3.G a_17607_n3082# 0.30541f
C125 M23_0/pmosHV$1_priv3_0.D VDD3_3 4.68445f
C126 GROUP4_1.G VDD3_3 6.17456f
C127 M21_1/nmosHV$5_priv1_0.D VDD3_3 0.91005f
C128 GROUP1$4_0.G a_25059_n11482# 0.17965f
C129 nmosHV_priv13_3.D ACC_CAP 0.61074f
C130 M21_2/nmosHV$5_priv1_0.D a_30326_8153# 0.15975f
C131 a_9613_n13340# q1 0.38866f
C132 a_3678_2278# VDD3_3 1.26848f
C133 GROUP1$4_0.G q3 0.02284f
C134 M24_2/pmosHV$1_priv4_0.D Cap_M11 2.44664f
C135 a_23699_5941# VDD3_3 0.05468f
C136 M16_0/nmosHV$2_priv1_0.D M15_0/nmosHV$1_priv1_0.D 0.14762f
C137 GROUP1_0.G GROUP1$1_0.G 8.55262f
C138 M2_1/nmosHV$3_priv4_0.D Cap_M11 1.32757f
C139 GROUP4_1.G a_5141_n3082# 0.04142f
C140 a_29298_n9896# VDD1_5 0.02439f
C141 nmosHV_priv13_1.D vref0 0.86475f
C142 VDD3_3 pmosHV_priv26_2.S 4.74951f
C143 a_25120_n12306# a_25059_n13340# 0.0643f
C144 a_7578_n10689# VDD3_3 0.52362f
C145 a_20971_8300# VDD3_3 0.1371f
C146 GROUP1$1$2_0.G a_18279_n14164# 0.14901f
C147 a_34131_8610# a_34955_8610# 0.01052f
C148 VDD3_3 GROUP3$1_0.G 6.31824f
C149 a_1828_6438# VDD3_3 0.24165f
C150 GROUP1$3_0.G a_18279_n12306# 0.1512f
C151 pmosHV_priv26_3.S a_11981_n3082# 0.24332f
C152 a_23294_n13340# a_23355_n14164# 0.096f
C153 a_3498_n854# vin 0.01951f
C154 M15_2/nmosHV$1_priv1_0.D Cap_M2 3.30877f
C155 M24_1/pmosHV$1_priv4_0.D a_36908_1821# 0.07959f
C156 a_4599_n14164# q0 0.55538f
C157 a_9674_n14164# a_7872_n17542# 0.06081f
C158 M2_0/nmosHV$3_priv4_0.D Cap_M1 1.32757f
C159 a_25661_n3082# VDD3_3 0.38983f
C160 M20_2/nmosHV$5_priv2_0.D a_29255_9076# 0.04424f
C161 M21_2/nmosHV$5_priv1_0.D M23_1/pmosHV$1_priv3_0.D 2.07569f
C162 VDD3_3 Cap_M11 8.30409f
C163 M23_0/pmosHV$1_priv3_0.D a_8174_5192# 0.01212f
C164 nmosHV_priv13_2.D ACC_CAP 0.61074f
C165 nmosHV_priv13_3.D vref1 0.86475f
C166 a_1032_n17542# q0 0.17576f
C167 GROUP3$1_3.G a_18821_n3082# 0.04142f
C168 a_8174_5192# a_3678_2278# 0.24633f
C169 a_23699_5400# VDD3_3 0.04104f
C170 GROUP1_0.nmosHV_priv3_0.S VDD3_3 0.04442f
C171 GROUP4_1.G a_738_n10689# 0.07762f
C172 M2_1/nmosHV$3_priv4_0.D a_23607_8666# 0.03745f
C173 a_32319_9292# M22_1/pmosHV$1_priv2_0.D 0.16376f
C174 M2_2/nmosHV$3_priv4_0.D lnaf 1.33381f
C175 a_19186_n3082# VDD3_3 0.62854f
C176 a_18592_7364# VDD3_3 0.3942f
C177 nmosHV_priv13_2.D vref2 0.86475f
C178 VDD3_3 VDD1_5 9.70986f
C179 M16_2/nmosHV$2_priv1_0.D a_21160_1739# 0.0665f
C180 a_32319_9292# VDD3_3 0.14771f
C181 a_17176_2278# VDD3_3 1.26848f
C182 a_8297_8300# Cap_M1 0.03834f
C183 a_36859_5885# lnaf 0.10887f
C184 a_23748_1877# Cap_M2 0.14651f
C185 a_8174_5192# M16_0/nmosHV$2_priv1_0.D 0.07775f
C186 GROUP1$1_0.G a_4599_n14164# 0.14901f
C187 a_11042_8097# VDD3_3 0.36196f
C188 nmosHV_priv13_0.D ACC_CAP 0.61074f
C189 M20_0/nmosHV$5_priv2_0.D M21_0/nmosHV$5_priv1_0.D 2.22862f
C190 M20_2/nmosHV$5_priv2_0.D a_28486_6382# 0.03962f
C191 a_21672_5192# M16_2/nmosHV$2_priv1_0.D 0.07775f
C192 GROUP1$1_0.G a_1032_n17542# 0.15686f
C193 M2_0/nmosHV$3_priv4_0.D a_10109_8300# 0.03745f
C194 M16_1/nmosHV$2_priv1_0.D a_34320_1142# 0.14061f
C195 GROUP1$3_0.nmosHV_priv3$3_0.S VDD3_3 0.04442f
C196 a_1157_9868# a_5661_9348# 0.87347f
C197 a_25059_n13340# q3 0.06792f
C198 pmosHV_priv16_1.S a_5506_n3082# 0.01246f
C199 a_25120_n12306# VDD1_5 0.01988f
C200 GROUP1$1$3_0.G GROUP1$4_0.nmosHV_priv3$4_0.S 0.52173f
C201 nmosHV_priv13_0.D vref3 0.86475f
C202 GROUP1$3_0.G a_18218_n11482# 0.17965f
C203 a_23355_n14164# q3 0.02292f
C204 a_23294_n13340# VDD1_5 1.07246f
C205 a_24812_n3082# GROUP3$1_0.G 0.04397f
C206 M15_0/nmosHV$1_priv1_0.D a_9534_1189# 0.03229f
C207 a_10201_5941# Cap_M1 0.10887f
C208 a_20971_8666# M23_2/pmosHV$1_priv3_0.D 0.03902f
C209 GROUP1$2_0.nmosHV_priv3$2_0.S a_9674_n14164# 0.06019f
C210 a_18279_n14164# VDD1_5 0.03108f
C211 GROUP1$1$2_0.G q2 7.7553f
C212 a_24218_n854# VDD1_5 0.0146f
C213 M2_2/nmosHV$3_priv4_0.D a_36767_8244# 0.03745f
C214 a_11042_4414# VDD3_3 0.21093f
C215 VDD3_3 a_4292_n3082# 0.62487f
C216 M24_2/pmosHV$1_priv4_0.D a_24540_6676# 0.04009f
C217 GROUP1$2_0.nmosHV_priv3$2_0.S a_7872_n17542# 0.27124f
C218 M23_1/pmosHV$1_priv3_0.D a_33174_7308# 0.15966f
C219 a_4599_n12306# a_4538_n13340# 0.0643f
C220 M20_1/nmosHV$5_priv2_0.D M22_2/pmosHV$1_priv2_0.D 0.26211f
C221 a_18821_n3082# pmosHV_priv26_2.S 0.24332f
C222 GROUP4_1.G pmosHV_priv16_1.S 1.82103f
C223 M2_2/nmosHV$3_priv4_0.D M24_1/pmosHV$1_priv4_0.D 0.04733f
C224 a_4538_n11482# VDD3_3 1.56562f
C225 GROUP1$2_0.G pmosHV_priv26_3.S 2.02427f
C226 a_8921_8300# a_9586_8299# 0.0104f
C227 opm lnaf 0.34626p
C228 a_27815_9812# M21_2/nmosHV$5_priv1_0.D 0.04177f
C229 M15_1/nmosHV$1_priv1_0.D a_36192_1133# 0.03229f
C230 a_23355_n12306# VDD3_3 0.02884f
C231 a_2773_n11482# a_2834_n12306# 0.096f
C232 a_14418_n10689# vref2 0.23624f
C233 GROUP1$3_0.nmosHV_priv3$3_0.S a_18279_n14164# 0.05692f
C234 GROUP3_0.G a_31876_n4617# 0.0419f
C235 a_24540_8097# M24_2/pmosHV$1_priv4_0.D 0.03987f
C236 M23_1/pmosHV$1_priv3_0.D a_34955_8244# 0.0883f
C237 M21_0/nmosHV$5_priv1_0.D a_7473_8666# 0.13104f
C238 a_29298_n9896# vref3 0.07753f
C239 M21_0/nmosHV$5_priv1_0.D Cap_M1 2.07206f
C240 a_30336_2222# M15_1/nmosHV$1_priv1_0.D 0.03799f
C241 a_37700_8041# VDD3_3 0.36196f
C242 GROUP1$1$2_0.G a_18279_n12306# 0.49337f
C243 a_10201_5400# Cap_M1 0.02732f
C244 M2_0/nmosHV$3_priv4_0.D VDD3_3 0.61332f
C245 M22_2/pmosHV$1_priv2_0.D a_20014_7364# 0.0413f
C246 a_24540_6676# VDD3_3 0.23422f
C247 a_21258_n10689# GROUP1$1$3_0.G 0.1044f
C248 GROUP1$1$2_0.G a_16453_n13340# 0.14923f
C249 a_5661_9348# M23_0/pmosHV$1_priv3_0.D 0.02527f
C250 GROUP1$1$1_0.G VDD3_3 2.26741f
C251 VDD3_3 a_12346_n3082# 0.62854f
C252 Cap_M1 Cap_M2 0.3793p
C253 a_23355_n12306# a_23294_n13340# 0.0643f
C254 a_32800_n3196# VDD3_3 0.21537f
C255 GROUP1$1_0.G a_2834_n12306# 0.02783f
C256 a_14655_9868# a_19159_9348# 0.87347f
C257 GROUP1$1$2_0.G a_14712_n17542# 0.15686f
C258 a_24540_8097# VDD3_3 0.36196f
C259 GROUP3$1_2.G a_11981_n3082# 0.04142f
C260 M23_2/pmosHV$1_priv3_0.D a_20014_7364# 0.15966f
C261 a_30325_9076# a_30326_8153# 0.01044f
C262 a_18218_n13340# a_18279_n14164# 0.096f
C263 VDD1_5 q3 1.73892f
C264 a_2773_n13340# q0 0.38827f
C265 GROUP1$1$1_0.G a_9613_n11482# 0.38882f
C266 GROUP1$4_0.G GROUP1$1$3_0.G 8.55273f
C267 M2_2/nmosHV$3_priv4_0.D a_36767_8610# 0.03745f
C268 GROUP1_0.G a_2834_n12306# 0.14917f
C269 VDD3_3 ACC_CAP 30.5815f
C270 M23_2/pmosHV$1_priv3_0.D a_21795_8300# 0.0883f
C271 a_19159_9348# M21_1/nmosHV$5_priv1_0.D 0.43619f
C272 VDD1_5 pmosHV_priv16_1.S 0.01393f
C273 a_31876_n3196# opm 0.17138f
C274 VDD3_3 vref3 6.04753f
C275 a_23294_n11482# VDD3_3 1.19888f
C276 GROUP1$4_0.G GROUP1$4_0.nmosHV_priv3$4_0.S 3.58429f
C277 VDD1_5 q2 1.7388f
C278 a_32319_9292# lnaf 0.02426f
C279 a_17972_n3082# VDD3_3 0.62488f
C280 a_6516_7364# VDD3_3 0.22578f
C281 VDD3_3 vref2 5.77524f
C282 M16_0/nmosHV$2_priv1_0.D a_7662_1198# 0.14061f
C283 a_10201_5941# VDD3_3 0.05468f
C284 M22_0/pmosHV$1_priv2_0.D a_5094_8188# 0.04427f
C285 a_23032_4546# Cap_M2 0.038f
C286 GROUP1$1_0.G a_2773_n13340# 0.14909f
C287 GROUP1$1$2_0.G a_18218_n11482# 0.04302f
C288 a_23084_8665# a_23607_8666# 0.01289f
C289 GROUP3_0.G opm 2.58303f
C290 M23_0/pmosHV$1_priv3_0.D a_7473_8300# 0.0394f
C291 VDD3_3 a_3927_n3082# 0.36444f
C292 GROUP1$3_0.nmosHV_priv3$3_0.S q2 0.28674f
C293 M22_0/pmosHV$1_priv2_0.D M23_0/pmosHV$1_priv3_0.D 2.49299f
C294 VDD3_3 vref1 5.87968f
C295 M22_0/pmosHV$1_priv2_0.D a_3678_2278# 0.04136f
C296 M15_0/nmosHV$1_priv1_0.D a_10201_5400# 0.09472f
C297 VDD1_5 q1 1.73894f
C298 a_19159_9348# Cap_M11 0.02426f
C299 a_22419_8666# VDD3_3 0.10331f
C300 M22_1/pmosHV$1_priv2_0.D M23_1/pmosHV$1_priv3_0.D 2.49299f
C301 M24_2/pmosHV$1_priv4_0.D Cap_M2 0.0979f
C302 a_4599_n12306# VDD3_3 0.03079f
C303 GROUP1$2_0.G a_11378_n11482# 0.17965f
C304 a_24218_n854# vref3 0.08766f
C305 a_18279_n12306# VDD1_5 0.01988f
C306 a_16453_n11482# a_16514_n12306# 0.096f
C307 VDD3_3 vref0 5.84865f
C308 GROUP1_0.nmosHV_priv3_0.S q0 0.25673f
C309 M23_1/pmosHV$1_priv3_0.D VDD3_3 4.68445f
C310 a_16453_n13340# VDD1_5 1.07244f
C311 a_11042_6676# Cap_M1 0.15135f
C312 M22_2/pmosHV$1_priv2_0.D VDD3_3 11.9589f
C313 M15_2/nmosHV$1_priv1_0.D a_23032_4546# 0.12199f
C314 M21_0/nmosHV$5_priv1_0.D VDD3_3 0.91005f
C315 a_6515_8188# a_6516_7364# 0.01286f
C316 a_34832_5136# M16_1/nmosHV$2_priv1_0.D 0.07775f
C317 a_21553_n17542# q3 0.17575f
C318 a_23607_8300# Cap_M11 0.08848f
C319 M22_0/pmosHV$1_priv2_0.D a_1828_6438# 0.07479f
C320 a_24218_n854# vref2 0.05846f
C321 a_11439_n14164# VDD1_5 0.03108f
C322 a_11374_n854# VDD1_5 0.02921f
C323 a_21258_n10689# GROUP1$4_0.G 0.11394f
C324 a_2773_n11482# GROUP1_0.nmosHV_priv3_0.S 0.01288f
C325 VDD3_3 Cap_M21 0.13264f
C326 M15_0/nmosHV$1_priv1_0.D vin 3.30877f
C327 GROUP1$2_0.G a_11439_n12306# 0.1512f
C328 a_10201_5400# VDD3_3 0.04104f
C329 a_8174_5192# a_10201_5941# 0.01408f
C330 VDD1_5 q0 2.15856f
C331 M15_1/nmosHV$1_priv1_0.D a_36192_4490# 0.12199f
C332 a_18218_n13340# q2 0.06793f
C333 a_21672_5192# a_23699_5941# 0.01408f
C334 M24_2/pmosHV$1_priv4_0.D M15_2/nmosHV$1_priv1_0.D 0.11544f
C335 a_8297_8300# a_8921_8300# 0.01052f
C336 GROUP1$3_0.nmosHV_priv3$3_0.S a_16453_n13340# 0.07801f
C337 GROUP1$1$3_0.G a_25059_n13340# 0.17519f
C338 M23_2/pmosHV$1_priv3_0.D VDD3_3 4.68445f
C339 VDD3_3 Cap_M2 0.12632f
C340 a_14418_n10689# nmosHV_priv13_3.D 0.02119f
C341 a_16514_n14164# q2 0.02286f
C342 pmosHV_priv24_0.S a_21258_n10689# 0.03529f
C343 GROUP1$1$3_0.G a_23355_n14164# 0.14917f
C344 GROUP3$1_2.G pmosHV_priv26_3.S 1.82103f
C345 a_37700_8041# lnaf 0.06056f
C346 M2_1/nmosHV$3_priv4_0.D a_23084_8299# 0.03988f
C347 GROUP1$3_0.nmosHV_priv3$3_0.S a_14712_n17542# 0.27124f
C348 M21_0/nmosHV$5_priv1_0.D a_3668_8209# 0.15975f
C349 M22_1/pmosHV$1_priv2_0.D a_31752_7308# 0.04083f
C350 VDD3_3 vin 0.52666f
C351 a_8921_8666# VDD3_3 0.10331f
C352 a_3498_n854# VDD3_3 0.41143f
C353 GROUP1$1_0.G GROUP1_0.nmosHV_priv3_0.S 0.49474f
C354 GROUP1$1$1_0.G a_9674_n12306# 0.02783f
C355 a_31752_7308# VDD3_3 0.3942f
C356 M23_1/pmosHV$1_priv3_0.D a_34832_5136# 0.01212f
C357 GROUP1$4_0.nmosHV_priv3$4_0.S a_23355_n14164# 0.06029f
C358 a_27815_9812# a_30325_9076# 0.01464f
C359 pmosHV_priv24_0.S GROUP1$4_0.G 2.02427f
C360 a_10250_1877# vin 0.14651f
C361 M20_2/nmosHV$5_priv2_0.D a_32319_9292# 0.05279f
C362 a_21672_5192# Cap_M11 0.48847f
C363 M15_2/nmosHV$1_priv1_0.D VDD3_3 2.65165f
C364 VDD3_3 a_11132_n3082# 0.62488f
C365 a_738_n10689# vref0 0.23624f
C366 a_8174_5192# a_10201_5400# 0.01408f
C367 a_18279_n12306# a_18218_n13340# 0.0643f
C368 a_34832_5136# Cap_M21 0.0897f
C369 ACC_CAP pmosHV_priv16_1.S 1.40883f
C370 GROUP1$1_0.G VDD1_5 5.9292f
C371 a_5661_9348# M2_0/nmosHV$3_priv4_0.D 0.16185f
C372 a_21672_5192# a_23699_5400# 0.01408f
C373 M24_2/pmosHV$1_priv4_0.D a_23748_1877# 0.07959f
C374 GROUP1_0.G GROUP1_0.nmosHV_priv3_0.S 3.5843f
C375 nmosHV_priv13_1.D VDD3_3 2.49815f
C376 a_14418_n10689# nmosHV_priv13_2.D 0.01809f
C377 a_7578_n10689# GROUP1$2_0.G 0.11398f
C378 m2_19838_156# Cap_M2 0.17579f
C379 GROUP1$3_0.G GROUP1$1$2_0.G 8.55262f
C380 a_16453_n13340# a_16514_n14164# 0.096f
C381 a_21795_8666# Cap_M11 0.03634f
C382 GROUP1$1$1_0.G q1 7.75526f
C383 M21_2/nmosHV$5_priv1_0.D M22_1/pmosHV$1_priv2_0.D 0.52109f
C384 GROUP1_0.G VDD1_5 0.1684f
C385 a_9586_8665# a_10109_8666# 0.01289f
C386 a_7578_n10689# pmosHV_priv26_3.S 0.03529f
C387 a_8174_5192# vin 0.0897f
C388 a_27815_9812# VDD3_3 1.65703f
C389 a_21672_5192# a_17176_2278# 0.24633f
C390 a_16514_n14164# a_14712_n17542# 0.06081f
C391 M21_0/nmosHV$5_priv1_0.D a_8921_8300# 0.03711f
C392 M2_0/nmosHV$3_priv4_0.D a_9586_8665# 0.11653f
C393 M21_2/nmosHV$5_priv1_0.D VDD3_3 0.91005f
C394 a_32800_n4617# VDD3_3 0.38865f
C395 a_37700_8041# M24_1/pmosHV$1_priv4_0.D 0.03987f
C396 GROUP1$1$1_0.G a_11439_n14164# 0.14901f
C397 M20_1/nmosHV$5_priv2_0.D a_16095_9132# 0.04424f
C398 a_14655_9868# a_17165_9132# 0.01464f
C399 GROUP1$1$3_0.G VDD1_5 5.60644f
C400 GROUP1$3_0.G pmosHV_priv26_2.S 2.02427f
C401 M21_1/nmosHV$5_priv1_0.D a_22419_8300# 0.03711f
C402 nmosHV_priv13_3.D VDD3_3 2.49815f
C403 GROUP1$1_0.G a_4538_n11482# 0.04302f
C404 M22_2/pmosHV$1_priv2_0.D a_15326_6438# 0.07479f
C405 a_11042_6676# VDD3_3 0.23422f
C406 vref0 pmosHV_priv16_1.S 1.66327f
C407 GROUP1$2_0.nmosHV_priv3$2_0.S VDD3_3 0.04441f
C408 GROUP1$2_0.G VDD1_5 0.09255f
C409 a_31876_n3196# a_32800_n3196# 0.01052f
C410 a_22419_8666# a_23084_8665# 0.0104f
C411 a_10109_8300# Cap_M1 0.08848f
C412 a_31926_n2220# opm 0.10311f
C413 a_11374_n854# ACC_CAP 0.01867f
C414 GROUP1$4_0.nmosHV_priv3$4_0.S VDD1_5 0.06404f
C415 a_31876_n4617# opm 0.01271f
C416 M20_0/nmosHV$5_priv2_0.D VDD3_3 0.14122f
C417 a_738_n10689# nmosHV_priv13_1.D 0.01809f
C418 GROUP1_0.G a_4538_n11482# 0.17965f
C419 a_21258_n10689# GROUP3$1_0.G 0.07762f
C420 VDD1_5 pmosHV_priv26_3.S 0.01401f
C421 M23_1/pmosHV$1_priv3_0.D lnaf 1.71633f
C422 a_16453_n11482# VDD3_3 1.19888f
C423 a_37700_5780# VDD3_3 0.38019f
C424 a_17176_2278# M16_2/nmosHV$2_priv1_0.D 0.33406f
C425 GROUP1_0.nmosHV_priv3_0.S a_4599_n14164# 0.05692f
C426 a_11378_n11482# a_11439_n12306# 0.096f
C427 a_9613_n11482# GROUP1$2_0.nmosHV_priv3$2_0.S 0.01284f
C428 M20_0/nmosHV$5_priv2_0.D a_3667_9132# 0.19696f
C429 GROUP1_0.nmosHV_priv3_0.S a_1032_n17542# 0.27124f
C430 lnaf Cap_M21 0.0167f
C431 a_2834_n12306# a_2773_n13340# 0.0643f
C432 M20_1/nmosHV$5_priv2_0.D a_17166_8209# 0.04231f
C433 a_9613_n13340# VDD1_5 1.07248f
C434 GROUP3_0.G a_32800_n3196# 0.19666f
C435 a_22419_8300# Cap_M11 0.09625f
C436 nmosHV_priv13_2.D VDD3_3 2.49815f
C437 a_31752_8132# a_31752_7308# 0.01299f
C438 a_4599_n14164# VDD1_5 0.03108f
C439 M22_1/pmosHV$1_priv2_0.D a_33174_7308# 0.0413f
C440 a_16514_n12306# VDD3_3 0.02884f
C441 M15_0/nmosHV$1_priv1_0.D Cap_M1 0.78168f
C442 GROUP1$1$3_0.G a_23355_n12306# 0.0279f
C443 a_5661_9348# M21_0/nmosHV$5_priv1_0.D 0.43619f
C444 M20_0/nmosHV$5_priv2_0.D a_3668_8209# 0.04231f
C445 M20_1/nmosHV$5_priv2_0.D VDD3_3 0.14122f
C446 GROUP1$3_0.G VDD1_5 0.09025f
C447 a_33174_7308# VDD3_3 0.22578f
C448 VDD3_3 a_10767_n3082# 0.3644f
C449 a_7473_8300# a_8297_8300# 0.01052f
C450 M24_2/pmosHV$1_priv4_0.D a_24540_5836# 0.04219f
C451 a_11374_n854# vref1 0.11303f
C452 GROUP3_0.G ACC_CAP 0.14205f
C453 pmosHV_priv24_0.S GROUP3$1_0.G 1.82103f
C454 a_37700_4358# VDD3_3 0.21093f
C455 a_21258_n10689# VDD1_5 0.56343f
C456 a_11374_n854# vref0 0.06935f
C457 GROUP1$1$3_0.G a_21553_n17542# 0.15686f
C458 GROUP1$4_0.nmosHV_priv3$4_0.S a_23355_n12306# 0.42852f
C459 VDD3_3 Cap_M1 8.25609f
C460 GROUP1$3_0.G GROUP1$3_0.nmosHV_priv3$3_0.S 3.5843f
C461 M20_2/nmosHV$5_priv2_0.D a_30326_8153# 0.04231f
C462 nmosHV_priv13_1.D pmosHV_priv16_1.S 2.23672f
C463 GROUP3$1_3.G pmosHV_priv26_2.S 1.82103f
C464 GROUP1_0.G ACC_CAP 0.4979f
C465 pmosHV_priv24_0.S a_25661_n3082# 0.24332f
C466 M22_0/pmosHV$1_priv2_0.D a_6516_7364# 0.0413f
C467 nmosHV_priv13_0.D VDD3_3 2.49808f
C468 a_20014_7364# VDD3_3 0.22578f
C469 a_11378_n13340# q1 0.06793f
C470 a_9534_4546# vin 0.038f
C471 a_19159_9348# M22_2/pmosHV$1_priv2_0.D 0.16376f
C472 a_11042_8097# M24_0/pmosHV$1_priv4_0.D 0.03987f
C473 a_24540_5836# VDD3_3 0.38019f
C474 a_9674_n14164# q1 0.02286f
C475 GROUP1$4_0.nmosHV_priv3$4_0.S a_21553_n17542# 0.27124f
C476 a_14655_9868# M21_1/nmosHV$5_priv1_0.D 0.04177f
C477 GROUP1$4_0.G VDD1_5 0.0934f
C478 GROUP4_1.G a_5506_n3082# 0.04124f
C479 M24_1/pmosHV$1_priv4_0.D Cap_M21 0.0979f
C480 a_7872_n17542# q1 0.17579f
C481 GROUP1$2_0.G GROUP1$1$1_0.G 8.55262f
C482 a_14418_n10689# VDD3_3 0.52362f
C483 a_11378_n13340# a_11439_n14164# 0.096f
C484 a_19159_9348# M23_2/pmosHV$1_priv3_0.D 0.02527f
C485 a_5094_7364# VDD3_3 0.3942f
C486 GROUP1_0.nmosHV_priv3_0.S a_2834_n12306# 0.42813f
C487 pmosHV_priv26_3.S a_12346_n3082# 0.01246f
C488 a_32836_n2566# lnaf 0.07651f
C489 GROUP3$1_2.G a_7578_n10689# 0.07762f
C490 M21_2/nmosHV$5_priv1_0.D lnaf 2.07211f
C491 pmosHV_priv24_0.S VDD1_5 0.01401f
C492 a_8921_8666# a_9586_8665# 0.0104f
C493 GROUP1$1_0.G a_4599_n12306# 0.49337f
C494 a_8174_5192# Cap_M1 0.48847f
C495 M2_1/nmosHV$3_priv4_0.D M24_2/pmosHV$1_priv4_0.D 0.04733f
C496 M24_0/pmosHV$1_priv4_0.D a_11042_4414# 0.18809f
C497 a_36244_8243# a_36767_8244# 0.01289f
C498 M21_0/nmosHV$5_priv1_0.D M22_0/pmosHV$1_priv2_0.D 0.52109f
C499 a_2834_n12306# VDD1_5 0.03547f
C500 a_32319_9292# M2_2/nmosHV$3_priv4_0.D 0.16185f
C501 GROUP1$1$1_0.G a_9613_n13340# 0.14923f
C502 GROUP1$1$3_0.G a_23294_n11482# 0.38889f
C503 a_26026_n3082# VDD3_3 0.62854f
C504 M16_1/nmosHV$2_priv1_0.D M15_1/nmosHV$1_priv1_0.D 0.14762f
C505 a_10109_8300# VDD3_3 0.01071f
C506 GROUP1$2_0.G ACC_CAP 0.4979f
C507 a_29298_n9896# VDD3_3 0.43808f
C508 GROUP3$1_3.G a_19186_n3082# 0.04124f
C509 a_18592_8188# a_18592_7364# 0.01299f
C510 GROUP1_0.G a_4599_n12306# 0.1512f
C511 M16_0/nmosHV$2_priv1_0.D a_7662_1739# 0.0665f
C512 GROUP3$1_3.G VDD1_5 0.0352f
C513 ACC_CAP pmosHV_priv26_3.S 1.374f
C514 GROUP1_0.G vref0 1.60496f
C515 a_23294_n11482# GROUP1$4_0.nmosHV_priv3$4_0.S 0.01289f
C516 GROUP1$2_0.nmosHV_priv3$2_0.S a_9674_n12306# 0.42836f
C517 a_24447_n3082# VDD3_3 0.3644f
C518 M24_2/pmosHV$1_priv4_0.D VDD3_3 11.7361f
C519 GROUP1$4_0.G a_23355_n12306# 0.14917f
C520 M2_1/nmosHV$3_priv4_0.D VDD3_3 0.61332f
C521 a_21795_8666# a_22419_8666# 0.01052f
C522 M15_0/nmosHV$1_priv1_0.D VDD3_3 2.65165f
C523 M2_0/nmosHV$3_priv4_0.D M24_0/pmosHV$1_priv4_0.D 0.04733f
C524 a_8921_8300# Cap_M1 0.09625f
C525 a_11439_n12306# VDD1_5 0.01988f
C526 M20_1/nmosHV$5_priv2_0.D a_15326_6438# 0.03962f
C527 a_3678_2278# M16_0/nmosHV$2_priv1_0.D 0.33406f
C528 GROUP1_0.nmosHV_priv3_0.S a_2773_n13340# 0.05788f
C529 GROUP3$1_2.G VDD1_5 0.0352f
C530 M21_1/nmosHV$5_priv1_0.D Cap_M11 2.07206f
C531 GROUP1$3_0.G ACC_CAP 0.4979f
C532 a_37700_6620# VDD3_3 0.23422f
C533 GROUP1$2_0.G vref1 1.60496f
C534 a_23084_8299# a_23607_8300# 0.01289f
C535 GROUP1$2_0.nmosHV_priv3$2_0.S q1 0.28679f
C536 GROUP1$1$2_0.G VDD1_5 5.60545f
C537 a_23699_5941# Cap_M11 0.10887f
C538 M23_2/pmosHV$1_priv3_0.D a_21672_5192# 0.01212f
C539 M22_1/pmosHV$1_priv2_0.D VDD3_3 11.9588f
C540 a_21672_5192# Cap_M2 0.0897f
C541 M20_0/nmosHV$5_priv2_0.D a_5661_9348# 0.05279f
C542 a_1157_9868# a_2597_9132# 0.01464f
C543 M15_1/nmosHV$1_priv1_0.D Cap_M21 3.30877f
C544 a_2773_n13340# VDD1_5 1.14603f
C545 vref1 pmosHV_priv26_3.S 1.66732f
C546 nmosHV_priv13_0.D a_25059_n11482# 0.03361f
C547 a_25120_n14164# q3 0.55538f
C548 a_25059_n13340# VDD1_5 1.54356f
C549 a_25661_n3082# GROUP3$1_0.G 0.04142f
C550 a_30336_2222# M16_1/nmosHV$2_priv1_0.D 0.33406f
C551 GROUP1$2_0.nmosHV_priv3$2_0.S a_11439_n14164# 0.057f
C552 a_23355_n14164# VDD1_5 0.01237f
C553 GROUP4_1.G VDD1_5 0.0338f
C554 GROUP1$1$2_0.G GROUP1$3_0.nmosHV_priv3$3_0.S 0.52176f
C555 GROUP1$3_0.G vref2 1.60496f
C556 a_21258_n10689# vref3 0.23624f
C557 a_8174_5192# M15_0/nmosHV$1_priv1_0.D 0.13771f
C558 VDD3_3 a_5141_n3082# 0.38983f
C559 a_19186_n3082# pmosHV_priv26_2.S 0.01246f
C560 a_27815_9812# M20_2/nmosHV$5_priv2_0.D 0.64018f
C561 a_9613_n11482# VDD3_3 1.19888f
C562 a_21672_5192# M15_2/nmosHV$1_priv1_0.D 0.13771f
C563 M22_2/pmosHV$1_priv2_0.D a_20013_8188# 0.21591f
C564 M20_2/nmosHV$5_priv2_0.D M21_2/nmosHV$5_priv1_0.D 2.22862f
C565 GROUP1$4_0.G ACC_CAP 0.4979f
C566 VDD1_5 pmosHV_priv26_2.S 0.01401f
C567 a_25120_n12306# VDD3_3 0.03079f
C568 a_34955_8244# lnaf 0.03834f
C569 a_36859_5344# VDD3_3 0.04104f
C570 nmosHV_priv13_1.D GROUP1_0.G 3.94644f
C571 a_32836_n2566# GROUP3_0.G 0.07811f
C572 a_7578_n10689# VDD1_5 0.56401f
C573 GROUP3_0.G a_32800_n4617# 0.04426f
C574 a_23699_5400# Cap_M11 0.02732f
C575 VDD1_5 GROUP3$1_0.G 0.0352f
C576 M24_1/pmosHV$1_priv4_0.D a_37700_5780# 0.04219f
C577 a_16514_n12306# a_16453_n13340# 0.0643f
C578 a_36908_1821# Cap_M21 0.14651f
C579 a_6515_8188# VDD3_3 0.21572f
C580 GROUP1$4_0.G vref3 1.60496f
C581 M16_2/nmosHV$2_priv1_0.D Cap_M2 0.49192f
C582 GROUP1$4_0.G a_23294_n11482# 0.14967f
C583 GROUP1$1$1_0.G a_11378_n11482# 0.04302f
C584 a_8174_5192# VDD3_3 0.68572f
C585 pmosHV_priv24_0.S ACC_CAP 1.374f
C586 a_36192_1133# Cap_M21 0.03816f
C587 a_5661_9348# Cap_M1 0.02426f
C588 a_3667_9132# a_3668_8209# 0.01044f
C589 a_34832_5136# VDD3_3 0.68572f
C590 GROUP1$1$2_0.G a_18218_n13340# 0.17519f
C591 GROUP4_1.G a_4292_n3082# 0.04397f
C592 VDD3_3 a_17607_n3082# 0.3644f
C593 pmosHV_priv24_0.S vref3 1.66331f
C594 GROUP1$1$2_0.G a_16514_n14164# 0.14917f
C595 a_738_n10689# VDD3_3 0.20487f
C596 a_30336_2222# Cap_M21 0.05288f
C597 GROUP1$1$1_0.G a_11439_n12306# 0.49337f
C598 M20_0/nmosHV$5_priv2_0.D M22_0/pmosHV$1_priv2_0.D 0.26211f
C599 M20_1/nmosHV$5_priv2_0.D a_19159_9348# 0.05279f
C600 GROUP3$1_3.G ACC_CAP 0.18281f
C601 a_9613_n13340# a_9674_n14164# 0.096f
C602 GROUP1_0.nmosHV_priv3_0.S VDD1_5 0.44008f
C603 GROUP3$1_2.G a_12346_n3082# 0.04124f
C604 a_36244_8609# a_36767_8610# 0.01289f
C605 M16_2/nmosHV$2_priv1_0.D M15_2/nmosHV$1_priv1_0.D 0.14762f
C606 a_4538_n13340# q0 0.06793f
C607 a_8297_8666# a_8921_8666# 0.01052f
C608 a_34832_5136# a_36859_5344# 0.01408f
C609 M24_1/pmosHV$1_priv4_0.D a_37700_4358# 0.18809f
C610 a_2834_n14164# q0 0.02286f
C611 a_35579_8244# a_36244_8243# 0.0104f
C612 a_27815_9812# a_29255_9076# 0.01464f
C613 a_8921_8300# VDD3_3 0.10511f
C614 a_24812_n3082# VDD3_3 0.62488f
C615 a_23355_n14164# a_21553_n17542# 0.06081f
C616 GROUP3$1_3.G a_17972_n3082# 0.04397f
C617 M22_1/pmosHV$1_priv2_0.D a_31752_8132# 0.04427f
C618 a_34955_8610# lnaf 0.03634f
C619 GROUP3$1_3.G vref2 0.06095f
C620 GROUP3$1_2.G ACC_CAP 0.18282f
C621 a_25059_n11482# VDD3_3 1.56562f
C622 nmosHV_priv13_2.D a_18218_n11482# 0.03365f
C623 M2_1/nmosHV$3_priv4_0.D a_23084_8665# 0.11653f
C624 a_31752_8132# VDD3_3 0.37348f
C625 GROUP1$3_0.nmosHV_priv3$3_0.S VDD1_5 0.06412f
C626 a_18821_n3082# VDD3_3 0.38983f
C627 M24_0/pmosHV$1_priv4_0.D vin 0.0979f
C628 a_15326_6438# VDD3_3 0.24165f
C629 nmosHV_priv13_3.D GROUP1$2_0.G 3.94644f
C630 a_20971_8666# a_21795_8666# 0.01052f
C631 a_11042_5836# VDD3_3 0.38019f
C632 opm ACC_CAP 6.32252f
C633 a_7578_n10689# GROUP1$1$1_0.G 0.10455f
C634 a_37700_6620# lnaf 0.15256f
C635 GROUP1$1_0.G a_4538_n13340# 0.17519f
C636 GROUP1$2_0.G GROUP1$2_0.nmosHV_priv3$2_0.S 3.58452f
C637 VDD3_3 pmosHV_priv16_1.S 4.74852f
C638 M23_0/pmosHV$1_priv3_0.D a_8297_8300# 0.0883f
C639 GROUP4_1.G ACC_CAP 0.52998f
C640 a_25059_n11482# a_25120_n12306# 0.096f
C641 nmosHV_priv13_3.D pmosHV_priv26_3.S 2.23672f
C642 GROUP1$1_0.G a_2834_n14164# 0.14917f
C643 a_2597_9132# a_2598_8209# 0.01044f
C644 M21_2/nmosHV$5_priv1_0.D a_35579_8244# 0.03711f
C645 a_1157_9868# M21_0/nmosHV$5_priv1_0.D 0.04177f
C646 a_22419_8300# a_23084_8299# 0.0104f
C647 M15_0/nmosHV$1_priv1_0.D a_9534_4546# 0.12199f
C648 M22_2/pmosHV$1_priv2_0.D a_18592_8188# 0.04427f
C649 M2_0/nmosHV$3_priv4_0.D a_9586_8299# 0.03988f
C650 a_24540_6676# Cap_M11 0.15134f
C651 VDD3_3 lnaf 8.71474f
C652 a_9674_n12306# VDD3_3 0.02884f
C653 a_23294_n13340# q3 0.38875f
C654 GROUP3$1_2.G vref1 0.05817f
C655 pmosHV_priv16_1.S a_5141_n3082# 0.24332f
C656 ACC_CAP pmosHV_priv26_2.S 1.374f
C657 a_18218_n13340# VDD1_5 1.54357f
C658 GROUP1$2_0.nmosHV_priv3$2_0.S a_9613_n13340# 0.07792f
C659 ACC_CAP GROUP3$1_0.G 0.18276f
C660 M23_0/pmosHV$1_priv3_0.D a_6516_7364# 0.15966f
C661 a_24540_8097# Cap_M11 0.06037f
C662 M22_0/pmosHV$1_priv2_0.D a_5094_7364# 0.04083f
C663 a_16514_n14164# VDD1_5 0.01237f
C664 a_18726_n854# VDD1_5 0.0146f
C665 a_9613_n11482# a_9674_n12306# 0.096f
C666 M2_2/nmosHV$3_priv4_0.D a_36244_8243# 0.03988f
C667 a_5661_9348# VDD3_3 0.88252f
C668 a_33173_8132# a_33174_7308# 0.01286f
C669 a_36859_5344# lnaf 0.02732f
C670 a_19159_9348# M2_1/nmosHV$3_priv4_0.D 0.16185f
C671 vref3 GROUP3$1_0.G 0.04973f
C672 GROUP4_1.G a_3927_n3082# 0.30541f
C673 vref2 pmosHV_priv26_2.S 1.66715f
C674 GROUP1$1$1_0.G VDD1_5 5.60623f
C675 a_18279_n12306# VDD3_3 0.03079f
C676 a_18279_n14164# q2 0.55538f
C677 a_31926_n2220# a_32836_n2566# 0.15162f
C678 M21_1/nmosHV$5_priv1_0.D a_22419_8666# 0.03711f
C679 GROUP1$1$3_0.G a_25120_n14164# 0.14901f
C680 GROUP1$3_0.nmosHV_priv3$3_0.S a_16514_n14164# 0.06026f
C681 M24_1/pmosHV$1_priv4_0.D a_37700_6620# 0.04009f
C682 a_31876_n4617# a_32800_n4617# 0.01052f
C683 GROUP1$3_0.G a_16453_n11482# 0.14967f
C684 M2_1/nmosHV$3_priv4_0.D a_23607_8300# 0.03745f
C685 GROUP4_1.G vref0 0.03503f
C686 a_11439_n12306# a_11378_n13340# 0.0643f
C687 a_36192_4490# Cap_M21 0.038f
C688 M24_0/pmosHV$1_priv4_0.D a_11042_6676# 0.04009f
C689 M23_1/pmosHV$1_priv3_0.D a_34131_8244# 0.0394f
C690 a_738_n10689# pmosHV_priv16_1.S 0.03529f
C691 a_34832_5136# lnaf 0.48847f
C692 a_11374_n854# VDD3_3 0.01272f
C693 a_7578_n10689# vref1 0.23624f
C694 a_36767_8244# VDD3_3 0.01071f
C695 M21_1/nmosHV$5_priv1_0.D M22_2/pmosHV$1_priv2_0.D 0.52109f
C696 M21_0/nmosHV$5_priv1_0.D M23_0/pmosHV$1_priv3_0.D 2.07569f
C697 a_19159_9348# VDD3_3 0.83396f
C698 M21_2/nmosHV$5_priv1_0.D a_35579_8610# 0.03711f
C699 M24_1/pmosHV$1_priv4_0.D VDD3_3 11.7315f
C700 GROUP1$4_0.nmosHV_priv3$4_0.S a_25120_n14164# 0.05687f
C701 nmosHV_priv13_2.D GROUP1$3_0.G 3.94644f
C702 VDD1_5 ACC_CAP 5.41528f
C703 M20_2/nmosHV$5_priv2_0.D a_30325_9076# 0.19696f
C704 GROUP1$3_0.G a_16514_n12306# 0.14917f
C705 a_2773_n11482# VDD3_3 1.19888f
C706 m2_32998_100# Cap_M21 0.17593f
C707 VDD3_3 a_11981_n3082# 0.38983f
C708 M2_2/nmosHV$3_priv4_0.D M21_2/nmosHV$5_priv1_0.D 0.51067f
C709 a_23032_1189# Cap_M2 0.03816f
C710 a_31876_n3196# VDD3_3 0.21871f
C711 a_4538_n13340# a_4599_n14164# 0.096f
C712 M21_1/nmosHV$5_priv1_0.D M23_2/pmosHV$1_priv3_0.D 2.07569f
C713 VDD1_5 vref3 0.74072f
C714 a_23607_8300# VDD3_3 0.01071f
C715 a_21258_n10689# nmosHV_priv13_2.D 0.02119f
C716 a_20013_8188# a_20014_7364# 0.01286f
C717 GROUP3$1_2.G a_11132_n3082# 0.04397f
C718 a_35579_8610# a_36244_8609# 0.0104f
C719 a_8297_8666# Cap_M1 0.03634f
C720 a_7473_8666# a_8297_8666# 0.01052f
C721 M20_2/nmosHV$5_priv2_0.D M22_1/pmosHV$1_priv2_0.D 0.26211f
C722 M2_2/nmosHV$3_priv4_0.D a_36244_8609# 0.11653f
C723 a_2834_n14164# a_1032_n17542# 0.06081f
C724 VDD1_5 vref2 1.21457f
C725 M24_2/pmosHV$1_priv4_0.D a_21672_5192# 0.02126f
C726 a_34955_8244# a_35579_8244# 0.01052f
C727 a_3498_n854# GROUP4_1.G 0.01904f
C728 a_3678_2278# vin 0.04999f
C729 a_7473_8300# VDD3_3 0.1371f
C730 M20_2/nmosHV$5_priv2_0.D VDD3_3 0.14122f
C731 M22_0/pmosHV$1_priv2_0.D VDD3_3 11.9588f
C732 M23_2/pmosHV$1_priv3_0.D a_20971_8300# 0.0394f
C733 M2_0/nmosHV$3_priv4_0.D a_10109_8666# 0.03745f
C734 GROUP3_0.G VDD3_3 12.214f
C735 M15_2/nmosHV$1_priv1_0.D a_23032_1189# 0.03229f
C736 GROUP1$1_0.G VDD3_3 2.26741f
C737 nmosHV_priv13_3.D a_11378_n11482# 0.03365f
C738 Cap_M11 Cap_M21 0.34624p
C739 VDD1_5 vref1 1.32996f
C740 a_18218_n11482# VDD3_3 1.56562f
C741 M20_1/nmosHV$5_priv2_0.D a_17165_9132# 0.19696f
C742 M24_1/pmosHV$1_priv4_0.D a_34832_5136# 0.02126f
C743 a_4599_n12306# VDD1_5 0.01988f
C744 M20_1/nmosHV$5_priv2_0.D a_16096_8209# 0.04173f
C745 a_34131_8610# M23_1/pmosHV$1_priv3_0.D 0.03902f
C746 a_1157_9868# M20_0/nmosHV$5_priv2_0.D 0.64018f
C747 M24_0/pmosHV$1_priv4_0.D Cap_M1 2.44657f
C748 M23_2/pmosHV$1_priv3_0.D Cap_M11 1.71633f
C749 VDD1_5 vref0 0.91109f
C750 a_21258_n10689# nmosHV_priv13_0.D 0.01809f
C751 GROUP1_0.G VDD3_3 8.5579f
C752 a_14418_n10689# GROUP1$3_0.G 0.11398f
C753 M22_2/pmosHV$1_priv2_0.D a_18592_7364# 0.04083f
C754 a_32319_9292# M23_1/pmosHV$1_priv3_0.D 0.02527f
C755 a_21672_5192# VDD3_3 0.68572f
C756 M16_0/nmosHV$2_priv1_0.D vin 0.49192f
C757 M22_2/pmosHV$1_priv2_0.D a_17176_2278# 0.04136f
C758 a_32836_n2566# opm 0.01905f
C759 M22_0/pmosHV$1_priv2_0.D a_6515_8188# 0.21591f
C760 a_23294_n11482# a_23355_n12306# 0.096f
C761 a_7578_n10689# nmosHV_priv13_1.D 0.02119f
C762 a_21795_8300# a_22419_8300# 0.01052f
C763 M22_1/pmosHV$1_priv2_0.D a_33173_8132# 0.21591f
C764 M15_1/nmosHV$1_priv1_0.D VDD3_3 2.65165f
C765 GROUP1$1$3_0.G VDD3_3 2.26739f
C766 nmosHV_priv13_0.D GROUP1$4_0.G 3.94649f
C767 M15_2/nmosHV$1_priv1_0.D Cap_M11 0.78168f
C768 a_17176_2278# Cap_M2 0.05221f
C769 a_33173_8132# VDD3_3 0.21572f
C770 a_11378_n13340# VDD1_5 1.54357f
C771 M15_2/nmosHV$1_priv1_0.D a_23699_5400# 0.09472f
C772 M20_2/nmosHV$5_priv2_0.D a_29256_8153# 0.04173f
C773 GROUP1$2_0.G VDD3_3 8.55582f
C774 a_9674_n14164# VDD1_5 0.01237f
C775 a_18726_n854# vref2 0.08611f
C776 a_3498_n854# VDD1_5 0.10301f
C777 a_738_n10689# GROUP1$1_0.G 0.10455f
C778 GROUP1$4_0.nmosHV_priv3$4_0.S VDD3_3 0.04443f
C779 GROUP1$1$2_0.G a_16453_n11482# 0.38882f
C780 pmosHV_priv24_0.S nmosHV_priv13_0.D 2.23672f
C781 a_4538_n11482# a_4599_n12306# 0.096f
C782 GROUP1$1$3_0.G a_25120_n12306# 0.49329f
C783 M15_1/nmosHV$1_priv1_0.D a_36859_5344# 0.09472f
C784 a_16453_n13340# q2 0.38866f
C785 VDD3_3 pmosHV_priv26_3.S 4.74951f
C786 a_18726_n854# vref1 0.05846f
C787 GROUP1$1$3_0.G a_23294_n13340# 0.14924f
C788 a_20013_8188# VDD3_3 0.21572f
C789 a_16095_9132# a_16096_8209# 0.01044f
C790 a_738_n10689# GROUP1_0.G 0.11398f
C791 a_7578_n10689# nmosHV_priv13_3.D 0.01809f
C792 a_17176_2278# M15_2/nmosHV$1_priv1_0.D 0.03799f
C793 GROUP1$2_0.G a_9613_n11482# 0.14967f
C794 M21_1/nmosHV$5_priv1_0.D a_20971_8666# 0.13104f
C795 GROUP1$1$2_0.G a_16514_n12306# 0.02783f
C796 GROUP3$1_2.G a_10767_n3082# 0.30541f
C797 a_14655_9868# M20_1/nmosHV$5_priv2_0.D 0.64018f
C798 a_36767_8244# lnaf 0.08848f
C799 a_14712_n17542# q2 0.17576f
C800 vref3 ACC_CAP 3.33985f
C801 nmosHV_priv13_1.D VDD1_5 0.03552f
C802 M22_1/pmosHV$1_priv2_0.D a_28486_6382# 0.07479f
C803 M24_1/pmosHV$1_priv4_0.D lnaf 2.51378f
C804 a_34832_5136# M15_1/nmosHV$1_priv1_0.D 0.13771f
C805 GROUP1$4_0.nmosHV_priv3$4_0.S a_23294_n13340# 0.07803f
C806 a_35579_8244# VDD3_3 0.10511f
C807 vref3 VSS 0.19281f
C808 vref2 VSS 0.19281f
C809 VDD1_5 VSS 14.44425f
C810 VDD3_3 VSS 0.1798p
C811 m2_32998_100# VSS 0.7207f ; **FLOATING
C812 m2_19838_156# VSS 0.7087f ; **FLOATING
C813 a_25120_n14164# VSS 1.21454f ; **FLOATING
C814 a_23355_n14164# VSS 1.65247f ; **FLOATING
C815 a_18279_n14164# VSS 1.21454f ; **FLOATING
C816 a_16514_n14164# VSS 1.65247f ; **FLOATING
C817 a_11439_n14164# VSS 1.21456f ; **FLOATING
C818 a_9674_n14164# VSS 1.65247f ; **FLOATING
C819 a_4599_n14164# VSS 1.21454f ; **FLOATING
C820 a_2834_n14164# VSS 1.65247f ; **FLOATING
C821 a_25059_n13340# VSS 0.15209f ; **FLOATING
C822 a_23294_n13340# VSS 0.17276f ; **FLOATING
C823 a_18218_n13340# VSS 0.15209f ; **FLOATING
C824 a_16453_n13340# VSS 0.17279f ; **FLOATING
C825 a_11378_n13340# VSS 0.15209f ; **FLOATING
C826 a_9613_n13340# VSS 0.17279f ; **FLOATING
C827 a_4538_n13340# VSS 0.15209f ; **FLOATING
C828 a_2773_n13340# VSS 0.16879f ; **FLOATING
C829 a_25120_n12306# VSS 1.19331f ; **FLOATING
C830 a_23355_n12306# VSS 1.19331f ; **FLOATING
C831 a_18279_n12306# VSS 1.19331f ; **FLOATING
C832 a_16514_n12306# VSS 1.19331f ; **FLOATING
C833 a_11439_n12306# VSS 1.19331f ; **FLOATING
C834 GROUP1$3_0.nmosHV_priv3$3_0.S VSS 13.44575f
C835 a_9674_n12306# VSS 1.19331f ; **FLOATING
C836 a_4599_n12306# VSS 1.19331f ; **FLOATING
C837 GROUP1$2_0.nmosHV_priv3$2_0.S VSS 13.4503f
C838 a_2834_n12306# VSS 1.19331f ; **FLOATING
C839 a_25059_n11482# VSS 0.16398f ; **FLOATING
C840 a_23294_n11482# VSS 0.18138f ; **FLOATING
C841 a_18218_n11482# VSS 0.16397f ; **FLOATING
C842 GROUP1$1$3_0.G VSS 0.94964f
C843 a_16453_n11482# VSS 0.18138f ; **FLOATING
C844 a_11378_n11482# VSS 0.16397f ; **FLOATING
C845 a_9613_n11482# VSS 0.18138f ; **FLOATING
C846 a_4538_n11482# VSS 0.16397f ; **FLOATING
C847 a_2773_n11482# VSS 0.18138f ; **FLOATING
C848 a_32800_n4617# VSS 0.01297f ; **FLOATING
C849 a_31876_n4617# VSS 0.01214f ; **FLOATING
C850 GROUP1$3_0.G VSS 0.0964f
C851 a_32800_n3196# VSS 0.01297f ; **FLOATING
C852 a_31876_n3196# VSS 0.01095f ; **FLOATING
C853 a_26026_n3082# VSS 0.02585f ; **FLOATING
C854 a_25661_n3082# VSS 0.02585f ; **FLOATING
C855 a_24812_n3082# VSS 0.02585f ; **FLOATING
C856 a_24447_n3082# VSS 0.02466f ; **FLOATING
C857 a_19186_n3082# VSS 0.02585f ; **FLOATING
C858 a_18821_n3082# VSS 0.02466f ; **FLOATING
C859 a_17972_n3082# VSS 0.02585f ; **FLOATING
C860 pmosHV_priv26_2.S VSS 0.0964f
C861 a_17607_n3082# VSS 0.02585f ; **FLOATING
C862 a_12346_n3082# VSS 0.02585f ; **FLOATING
C863 a_11981_n3082# VSS 0.02539f ; **FLOATING
C864 a_11132_n3082# VSS 0.02585f ; **FLOATING
C865 pmosHV_priv26_3.S VSS 0.0964f
C866 a_10767_n3082# VSS 0.02585f ; **FLOATING
C867 a_5506_n3082# VSS 0.02466f ; **FLOATING
C868 a_5141_n3082# VSS 0.02466f ; **FLOATING
C869 a_4292_n3082# VSS 0.02466f ; **FLOATING
C870 a_3927_n3082# VSS 0.02466f ; **FLOATING
C871 a_36192_1133# VSS 0.24595f ; **FLOATING
C872 a_34320_1142# VSS 0.16311f ; **FLOATING
C873 a_23032_1189# VSS 0.24595f ; **FLOATING
C874 a_21160_1198# VSS 0.16311f ; **FLOATING
C875 a_9534_1189# VSS 0.24595f ; **FLOATING
C876 a_7662_1198# VSS 0.16311f ; **FLOATING
C877 a_34320_1683# VSS 0.23118f ; **FLOATING
C878 a_37700_4358# VSS 0.03248f ; **FLOATING
C879 a_36192_4490# VSS 0.15113f ; **FLOATING
C880 a_36859_5344# VSS 0.14508f ; **FLOATING
C881 M15_1/nmosHV$1_priv1_0.D VSS 2.17439f
C882 a_37700_5780# VSS 0.03021f ; **FLOATING
C883 a_36859_5885# VSS 0.14514f ; **FLOATING
C884 a_37700_6620# VSS 0.03066f ; **FLOATING
C885 M16_1/nmosHV$2_priv1_0.D VSS 4.34877f
C886 a_21160_1739# VSS 0.23118f ; **FLOATING
C887 a_24540_4414# VSS 0.03087f ; **FLOATING
C888 a_23032_4546# VSS 0.15113f ; **FLOATING
C889 a_23699_5400# VSS 0.14504f ; **FLOATING
C890 M15_2/nmosHV$1_priv1_0.D VSS 0.04026f
C891 a_24540_5836# VSS 0.02884f ; **FLOATING
C892 a_23699_5941# VSS 0.14509f ; **FLOATING
C893 a_24540_6676# VSS 0.0293f ; **FLOATING
C894 a_33174_7308# VSS 0.01148f ; **FLOATING
C895 a_7662_1739# VSS 0.23118f ; **FLOATING
C896 a_11042_4414# VSS 0.03087f ; **FLOATING
C897 a_9534_4546# VSS 0.15113f ; **FLOATING
C898 a_10201_5400# VSS 0.14504f ; **FLOATING
C899 a_11042_5836# VSS 0.02884f ; **FLOATING
C900 a_10201_5941# VSS 0.14509f ; **FLOATING
C901 a_11042_6676# VSS 0.0293f ; **FLOATING
C902 a_31752_7308# VSS 0.01147f ; **FLOATING
C903 a_20014_7364# VSS 0.01148f ; **FLOATING
C904 a_37700_8041# VSS 0.0191f ; **FLOATING
C905 a_36767_8244# VSS 0.1086f ; **FLOATING
C906 a_36244_8243# VSS 0.18276f ; **FLOATING
C907 a_35579_8244# VSS 0.0235f ; **FLOATING
C908 a_34955_8244# VSS 0.10819f ; **FLOATING
C909 a_34131_8244# VSS 0.18495f ; **FLOATING
C910 M23_1/pmosHV$1_priv3_0.D VSS 0.96151f
C911 a_33173_8132# VSS 0.01107f ; **FLOATING
C912 a_18592_7364# VSS 0.01147f ; **FLOATING
C913 a_6516_7364# VSS 0.01148f ; **FLOATING
C914 a_36767_8610# VSS 0.19122f ; **FLOATING
C915 a_36244_8609# VSS 0.11484f ; **FLOATING
C916 a_35579_8610# VSS 0.11539f ; **FLOATING
C917 a_34955_8610# VSS 0.19118f ; **FLOATING
C918 a_34131_8610# VSS 0.19177f ; **FLOATING
C919 a_31752_8132# VSS 0.01152f ; **FLOATING
C920 a_30326_8153# VSS 0.23557f ; **FLOATING
C921 a_5094_7364# VSS 0.01147f ; **FLOATING
C922 a_29256_8153# VSS 0.4136f ; **FLOATING
C923 a_24540_8097# VSS 0.01894f ; **FLOATING
C924 a_23607_8300# VSS 0.1086f ; **FLOATING
C925 a_23084_8299# VSS 0.18276f ; **FLOATING
C926 a_22419_8300# VSS 0.0235f ; **FLOATING
C927 a_21795_8300# VSS 0.10819f ; **FLOATING
C928 a_20971_8300# VSS 0.18495f ; **FLOATING
C929 a_20013_8188# VSS 0.01107f ; **FLOATING
C930 a_23607_8666# VSS 0.19122f ; **FLOATING
C931 a_23084_8665# VSS 0.11484f ; **FLOATING
C932 a_22419_8666# VSS 0.11539f ; **FLOATING
C933 a_21795_8666# VSS 0.19118f ; **FLOATING
C934 a_20971_8666# VSS 0.19177f ; **FLOATING
C935 a_18592_8188# VSS 0.01152f ; **FLOATING
C936 a_17166_8209# VSS 0.23557f ; **FLOATING
C937 a_11042_8097# VSS 0.01894f ; **FLOATING
C938 a_16096_8209# VSS 0.4136f ; **FLOATING
C939 a_10109_8300# VSS 0.1086f ; **FLOATING
C940 a_9586_8299# VSS 0.18276f ; **FLOATING
C941 a_8921_8300# VSS 0.0235f ; **FLOATING
C942 a_8297_8300# VSS 0.10819f ; **FLOATING
C943 a_7473_8300# VSS 0.18495f ; **FLOATING
C944 a_6515_8188# VSS 0.01107f ; **FLOATING
C945 a_10109_8666# VSS 0.19122f ; **FLOATING
C946 a_9586_8665# VSS 0.11484f ; **FLOATING
C947 a_8921_8666# VSS 0.11539f ; **FLOATING
C948 a_8297_8666# VSS 0.19118f ; **FLOATING
C949 a_7473_8666# VSS 0.19177f ; **FLOATING
C950 a_5094_8188# VSS 0.01152f ; **FLOATING
C951 a_3668_8209# VSS 0.23557f ; **FLOATING
C952 a_30325_9076# VSS 0.22376f ; **FLOATING
C953 a_2598_8209# VSS 0.4136f ; **FLOATING
C954 M21_1/nmosHV$5_priv1_0.D VSS 10.36797f
C955 a_29255_9076# VSS 0.39753f ; **FLOATING
C956 a_17165_9132# VSS 0.22376f ; **FLOATING
C957 a_16095_9132# VSS 0.39753f ; **FLOATING
C958 a_3667_9132# VSS 0.22376f ; **FLOATING
C959 a_2597_9132# VSS 0.39753f ; **FLOATING
C960 VSS.t313 VSS 4.7959f
C961 VSS.t39 VSS 12.53189f
C962 VSS.t1 VSS 1.91081f
C963 VSS.t236 VSS 10.36828f
C964 VSS.t227 VSS 5.7782f
C965 VSS.t352 VSS 13.03985f
C966 VSS.t432 VSS 10.36797f
C967 VSS.t37 VSS 1.92303f
C968 VSS.t471 VSS 12.58314f
C969 VSS.t32 VSS 13.03985f
C970 VSS.t79 VSS 2.04658f
C971 VSS.t16 VSS 11.89605f
C972 VSS.t18 VSS 2.17439f
C973 VSS.t50 VSS 1.35675f
C974 VSS.t247 VSS 1.09001f
C975 VSS.t339 VSS 13.70415f
C976 VSS.t294 VSS 4.7959f
C977 VSS.t244 VSS 16.5337f
C978 VSS.t389 VSS 13.4503f
C979 VSS.t375 VSS 16.53175f
C980 VSS.t260 VSS 4.80406f
C981 VSS.t283 VSS 10.36868f
C982 VSS.t278 VSS 5.7782f
C983 VSS.t396 VSS 1.92303f
C984 VSS.t439 VSS 2.31366f
C985 VSS.t441 VSS 13.0437f
C986 VSS.t394 VSS 2.06112f
C987 VSS.t67 VSS 2.17439f
C988 VSS.t70 VSS 12.82995f
C989 VSS.t223 VSS 13.43375f
C990 VSS.t413 VSS 13.44575f
C991 VSS.t407 VSS 13.8098f
C992 VSS.t361 VSS 8.95515f
C993 VSS.t274 VSS 16.5342f
C994 VSS.t398 VSS 9.77625f
C995 VSS.t221 VSS 2.04658f
C996 VSS.t459 VSS 2.17439f
C997 VSS.t447 VSS 8.6913f
C998 VSS.t345 VSS 1.17767f
C999 VSS.t329 VSS 1.74872f
C1000 VSS.t343 VSS 17.1404f
C1001 VDD3_3.n0 VSS 0.50923f
C1002 VDD3_3.n1 VSS 0.08138f
C1003 VDD3_3.n2 VSS 0.05048f
C1004 VDD3_3.n3 VSS 3.53503f
C1005 VDD3_3.n4 VSS 0.91203f
C1006 VDD3_3.n5 VSS 0.50923f
C1007 VDD3_3.n6 VSS 0.08138f
C1008 VDD3_3.n7 VSS 0.05048f
C1009 VDD3_3.n8 VSS 3.53503f
C1010 VDD3_3.n9 VSS 0.91203f
C1011 VDD3_3.n10 VSS 0.05048f
C1012 VDD3_3.n11 VSS 0.46252f
C1013 VDD3_3.n12 VSS 0.08138f
C1014 VDD3_3.n13 VSS 1.63261f
C1015 VDD3_3.n14 VSS 0.8545f
C1016 VDD3_3.n15 VSS 1.04098f
C1017 VDD3_3.n16 VSS 1.04098f
C1018 VDD3_3.n17 VSS 0.33742f
C1019 VDD3_3.n18 VSS 0.33742f
C1020 VDD3_3.n19 VSS 0.41254f
C1021 VDD3_3.n20 VSS 0.33742f
C1022 VDD3_3.n21 VSS 0.73682f
C1023 VDD3_3.n22 VSS 0.3194f
C1024 VDD3_3.n23 VSS 0.30317f
C1025 VDD3_3.n24 VSS 0.41278f
C1026 VDD3_3.n25 VSS 0.0352f
C1027 VDD3_3.n26 VSS 0.01364f
C1028 VDD3_3.n27 VSS 0.05878f
C1029 VDD3_3.n28 VSS 0.01364f
C1030 VDD3_3.n29 VSS 0.0352f
C1031 VDD3_3.n30 VSS 0.01364f
C1032 VDD3_3.n31 VSS 0.05878f
C1033 VDD3_3.n32 VSS 0.01364f
C1034 VDD3_3.n33 VSS 0.05878f
C1035 VDD3_3.n34 VSS 0.01364f
C1036 VDD3_3.n35 VSS 0.0352f
C1037 VDD3_3.n36 VSS 0.01364f
C1038 VDD3_3.n37 VSS 0.05878f
C1039 VDD3_3.n38 VSS 0.01364f
C1040 VDD3_3.n39 VSS 0.0352f
C1041 VDD3_3.n40 VSS 0.01364f
C1042 VDD3_3.n41 VSS 0.0352f
C1043 VDD3_3.n42 VSS 0.01364f
C1044 VDD3_3.n43 VSS 0.05878f
C1045 VDD3_3.n44 VSS 0.01364f
C1046 VDD3_3.n45 VSS 0.0352f
C1047 VDD3_3.n46 VSS 0.01364f
C1048 VDD3_3.n47 VSS 0.05878f
C1049 VDD3_3.n48 VSS 0.01364f
C1050 VDD3_3.n49 VSS 0.05878f
C1051 VDD3_3.n50 VSS 0.01364f
C1052 VDD3_3.n51 VSS 0.0352f
C1053 VDD3_3.n52 VSS 0.01364f
C1054 VDD3_3.n53 VSS 0.05878f
C1055 VDD3_3.n54 VSS 0.01364f
C1056 VDD3_3.n55 VSS 0.0352f
C1057 VDD3_3.n56 VSS 0.01364f
C1058 VDD3_3.n57 VSS 0.05878f
C1059 VDD3_3.n58 VSS 0.01364f
C1060 VDD3_3.n59 VSS 0.0352f
C1061 VDD3_3.n60 VSS 0.01364f
C1062 VDD3_3.n61 VSS 0.05878f
C1063 VDD3_3.n62 VSS 0.01364f
C1064 VDD3_3.n63 VSS 0.0352f
C1065 VDD3_3.n64 VSS 0.01364f
C1066 VDD3_3.n65 VSS 0.0352f
C1067 VDD3_3.n66 VSS 0.01364f
C1068 VDD3_3.n67 VSS 0.05878f
C1069 VDD3_3.n68 VSS 0.01364f
C1070 VDD3_3.n69 VSS 0.0352f
C1071 VDD3_3.n70 VSS 0.01364f
C1072 VDD3_3.n71 VSS 0.05878f
C1073 VDD3_3.n72 VSS 0.01364f
C1074 VDD3_3.n73 VSS 0.05878f
C1075 VDD3_3.n74 VSS 0.01364f
C1076 VDD3_3.n75 VSS 0.0352f
C1077 VDD3_3.n76 VSS 0.01364f
C1078 VDD3_3.n77 VSS 0.05878f
C1079 VDD3_3.n78 VSS 0.01364f
C1080 VDD3_3.n79 VSS 0.0352f
C1081 VDD3_3.n80 VSS 0.01364f
C1082 VDD3_3.t66 VSS 0.15486f
C1083 VDD3_3.t19 VSS 5.97496f
C1084 VDD3_3.t176 VSS 0.07939f
C1085 VDD3_3.n81 VSS 0.03461f
C1086 VDD3_3.t177 VSS 0.07939f
C1087 VDD3_3.n82 VSS 0.02822f
C1088 VDD3_3.t69 VSS 0.06671f
C1089 VDD3_3.n83 VSS 0.02978f
C1090 VDD3_3.t58 VSS 1.34355f
C1091 VDD3_3.t62 VSS 0.16945f
C1092 VDD3_3.n84 VSS 0.02978f
C1093 VDD3_3.n85 VSS 0.06244f
C1094 VDD3_3.n86 VSS 0.06244f
C1095 VDD3_3.t55 VSS 3.8611f
C1096 VDD3_3.t16 VSS 3.86758f
C1097 VDD3_3.t188 VSS 0.326f
C1098 VDD3_3.n87 VSS 0.57551f
C1099 VDD3_3.t189 VSS 0.32033f
C1100 VDD3_3.n88 VSS 0.22369f
C1101 VDD3_3.t86 VSS 0.9923f
C1102 VDD3_3.n89 VSS 0.11697f
C1103 VDD3_3.t85 VSS 5.21102f
C1104 VDD3_3.n90 VSS 3.19697f
C1105 VDD3_3.t40 VSS 17.5365f
C1106 VDD3_3.n91 VSS 2.6221f
C1107 VDD3_3.n92 VSS 0.02579f
C1108 VDD3_3.n93 VSS 0.01123f
C1109 VDD3_3.n94 VSS 0.01123f
C1110 VDD3_3.n95 VSS 0.02245f
C1111 VDD3_3.n96 VSS 0.02245f
C1112 VDD3_3.n97 VSS 0.02245f
C1113 VDD3_3.n98 VSS 0.01123f
C1114 VDD3_3.n99 VSS 0.01123f
C1115 VDD3_3.n100 VSS 0.02245f
C1116 VDD3_3.n101 VSS 0.02245f
C1117 VDD3_3.t170 VSS 0.14824f
C1118 VDD3_3.n102 VSS 0.02245f
C1119 VDD3_3.n103 VSS 0.02245f
C1120 VDD3_3.t171 VSS 0.14824f
C1121 VDD3_3.n104 VSS 0.04938f
C1122 VDD3_3.n105 VSS 0.02822f
C1123 VDD3_3.t18 VSS 0.09324f
C1124 VDD3_3.n106 VSS 0.03183f
C1125 VDD3_3.n107 VSS 0.02579f
C1126 VDD3_3.n108 VSS 0.01123f
C1127 VDD3_3.n109 VSS 0.01123f
C1128 VDD3_3.n110 VSS 0.02245f
C1129 VDD3_3.n111 VSS 0.02245f
C1130 VDD3_3.n112 VSS 0.02245f
C1131 VDD3_3.n113 VSS 0.02245f
C1132 VDD3_3.n114 VSS 0.02245f
C1133 VDD3_3.n115 VSS 0.02245f
C1134 VDD3_3.t167 VSS 0.14824f
C1135 VDD3_3.n116 VSS 0.02245f
C1136 VDD3_3.n117 VSS 0.02245f
C1137 VDD3_3.t168 VSS 0.14824f
C1138 VDD3_3.n118 VSS 0.04938f
C1139 VDD3_3.n119 VSS 0.02822f
C1140 VDD3_3.t17 VSS 9.8685f
C1141 VDD3_3.n120 VSS 0.04379f
C1142 VDD3_3.n121 VSS 0.60875f
C1143 VDD3_3.n122 VSS 0.61979f
C1144 VDD3_3.n123 VSS 0.25635f
C1145 VDD3_3.t44 VSS 3.86758f
C1146 VDD3_3.t185 VSS 0.326f
C1147 VDD3_3.n124 VSS 0.57551f
C1148 VDD3_3.t186 VSS 0.32033f
C1149 VDD3_3.n125 VSS 0.22369f
C1150 VDD3_3.t101 VSS 0.04266f
C1151 VDD3_3.n126 VSS 0.11701f
C1152 VDD3_3.t15 VSS 5.18859f
C1153 VDD3_3.n127 VSS 3.19717f
C1154 VDD3_3.t45 VSS 17.5365f
C1155 VDD3_3.n128 VSS 2.62221f
C1156 VDD3_3.n129 VSS 0.02579f
C1157 VDD3_3.t164 VSS 0.14824f
C1158 VDD3_3.n130 VSS 0.02245f
C1159 VDD3_3.n131 VSS 0.01123f
C1160 VDD3_3.n132 VSS 0.02245f
C1161 VDD3_3.n133 VSS 0.02245f
C1162 VDD3_3.n134 VSS 0.01123f
C1163 VDD3_3.n135 VSS 0.02245f
C1164 VDD3_3.n136 VSS 0.02245f
C1165 VDD3_3.n137 VSS 0.02245f
C1166 VDD3_3.n138 VSS 0.01123f
C1167 VDD3_3.n139 VSS 0.02245f
C1168 VDD3_3.t165 VSS 0.14824f
C1169 VDD3_3.n140 VSS 0.01123f
C1170 VDD3_3.n141 VSS 0.04938f
C1171 VDD3_3.n142 VSS 0.02822f
C1172 VDD3_3.t46 VSS 0.09324f
C1173 VDD3_3.n143 VSS 0.03183f
C1174 VDD3_3.n144 VSS 0.02579f
C1175 VDD3_3.n145 VSS 0.01123f
C1176 VDD3_3.n146 VSS 0.01123f
C1177 VDD3_3.n147 VSS 0.02245f
C1178 VDD3_3.n148 VSS 0.02245f
C1179 VDD3_3.n149 VSS 0.02245f
C1180 VDD3_3.n150 VSS 0.01123f
C1181 VDD3_3.n151 VSS 0.02245f
C1182 VDD3_3.n152 VSS 0.02245f
C1183 VDD3_3.n153 VSS 0.01123f
C1184 VDD3_3.t161 VSS 0.14824f
C1185 VDD3_3.n154 VSS 0.02245f
C1186 VDD3_3.n155 VSS 0.02245f
C1187 VDD3_3.t162 VSS 0.14824f
C1188 VDD3_3.n156 VSS 0.04938f
C1189 VDD3_3.n157 VSS 0.02822f
C1190 VDD3_3.t47 VSS 8.36008f
C1191 VDD3_3.n158 VSS 0.04379f
C1192 VDD3_3.n159 VSS 0.60875f
C1193 VDD3_3.n160 VSS 0.61979f
C1194 VDD3_3.n161 VSS 0.25635f
C1195 VDD3_3.t48 VSS 3.86758f
C1196 VDD3_3.t182 VSS 0.326f
C1197 VDD3_3.n162 VSS 0.57551f
C1198 VDD3_3.t183 VSS 0.32033f
C1199 VDD3_3.n163 VSS 0.22369f
C1200 VDD3_3.t52 VSS 0.04266f
C1201 VDD3_3.n164 VSS 0.11701f
C1202 VDD3_3.t51 VSS 5.16838f
C1203 VDD3_3.n165 VSS 3.19717f
C1204 VDD3_3.t49 VSS 17.5365f
C1205 VDD3_3.n166 VSS 2.62221f
C1206 VDD3_3.n167 VSS 0.02579f
C1207 VDD3_3.n168 VSS 0.01123f
C1208 VDD3_3.n169 VSS 0.02245f
C1209 VDD3_3.n170 VSS 0.01123f
C1210 VDD3_3.n171 VSS 0.02245f
C1211 VDD3_3.n172 VSS 0.02245f
C1212 VDD3_3.n173 VSS 0.01123f
C1213 VDD3_3.n174 VSS 0.01123f
C1214 VDD3_3.n175 VSS 0.02245f
C1215 VDD3_3.n176 VSS 0.02245f
C1216 VDD3_3.t158 VSS 0.14824f
C1217 VDD3_3.n177 VSS 0.02245f
C1218 VDD3_3.n178 VSS 0.02245f
C1219 VDD3_3.t159 VSS 0.14824f
C1220 VDD3_3.n179 VSS 0.04938f
C1221 VDD3_3.n180 VSS 0.02822f
C1222 VDD3_3.t53 VSS 0.09324f
C1223 VDD3_3.n181 VSS 0.03183f
C1224 VDD3_3.n182 VSS 0.02579f
C1225 VDD3_3.n183 VSS 0.01123f
C1226 VDD3_3.n184 VSS 0.02245f
C1227 VDD3_3.n185 VSS 0.01123f
C1228 VDD3_3.n186 VSS 0.02245f
C1229 VDD3_3.n187 VSS 0.02245f
C1230 VDD3_3.n188 VSS 0.02245f
C1231 VDD3_3.n189 VSS 0.02245f
C1232 VDD3_3.n190 VSS 0.02245f
C1233 VDD3_3.t155 VSS 0.14824f
C1234 VDD3_3.n192 VSS 0.02245f
C1235 VDD3_3.n193 VSS 0.02245f
C1236 VDD3_3.t156 VSS 0.14824f
C1237 VDD3_3.n194 VSS 0.04938f
C1238 VDD3_3.n195 VSS 0.02822f
C1239 VDD3_3.t54 VSS 9.87034f
C1240 VDD3_3.n196 VSS 0.04379f
C1241 VDD3_3.n197 VSS 0.60875f
C1242 VDD3_3.n198 VSS 0.61979f
C1243 VDD3_3.n199 VSS 0.25635f
C1244 VDD3_3.t41 VSS 3.86758f
C1245 VDD3_3.t179 VSS 0.326f
C1246 VDD3_3.n200 VSS 0.57551f
C1247 VDD3_3.t180 VSS 0.32033f
C1248 VDD3_3.n201 VSS 0.22369f
C1249 VDD3_3.t191 VSS 6.53058f
C1250 VDD3_3.n202 VSS 0.11701f
C1251 VDD3_3.t84 VSS 5.17757f
C1252 VDD3_3.n203 VSS 3.19717f
C1253 VDD3_3.t42 VSS 17.5365f
C1254 VDD3_3.n204 VSS 2.62221f
C1255 VDD3_3.n205 VSS 0.02579f
C1256 VDD3_3.t152 VSS 0.14824f
C1257 VDD3_3.n206 VSS 0.01123f
C1258 VDD3_3.n207 VSS 0.01123f
C1259 VDD3_3.n208 VSS 0.01123f
C1260 VDD3_3.n209 VSS 0.02245f
C1261 VDD3_3.n210 VSS 0.02245f
C1262 VDD3_3.n211 VSS 0.01123f
C1263 VDD3_3.n212 VSS 0.02245f
C1264 VDD3_3.n213 VSS 0.02245f
C1265 VDD3_3.n214 VSS 0.01123f
C1266 VDD3_3.n215 VSS 0.02245f
C1267 VDD3_3.n216 VSS 0.02245f
C1268 VDD3_3.t153 VSS 0.14824f
C1269 VDD3_3.n217 VSS 0.01123f
C1270 VDD3_3.n218 VSS 0.04938f
C1271 VDD3_3.n219 VSS 0.02822f
C1272 VDD3_3.t194 VSS 8.66343f
C1273 VDD3_3.n220 VSS 0.03183f
C1274 VDD3_3.n221 VSS 0.02579f
C1275 VDD3_3.n222 VSS 0.01123f
C1276 VDD3_3.n223 VSS 0.01123f
C1277 VDD3_3.n224 VSS 0.02245f
C1278 VDD3_3.n225 VSS 0.02245f
C1279 VDD3_3.n226 VSS 0.02245f
C1280 VDD3_3.n227 VSS 0.02245f
C1281 VDD3_3.n228 VSS 0.02245f
C1282 VDD3_3.n229 VSS 0.02245f
C1283 VDD3_3.t149 VSS 0.14824f
C1284 VDD3_3.n230 VSS 0.02245f
C1285 VDD3_3.n231 VSS 0.02245f
C1286 VDD3_3.t150 VSS 0.14824f
C1287 VDD3_3.n232 VSS 0.04938f
C1288 VDD3_3.n233 VSS 0.02822f
C1289 VDD3_3.t195 VSS 1.64693f
C1290 VDD3_3.n234 VSS 0.04379f
C1291 VDD3_3.n235 VSS 0.60875f
C1292 VDD3_3.n236 VSS 0.61979f
C1293 VDD3_3.n237 VSS 0.25635f
C1294 VDD3_3.t210 VSS 20.76553f
C1295 VDD3_3.n238 VSS 0.14482f
C1296 VDD3_3.n239 VSS 0.34704f
C1297 VDD3_3.n240 VSS 0.36751f
C1298 VDD3_3.n241 VSS 0.31494f
C1299 VDD3_3.n242 VSS 0.22715f
C1300 VDD3_3.n243 VSS 0.38856f
C1301 VDD3_3.n244 VSS 0.94478f
C1302 VDD3_3.n245 VSS 0.0267f
C1303 VDD3_3.t107 VSS 0.06218f
C1304 VDD3_3.t108 VSS 0.06218f
C1305 VDD3_3.n246 VSS 0.01214f
C1306 VDD3_3.n247 VSS 0.02427f
C1307 VDD3_3.n248 VSS 0.01214f
C1308 VDD3_3.n249 VSS 0.05029f
C1309 VDD3_3.n250 VSS 0.02822f
C1310 VDD3_3.t192 VSS 0.03105f
C1311 VDD3_3.n251 VSS 0.02544f
C1312 VDD3_3.n252 VSS 0.27656f
C1313 VDD3_3.n253 VSS 0.09339f
C1314 VDD3_3.n254 VSS 0.27167f
C1315 VDD3_3.n255 VSS 0.22727f
C1316 VDD3_3.n256 VSS 0.07746f
C1317 VDD3_3.t26 VSS 2.4168f
C1318 VDD3_3.n257 VSS 0.10799f
C1319 VDD3_3.t28 VSS 1.08475f
C1320 VDD3_3.n258 VSS 0.10269f
C1321 VDD3_3.t23 VSS 0.04266f
C1322 VDD3_3.n259 VSS 0.03461f
C1323 VDD3_3.t110 VSS 0.07939f
C1324 VDD3_3.t111 VSS 0.07939f
C1325 VDD3_3.n260 VSS 0.02822f
C1326 VDD3_3.n261 VSS 0.02405f
C1327 VDD3_3.n262 VSS 0.05747f
C1328 VDD3_3.t24 VSS 0.06146f
C1329 VDD3_3.n263 VSS 0.10799f
C1330 VDD3_3.n264 VSS 0.10269f
C1331 VDD3_3.n265 VSS 0.06272f
C1332 VDD3_3.n266 VSS 0.25612f
C1333 VDD3_3.n267 VSS 0.22727f
C1334 VDD3_3.n268 VSS 0.22727f
C1335 VDD3_3.n269 VSS 0.22727f
C1336 VDD3_3.n270 VSS 0.23256f
C1337 VDD3_3.t22 VSS 0.04266f
C1338 VDD3_3.n271 VSS 0.03461f
C1339 VDD3_3.t140 VSS 0.07939f
C1340 VDD3_3.t141 VSS 0.07939f
C1341 VDD3_3.n272 VSS 0.02822f
C1342 VDD3_3.n273 VSS 0.02405f
C1343 VDD3_3.n274 VSS 0.22727f
C1344 VDD3_3.t30 VSS 0.06146f
C1345 VDD3_3.n275 VSS 0.08275f
C1346 VDD3_3.n276 VSS 0.07746f
C1347 VDD3_3.n277 VSS 0.06016f
C1348 VDD3_3.t32 VSS 0.06146f
C1349 VDD3_3.t34 VSS 0.06146f
C1350 VDD3_3.n278 VSS 0.06327f
C1351 VDD3_3.n279 VSS 0.08188f
C1352 VDD3_3.n280 VSS 0.07658f
C1353 VDD3_3.n281 VSS 0.09339f
C1354 VDD3_3.n282 VSS 0.06619f
C1355 VDD3_3.n283 VSS 0.14935f
C1356 VDD3_3.n284 VSS 0.11779f
C1357 VDD3_3.n285 VSS 0.02714f
C1358 VDD3_3.n286 VSS 0.11722f
C1359 VDD3_3.n287 VSS 0.12977f
C1360 VDD3_3.n288 VSS 0.1032f
C1361 VDD3_3.n289 VSS 0.37658f
C1362 VDD3_3.n290 VSS 0.366f
C1363 VDD3_3.n291 VSS 0.17825f
C1364 VDD3_3.n292 VSS 0.56f
C1365 VDD3_3.t21 VSS 12.7865f
C1366 VDD3_3.t213 VSS 0.06146f
C1367 VDD3_3.n293 VSS 0.05048f
C1368 VDD3_3.t212 VSS 0.04266f
C1369 VDD3_3.t104 VSS 0.07939f
C1370 VDD3_3.n294 VSS 0.03461f
C1371 VDD3_3.t105 VSS 0.07939f
C1372 VDD3_3.n295 VSS 0.02822f
C1373 VDD3_3.n296 VSS 0.02405f
C1374 VDD3_3.n297 VSS 0.02978f
C1375 VDD3_3.t217 VSS 0.06146f
C1376 VDD3_3.n298 VSS 0.03122f
C1377 VDD3_3.t215 VSS 0.06146f
C1378 VDD3_3.n299 VSS 0.05048f
C1379 VDD3_3.n300 VSS 0.02978f
C1380 VDD3_3.n301 VSS 0.06244f
C1381 VDD3_3.n302 VSS 0.06244f
C1382 VDD3_3.t219 VSS 0.06146f
C1383 VDD3_3.t211 VSS 1.60767f
C1384 VDD3_3.t122 VSS 0.07939f
C1385 VDD3_3.n303 VSS 0.03461f
C1386 VDD3_3.t123 VSS 0.07939f
C1387 VDD3_3.n304 VSS 0.02822f
C1388 VDD3_3.n305 VSS 0.02405f
C1389 VDD3_3.n306 VSS 0.02978f
C1390 VDD3_3.t223 VSS 1.01687f
C1391 VDD3_3.n307 VSS 0.03109f
C1392 VDD3_3.t221 VSS 0.06146f
C1393 VDD3_3.n308 VSS 0.05048f
C1394 VDD3_3.n309 VSS 0.02978f
C1395 VDD3_3.n310 VSS 0.06244f
C1396 VDD3_3.n311 VSS 0.06244f
C1397 VDD3_3.n312 VSS 0.46252f
C1398 VDD3_3.n313 VSS 0.44013f
C1399 VDD3_3.n314 VSS 0.44013f
C1400 VDD3_3.n315 VSS 0.22715f
C1401 VDD3_3.n316 VSS 0.33279f
C1402 VDD3_3.n317 VSS 0.50836f
C1403 VDD3_3.n318 VSS 0.48497f
C1404 VDD3_3.n319 VSS 0.31235f
C1405 VDD3_3.n320 VSS 0.30502f
C1406 VDD3_3.n321 VSS 0.28664f
C1407 VDD3_3.n322 VSS 0.17445f
C1408 VDD3_3.n323 VSS 0.3269f
C1409 VDD3_3.n324 VSS 0.32208f
C1410 VDD3_3.n325 VSS 0.39516f
C1411 VDD3_3.n326 VSS 0.39332f
C1412 VDD3_3.t36 VSS 26.12988f
C1413 VDD3_3.n327 VSS 0.58226f
C1414 VDD3_3.n328 VSS 0.44884f
C1415 VDD3_3.n329 VSS 0.50273f
C1416 VDD3_3.n330 VSS 0.3566f
C1417 VDD3_3.n331 VSS 0.21475f
C1418 VDD3_3.n332 VSS 0.28664f
C1419 VDD3_3.n333 VSS 0.30502f
C1420 VDD3_3.n334 VSS 0.31256f
C1421 VDD3_3.t193 VSS 20.78784f
C1422 VDD3_3.n335 VSS 0.36383f
C1423 VDD3_3.n336 VSS 0.45331f
C1424 VDD3_3.n337 VSS 0.52302f
C1425 VDD3_3.n338 VSS 0.33577f
C1426 VDD3_3.t225 VSS 21.08519f
C1427 VDD3_3.n339 VSS 2.30665f
C1428 VDD3_3.n340 VSS 0.44013f
C1429 VDD3_3.t198 VSS 0.06146f
C1430 VDD3_3.n341 VSS 0.05048f
C1431 VDD3_3.t197 VSS 0.04266f
C1432 VDD3_3.t113 VSS 0.07939f
C1433 VDD3_3.n342 VSS 0.03461f
C1434 VDD3_3.t114 VSS 0.07939f
C1435 VDD3_3.n343 VSS 0.02822f
C1436 VDD3_3.n344 VSS 0.02405f
C1437 VDD3_3.n345 VSS 0.02978f
C1438 VDD3_3.t202 VSS 0.06146f
C1439 VDD3_3.n346 VSS 0.03122f
C1440 VDD3_3.t200 VSS 1.02297f
C1441 VDD3_3.n347 VSS 0.05048f
C1442 VDD3_3.n348 VSS 0.02978f
C1443 VDD3_3.n349 VSS 0.06244f
C1444 VDD3_3.n350 VSS 0.06244f
C1445 VDD3_3.t204 VSS 1.62646f
C1446 VDD3_3.t196 VSS 0.04266f
C1447 VDD3_3.t128 VSS 0.07939f
C1448 VDD3_3.n351 VSS 0.03461f
C1449 VDD3_3.t129 VSS 0.07939f
C1450 VDD3_3.n352 VSS 0.02822f
C1451 VDD3_3.n353 VSS 0.02405f
C1452 VDD3_3.n354 VSS 0.02978f
C1453 VDD3_3.t208 VSS 0.06146f
C1454 VDD3_3.n355 VSS 0.03109f
C1455 VDD3_3.t206 VSS 0.06146f
C1456 VDD3_3.n356 VSS 0.05048f
C1457 VDD3_3.n357 VSS 0.02978f
C1458 VDD3_3.n358 VSS 0.06244f
C1459 VDD3_3.n359 VSS 0.06244f
C1460 VDD3_3.n360 VSS 0.0267f
C1461 VDD3_3.t116 VSS 0.06218f
C1462 VDD3_3.t117 VSS 0.06218f
C1463 VDD3_3.n361 VSS 0.01214f
C1464 VDD3_3.n362 VSS 0.02427f
C1465 VDD3_3.n363 VSS 0.01214f
C1466 VDD3_3.n364 VSS 0.05029f
C1467 VDD3_3.n365 VSS 0.02822f
C1468 VDD3_3.t102 VSS 0.03105f
C1469 VDD3_3.n366 VSS 0.02544f
C1470 VDD3_3.n367 VSS 0.27656f
C1471 VDD3_3.n368 VSS 0.06619f
C1472 VDD3_3.t78 VSS 0.06146f
C1473 VDD3_3.n369 VSS 0.08275f
C1474 VDD3_3.t80 VSS 1.08475f
C1475 VDD3_3.t82 VSS 0.06146f
C1476 VDD3_3.n370 VSS 0.06327f
C1477 VDD3_3.n371 VSS 0.09339f
C1478 VDD3_3.n372 VSS 0.22727f
C1479 VDD3_3.n373 VSS 0.22727f
C1480 VDD3_3.t72 VSS 0.06146f
C1481 VDD3_3.n374 VSS 0.10799f
C1482 VDD3_3.t74 VSS 2.41646f
C1483 VDD3_3.n375 VSS 0.10269f
C1484 VDD3_3.t71 VSS 0.04266f
C1485 VDD3_3.n376 VSS 0.03461f
C1486 VDD3_3.t119 VSS 0.07939f
C1487 VDD3_3.t120 VSS 0.07939f
C1488 VDD3_3.n377 VSS 0.02822f
C1489 VDD3_3.n378 VSS 0.02405f
C1490 VDD3_3.n379 VSS 0.05747f
C1491 VDD3_3.n380 VSS 0.06272f
C1492 VDD3_3.n381 VSS 0.22727f
C1493 VDD3_3.n382 VSS 0.25612f
C1494 VDD3_3.n383 VSS 0.10269f
C1495 VDD3_3.n384 VSS 0.10799f
C1496 VDD3_3.t76 VSS 0.06146f
C1497 VDD3_3.n385 VSS 0.23256f
C1498 VDD3_3.t70 VSS 0.04266f
C1499 VDD3_3.n386 VSS 0.03461f
C1500 VDD3_3.t143 VSS 0.07939f
C1501 VDD3_3.t144 VSS 0.07939f
C1502 VDD3_3.n387 VSS 0.02822f
C1503 VDD3_3.n388 VSS 0.02405f
C1504 VDD3_3.n389 VSS 0.22727f
C1505 VDD3_3.n390 VSS 0.22727f
C1506 VDD3_3.n391 VSS 0.07746f
C1507 VDD3_3.n392 VSS 0.07746f
C1508 VDD3_3.n393 VSS 0.27167f
C1509 VDD3_3.n394 VSS 0.06016f
C1510 VDD3_3.n395 VSS 0.07658f
C1511 VDD3_3.n396 VSS 0.08188f
C1512 VDD3_3.n397 VSS 0.09339f
C1513 VDD3_3.n398 VSS 0.14935f
C1514 VDD3_3.n399 VSS 0.11779f
C1515 VDD3_3.n400 VSS 0.02714f
C1516 VDD3_3.n401 VSS 0.11722f
C1517 VDD3_3.n402 VSS 0.12977f
C1518 VDD3_3.n403 VSS 0.1032f
C1519 VDD3_3.n404 VSS 0.37658f
C1520 VDD3_3.n405 VSS 0.366f
C1521 VDD3_3.n406 VSS 0.17825f
C1522 VDD3_3.n407 VSS 0.56f
C1523 VDD3_3.t20 VSS 12.7865f
C1524 VDD3_3.n408 VSS 0.94478f
C1525 VDD3_3.n409 VSS 0.46252f
C1526 VDD3_3.n410 VSS 0.44013f
C1527 VDD3_3.n411 VSS 1.48079f
C1528 VDD3_3.n412 VSS 0.22715f
C1529 VDD3_3.n413 VSS 0.22715f
C1530 VDD3_3.n414 VSS 0.87896f
C1531 VDD3_3.n415 VSS 0.33577f
C1532 VDD3_3.n416 VSS 0.38856f
C1533 VDD3_3.n417 VSS 0.38856f
C1534 VDD3_3.n418 VSS 0.52302f
C1535 VDD3_3.n419 VSS 0.50836f
C1536 VDD3_3.n420 VSS 0.50836f
C1537 VDD3_3.n421 VSS 0.45331f
C1538 VDD3_3.n422 VSS 0.42355f
C1539 VDD3_3.n423 VSS 0.48497f
C1540 VDD3_3.n424 VSS 0.35933f
C1541 VDD3_3.n425 VSS 0.06674f
C1542 VDD3_3.n426 VSS 0.31235f
C1543 VDD3_3.n427 VSS 0.36366f
C1544 VDD3_3.n428 VSS 0.36366f
C1545 VDD3_3.n429 VSS 0.30502f
C1546 VDD3_3.n430 VSS 0.30764f
C1547 VDD3_3.n431 VSS 0.30764f
C1548 VDD3_3.n432 VSS 0.28664f
C1549 VDD3_3.n433 VSS 0.16761f
C1550 VDD3_3.n434 VSS 0.16761f
C1551 VDD3_3.n435 VSS 0.25791f
C1552 VDD3_3.n436 VSS 0.31421f
C1553 VDD3_3.n437 VSS 0.34965f
C1554 VDD3_3.n438 VSS 0.2538f
C1555 VDD3_3.n439 VSS 0.47892f
C1556 VDD3_3.n440 VSS 0.83368f
C1557 VDD3_3.n441 VSS 0.42037f
C1558 VDD3_3.n442 VSS 0.16104f
C1559 VDD3_3.t43 VSS 26.51476f
C1560 VDD3_3.n443 VSS 0.28664f
C1561 VDD3_3.n444 VSS 0.30502f
C1562 VDD3_3.n445 VSS 0.31256f
C1563 VDD3_3.t50 VSS 20.78924f
C1564 VDD3_3.n446 VSS 0.36383f
C1565 VDD3_3.n447 VSS 0.45331f
C1566 VDD3_3.n448 VSS 0.52302f
C1567 VDD3_3.n449 VSS 0.33577f
C1568 VDD3_3.n450 VSS 0.22715f
C1569 VDD3_3.t190 VSS 21.08519f
C1570 VDD3_3.t2 VSS 0.06146f
C1571 VDD3_3.n451 VSS 0.05048f
C1572 VDD3_3.t1 VSS 0.04266f
C1573 VDD3_3.t125 VSS 0.07939f
C1574 VDD3_3.n452 VSS 0.03461f
C1575 VDD3_3.t126 VSS 0.07939f
C1576 VDD3_3.n453 VSS 0.02822f
C1577 VDD3_3.n454 VSS 0.02405f
C1578 VDD3_3.n455 VSS 0.02978f
C1579 VDD3_3.t6 VSS 1.62648f
C1580 VDD3_3.n456 VSS 0.03122f
C1581 VDD3_3.t4 VSS 0.06146f
C1582 VDD3_3.n457 VSS 0.05048f
C1583 VDD3_3.n458 VSS 0.02978f
C1584 VDD3_3.n459 VSS 0.06244f
C1585 VDD3_3.n460 VSS 0.06244f
C1586 VDD3_3.t9 VSS 0.06146f
C1587 VDD3_3.t8 VSS 1.00417f
C1588 VDD3_3.t137 VSS 0.07939f
C1589 VDD3_3.n461 VSS 0.03461f
C1590 VDD3_3.t138 VSS 0.07939f
C1591 VDD3_3.n462 VSS 0.02822f
C1592 VDD3_3.n463 VSS 0.02405f
C1593 VDD3_3.n464 VSS 0.02978f
C1594 VDD3_3.t13 VSS 0.06146f
C1595 VDD3_3.n465 VSS 0.03109f
C1596 VDD3_3.t11 VSS 0.06146f
C1597 VDD3_3.n466 VSS 0.05048f
C1598 VDD3_3.n467 VSS 0.02978f
C1599 VDD3_3.n468 VSS 0.06244f
C1600 VDD3_3.n469 VSS 0.06244f
C1601 VDD3_3.n470 VSS 0.17825f
C1602 VDD3_3.n471 VSS 0.34023f
C1603 VDD3_3.n472 VSS 0.11779f
C1604 VDD3_3.n473 VSS 0.02714f
C1605 VDD3_3.n474 VSS 0.11722f
C1606 VDD3_3.n475 VSS 0.12977f
C1607 VDD3_3.n476 VSS 0.1032f
C1608 VDD3_3.n477 VSS 0.06619f
C1609 VDD3_3.t95 VSS 0.06146f
C1610 VDD3_3.n478 VSS 0.08275f
C1611 VDD3_3.t97 VSS 0.06146f
C1612 VDD3_3.t99 VSS 0.06146f
C1613 VDD3_3.n479 VSS 0.06327f
C1614 VDD3_3.n480 VSS 0.09339f
C1615 VDD3_3.n481 VSS 0.22727f
C1616 VDD3_3.n482 VSS 0.22727f
C1617 VDD3_3.t88 VSS 0.06146f
C1618 VDD3_3.n483 VSS 0.10799f
C1619 VDD3_3.t90 VSS 3.51775f
C1620 VDD3_3.n484 VSS 0.10269f
C1621 VDD3_3.t87 VSS 0.04266f
C1622 VDD3_3.n485 VSS 0.03461f
C1623 VDD3_3.t134 VSS 0.07939f
C1624 VDD3_3.t135 VSS 0.07939f
C1625 VDD3_3.n486 VSS 0.02822f
C1626 VDD3_3.n487 VSS 0.02405f
C1627 VDD3_3.n488 VSS 0.05747f
C1628 VDD3_3.n489 VSS 0.06272f
C1629 VDD3_3.n490 VSS 0.22727f
C1630 VDD3_3.n491 VSS 0.25612f
C1631 VDD3_3.n492 VSS 0.10269f
C1632 VDD3_3.n493 VSS 0.10799f
C1633 VDD3_3.t92 VSS 0.06146f
C1634 VDD3_3.n494 VSS 0.23256f
C1635 VDD3_3.t94 VSS 0.04266f
C1636 VDD3_3.n495 VSS 0.03461f
C1637 VDD3_3.t146 VSS 0.07939f
C1638 VDD3_3.t147 VSS 0.07939f
C1639 VDD3_3.n496 VSS 0.02822f
C1640 VDD3_3.n497 VSS 0.02405f
C1641 VDD3_3.n498 VSS 0.22727f
C1642 VDD3_3.n499 VSS 0.22727f
C1643 VDD3_3.n500 VSS 0.07746f
C1644 VDD3_3.n501 VSS 0.07746f
C1645 VDD3_3.n502 VSS 0.27167f
C1646 VDD3_3.n503 VSS 0.06016f
C1647 VDD3_3.n504 VSS 0.07658f
C1648 VDD3_3.n505 VSS 0.08188f
C1649 VDD3_3.n506 VSS 0.09339f
C1650 VDD3_3.n507 VSS 0.27656f
C1651 VDD3_3.n508 VSS 0.14935f
C1652 VDD3_3.n509 VSS 0.37658f
C1653 VDD3_3.n510 VSS 0.366f
C1654 VDD3_3.n511 VSS 0.3194f
C1655 VDD3_3.n512 VSS 0.34023f
C1656 VDD3_3.n513 VSS 0.41746f
C1657 VDD3_3.n514 VSS 0.29832f
C1658 VDD3_3.n515 VSS 0.34064f
C1659 VDD3_3.t0 VSS 12.7865f
C1660 VDD3_3.n516 VSS 0.0267f
C1661 VDD3_3.t131 VSS 0.06218f
C1662 VDD3_3.t132 VSS 0.06218f
C1663 VDD3_3.n517 VSS 0.01214f
C1664 VDD3_3.n518 VSS 0.02427f
C1665 VDD3_3.n519 VSS 0.01214f
C1666 VDD3_3.n520 VSS 0.05029f
C1667 VDD3_3.n521 VSS 0.02822f
C1668 VDD3_3.t37 VSS 0.03105f
C1669 VDD3_3.n522 VSS 0.02544f
C1670 VDD3_3.n523 VSS 0.77393f
C1671 VDD3_3.n524 VSS 0.44013f
C1672 VDD3_3.n525 VSS 0.44013f
C1673 VDD3_3.n526 VSS 0.22715f
C1674 VDD3_3.n527 VSS 1.48079f
C1675 VDD3_3.n528 VSS 2.30665f
C1676 VDD3_3.n529 VSS 0.87896f
C1677 VDD3_3.n530 VSS 0.33577f
C1678 VDD3_3.n531 VSS 0.38856f
C1679 VDD3_3.n532 VSS 0.38856f
C1680 VDD3_3.n533 VSS 0.52302f
C1681 VDD3_3.n534 VSS 0.50836f
C1682 VDD3_3.n535 VSS 0.50836f
C1683 VDD3_3.n536 VSS 0.45331f
C1684 VDD3_3.n537 VSS 0.42355f
C1685 VDD3_3.n538 VSS 0.48497f
C1686 VDD3_3.n539 VSS 0.35933f
C1687 VDD3_3.n540 VSS 0.06674f
C1688 VDD3_3.n541 VSS 0.31235f
C1689 VDD3_3.n542 VSS 0.36366f
C1690 VDD3_3.n543 VSS 0.36366f
C1691 VDD3_3.n544 VSS 0.30502f
C1692 VDD3_3.n545 VSS 0.30764f
C1693 VDD3_3.n546 VSS 0.30764f
C1694 VDD3_3.n547 VSS 0.28664f
C1695 VDD3_3.n548 VSS 0.27526f
C1696 VDD3_3.n549 VSS 0.27526f
C1697 VDD3_3.n550 VSS 0.16104f
C1698 VDD3_3.n551 VSS 1.63218f
C1699 VDD3_3.n552 VSS 2.97319f
C1700 VDD3_3.n553 VSS 1.00405f
C1701 VDD3_3.n554 VSS 0.42037f
C1702 VDD3_3.n555 VSS 0.59515f
C1703 VDD3_3.n556 VSS 0.59515f
C1704 VDD3_3.n557 VSS 0.83368f
C1705 VDD3_3.n558 VSS 0.68758f
C1706 VDD3_3.n559 VSS 0.68758f
C1707 VDD3_3.n560 VSS 0.47892f
C1708 VDD3_3.t38 VSS 26.12988f
C1709 VDD3_3.n561 VSS 0.28605f
C1710 VDD3_3.n562 VSS 0.37553f
C1711 VDD3_3.n563 VSS 0.44411f
C1712 VDD3_3.n564 VSS 0.44415f
C1713 VDD3_3.n565 VSS 0.39516f
C1714 VDD3_3.n566 VSS 0.39516f
C1715 VDD3_3.n567 VSS 0.34965f
C1716 VDD3_3.n568 VSS 0.32208f
C1717 VDD3_3.n569 VSS 0.32208f
C1718 VDD3_3.n570 VSS 0.31421f
C1719 VDD3_3.n571 VSS 0.3269f
C1720 VDD3_3.n572 VSS 0.3269f
C1721 VDD3_3.n573 VSS 0.25791f
C1722 VDD3_3.n574 VSS 0.06636f
C1723 VDD3_3.n575 VSS 0.06636f
C1724 VDD3_3.n576 VSS 0.21475f
C1725 VDD3_3.n577 VSS 0.27873f
C1726 VDD3_3.n578 VSS 0.27873f
C1727 VDD3_3.n579 VSS 0.3566f
C1728 VDD3_3.n580 VSS 0.23887f
C1729 VDD3_3.n581 VSS 0.23887f
C1730 VDD3_3.n582 VSS 0.50273f
C1731 VDD3_3.n583 VSS 0.60791f
C1732 VDD3_3.n584 VSS 0.60791f
C1733 VDD3_3.n585 VSS 0.44884f
C1734 VDD3_3.n586 VSS 0.44686f
C1735 VDD3_3.n587 VSS 0.44686f
C1736 VDD3_3.n588 VSS 0.58226f
C1737 VDD3_3.n589 VSS 0.53118f
C1738 VDD3_3.n590 VSS 0.53118f
C1739 VDD3_3.n591 VSS 0.31618f
C1740 VDD3_3.n592 VSS 0.2067f
C1741 VDD3_3.n593 VSS 0.25357f
C1742 VDD3_3.n594 VSS 0.35602f
C1743 VDD3_3.n595 VSS 0.39516f
C1744 VDD3_3.n596 VSS 0.34965f
C1745 VDD3_3.n597 VSS 0.34965f
C1746 VDD3_3.n598 VSS 0.32208f
C1747 VDD3_3.n599 VSS 0.31421f
C1748 VDD3_3.n600 VSS 0.31421f
C1749 VDD3_3.n601 VSS 0.3269f
C1750 VDD3_3.n602 VSS 0.25791f
C1751 VDD3_3.n603 VSS 0.25791f
C1752 VDD3_3.n604 VSS 0.17445f
C1753 VDD3_3.n605 VSS 0.27526f
C1754 VDD3_3.n606 VSS 0.27526f
C1755 VDD3_3.n607 VSS 0.28664f
C1756 VDD3_3.n608 VSS 0.30764f
C1757 VDD3_3.n609 VSS 0.30764f
C1758 VDD3_3.n610 VSS 0.30502f
C1759 VDD3_3.n611 VSS 0.36366f
C1760 VDD3_3.n612 VSS 0.36366f
C1761 VDD3_3.n613 VSS 0.31256f
C1762 VDD3_3.n614 VSS 0.35933f
C1763 VDD3_3.n615 VSS 0.06674f
C1764 VDD3_3.t39 VSS 20.78844f
C1765 VDD3_3.n616 VSS 0.36383f
C1766 VDD3_3.n617 VSS 0.42355f
C1767 VDD3_3.n618 VSS 0.45331f
C1768 VDD3_3.n619 VSS 0.45331f
C1769 VDD3_3.n620 VSS 0.50836f
C1770 VDD3_3.n621 VSS 0.52302f
C1771 VDD3_3.n622 VSS 0.52302f
C1772 VDD3_3.n623 VSS 0.38856f
C1773 VDD3_3.n624 VSS 0.33577f
C1774 VDD3_3.n625 VSS 0.33577f
C1775 VDD3_3.n626 VSS 0.33279f
C1776 VDD3_3.n627 VSS 0.31494f
C1777 VDD3_3.n628 VSS 0.43f
C1778 VDD3_3.n629 VSS 0.43f
C1779 VDD3_3.n630 VSS 0.36751f
C1780 VDD3_3.n631 VSS 0.32733f
C1781 VDD3_3.n632 VSS 0.32733f
C1782 VDD3_3.n633 VSS 0.34581f
C1783 VDD3_3.n634 VSS 2.95013f
C1784 VDD3_3.n635 VSS 2.43679f
C1785 VDD3_3.n636 VSS 2.5315f
C1786 VDD3_3.n637 VSS 2.5315f
C1787 VDD3_3.n638 VSS 3.40153f
C1788 VDD3_3.n639 VSS 4.27977f
C1789 VDD3_3.n640 VSS 1.50461f
C1790 VDD3_3.t59 VSS 0.16945f
C1791 VDD3_3.t173 VSS 0.07939f
C1792 VDD3_3.n641 VSS 0.03461f
C1793 VDD3_3.t174 VSS 0.07939f
C1794 VDD3_3.n642 VSS 0.02822f
C1795 VDD3_3.t68 VSS 0.06671f
C1796 VDD3_3.n643 VSS 0.02978f
C1797 VDD3_3.t56 VSS 0.80219f
C1798 VDD3_3.t61 VSS 0.16945f
C1799 VDD3_3.n644 VSS 0.02978f
C1800 VDD3_3.n645 VSS 0.06244f
C1801 VDD3_3.n646 VSS 0.06244f
C1802 VDD3_3.n647 VSS 0.20902f
.ends
