* Extracted by KLayout with SG13CMOS5L LVS runset on : 26/09/2026 15:00

.SUBCKT ook_analog_system ACC_CAP Cap_M1 Cap_M11 Cap_M2 Cap_M21 VAPWR VGND VPWR
+ clk_fb clk_ref dac_out lnaf opm q0 q1 q2 q3 rst_ni rx_in tx_out vcl
+ vctrl_b_in vctrl_b_out vctrl_in vctrl_out vref0 vref1 vref2 vref3
X$613 VPWR \$2944 VGND \$2503 \$2622 \$3191 \$2769 sg13cmos5l_nand4_1
X$617 VPWR VGND \$2507 \$2504 \$2442 \$2503 \$2456 sg13cmos5l_or4_1
X$621 VGND \$3588 VPWR \$3465 \$2969 sg13cmos5l_xor2_1
X$622 VGND \$3552 VPWR \$3066 \$3368 sg13cmos5l_xor2_1
X$623 VGND \$1562 VPWR \$1543 \$504 sg13cmos5l_xor2_1
X$624 VGND \$1931 VPWR \$1930 \$1970 sg13cmos5l_xor2_1
X$625 VGND \$3752 VPWR \$4034 \$4035 sg13cmos5l_xor2_1
X$626 VGND \$1768 VPWR \$1772 \$1929 sg13cmos5l_xor2_1
X$627 VGND \$3562 VPWR \$3671 \$2619 sg13cmos5l_xor2_1
X$628 VGND \$3518 VPWR \$3100 \$2964 sg13cmos5l_xor2_1
X$629 VGND \$2850 VPWR \$2723 \$2621 sg13cmos5l_xor2_1
X$630 VGND \$3092 VPWR \$3091 \$3093 sg13cmos5l_xor2_1
X$631 VGND \$4016 VPWR \$3148 \$3909 sg13cmos5l_xor2_1
X$632 VGND \$3558 VPWR \$3237 \$2949 sg13cmos5l_xor2_1
X$633 VGND \$3774 VPWR \$3552 \$3551 sg13cmos5l_xor2_1
X$634 VGND \$2564 VPWR \$2568 \$2622 sg13cmos5l_xor2_1
X$635 VGND \$3550 VPWR \$3656 \$2429 sg13cmos5l_xor2_1
X$636 VGND \$3808 VPWR \$2949 \$3602 sg13cmos5l_xor2_1
X$637 VGND \$3574 VPWR \$3467 \$3043 sg13cmos5l_xor2_1
X$638 VGND \$2847 VPWR \$2710 \$3017 sg13cmos5l_xor2_1
X$639 VGND \$3274 VPWR \$2675 \$2964 sg13cmos5l_xor2_1
X$640 VGND \$2699 VPWR \$2547 \$2309 sg13cmos5l_xor2_1
X$641 VGND \$4035 VPWR \$2969 \$3923 sg13cmos5l_xor2_1
X$642 VGND \$2100 VPWR \$2170 \$1726 sg13cmos5l_xor2_1
X$710 VPWR VGND \$3934 \$2742 \$3764 sg13cmos5l_xnor2_1
X$711 VPWR VGND \$3556 \$3667 \$2949 sg13cmos5l_xnor2_1
X$712 VPWR VGND \$3914 \$2670 \$3912 sg13cmos5l_xnor2_1
X$713 VPWR VGND \$2543 \$2038 \$2470 sg13cmos5l_xnor2_1
X$714 VPWR VGND \$2216 \$2136 \$2221 sg13cmos5l_xnor2_1
X$715 VPWR VGND \$2319 \$2220 \$2221 sg13cmos5l_xnor2_1
X$716 VPWR VGND \$1821 \$1822 \$1857 sg13cmos5l_xnor2_1
X$717 VPWR VGND \$2547 \$683 \$2434 sg13cmos5l_xnor2_1
X$718 VPWR VGND \$2764 \$2671 \$2769 sg13cmos5l_xnor2_1
X$719 VPWR VGND \$2721 \$2564 \$2562 sg13cmos5l_xnor2_1
X$720 VPWR VGND \$3427 \$3170 \$2968 sg13cmos5l_xnor2_1
X$721 VPWR VGND \$3726 \$2619 \$3899 sg13cmos5l_xnor2_1
X$722 VPWR VGND \$504 \$995 \$916 sg13cmos5l_xnor2_1
X$723 VPWR VGND \$2841 \$2050 \$3066 sg13cmos5l_xnor2_1
X$724 VPWR VGND \$3932 \$3935 \$3929 sg13cmos5l_xnor2_1
X$725 VPWR VGND \$2723 \$2626 \$3148 sg13cmos5l_xnor2_1
X$726 VPWR VGND \$3394 \$3441 \$3191 sg13cmos5l_xnor2_1
X$727 VPWR VGND \$3617 \$3506 \$3255 sg13cmos5l_xnor2_1
X$728 VPWR VGND \$1485 \$1686 \$346 sg13cmos5l_xnor2_1
X$729 VPWR VGND \$3989 \$4030 \$4027 sg13cmos5l_xnor2_1
X$730 VPWR VGND \$2658 \$2816 \$2564 sg13cmos5l_xnor2_1
X$731 VPWR VGND \$3816 \$3860 \$3815 sg13cmos5l_xnor2_1
X$732 VPWR VGND \$1867 \$1872 \$1870 sg13cmos5l_xnor2_1
X$733 VPWR VGND \$1901 \$1934 \$259 sg13cmos5l_xnor2_1
X$734 VPWR VGND \$3846 \$3544 \$3636 sg13cmos5l_xnor2_1
X$735 VPWR VGND \$2710 \$2947 \$2944 sg13cmos5l_xnor2_1
X$736 VPWR VGND \$3152 \$2764 \$2826 sg13cmos5l_xnor2_1
X$737 VPWR VGND \$3283 \$3284 \$3093 sg13cmos5l_xnor2_1
X$738 VPWR VGND \$3656 \$2559 \$3601 sg13cmos5l_xnor2_1
X$739 VPWR VGND \$2427 \$2271 \$2213 sg13cmos5l_xnor2_1
X$740 VPWR VGND \$3067 \$2841 \$2707 sg13cmos5l_xnor2_1
X$741 VPWR VGND \$2457 \$683 \$2073 sg13cmos5l_xnor2_1
X$742 VPWR VGND \$3636 \$3470 \$2539 sg13cmos5l_xnor2_1
X$785 VPWR VGND \$1070 \$224 \$555 \$502 sg13cmos5l_or3_1
X$786 VPWR VGND \$3506 \$3148 \$2670 \$3467 sg13cmos5l_or3_1
X$804 VGND VPWR \$756 \$709 \$225 \$52 sg13cmos5l_nand3_1
X$805 VGND VPWR \$2634 \$2678 \$2675 \$2742 sg13cmos5l_nand3_1
X$806 VGND VPWR \$3228 \$3225 \$2477 \$3004 sg13cmos5l_nand3_1
X$807 VGND VPWR \$2961 \$2764 \$2820 \$2955 sg13cmos5l_nand3_1
X$808 VGND VPWR \$1800 \$860 \$1622 \$1738 sg13cmos5l_nand3_1
X$809 VGND VPWR \$2669 \$2529 \$2557 \$2670 sg13cmos5l_nand3_1
X$810 VPWR \$2239 VGND \$2504 \$2666 \$2742 \$2678 sg13cmos5l_nand4_1
X$811 VGND VPWR \$2896 \$2841 \$2592 \$2434 sg13cmos5l_nand3_1
X$812 VGND VPWR \$2247 \$2344 \$2350 \$2349 sg13cmos5l_nand3_1
X$813 VGND VPWR \$2904 \$1788 \$2557 \$2949 sg13cmos5l_nand3_1
X$814 VGND VPWR \$628 \$849 \$346 \$602 sg13cmos5l_nand3_1
X$815 VGND VPWR \$274 \$555 \$346 \$224 sg13cmos5l_nand3_1
X$816 VGND VPWR \$2724 \$2723 \$2662 \$2664 sg13cmos5l_nand3_1
X$817 VGND VPWR \$2565 \$2237 \$2092 \$2619 sg13cmos5l_nand3_1
X$818 VGND VPWR \$1432 \$1320 \$1204 \$1356 sg13cmos5l_nand3_1
X$819 VGND VPWR \$2654 \$2710 \$2709 \$2711 sg13cmos5l_nand3_1
X$820 VGND VPWR \$3441 \$2619 \$3237 \$2944 sg13cmos5l_nand3_1
X$824 VPWR VGND \$3426 \$3343 \$3431 \$3207 sg13cmos5l_a21o_1
X$825 VPWR VGND \$2715 \$2716 \$2613 \$2658 sg13cmos5l_a21o_1
X$826 VPWR VGND \$2707 \$2434 \$2038 \$1982 sg13cmos5l_a21o_1
X$827 VPWR VGND \$1958 \$1545 \$1558 \$125 sg13cmos5l_a21o_1
X$828 VPWR VGND \$3561 \$2227 \$3441 \$3309 sg13cmos5l_a21o_1
X$829 VPWR VGND \$1998 \$1915 \$860 \$1622 sg13cmos5l_a21o_1
X$830 VPWR VGND \$2230 \$2278 \$2049 \$1660 sg13cmos5l_a21o_1
X$831 VPWR VGND \$2350 \$2460 \$2459 \$2458 sg13cmos5l_a21o_1
X$832 VPWR VGND \$1997 \$1558 \$1809 \$2082 sg13cmos5l_a21o_1
X$833 VPWR VGND \$3929 \$4036 \$4035 \$4034 sg13cmos5l_a21o_1
X$834 VPWR VGND \$2020 \$2162 \$2093 \$2226 sg13cmos5l_a21o_1
X$835 VPWR VGND \$2709 \$2841 \$2434 \$2592 sg13cmos5l_a21o_1
X$836 VPWR VGND \$3309 \$2619 \$2944 \$3237 sg13cmos5l_a21o_1
X$837 VPWR VGND \$2820 \$2723 \$2664 \$2662 sg13cmos5l_a21o_1
X$838 VPWR VGND \$588 \$660 \$611 \$412 sg13cmos5l_a21o_1
X$839 VPWR VGND \$2217 \$2222 \$2093 \$2322 sg13cmos5l_a21o_1
X$840 VPWR VGND \$225 \$504 \$500 \$502 sg13cmos5l_a21o_1
X$841 VPWR VGND \$3689 \$3929 \$3764 \$2742 sg13cmos5l_a21o_1
X$855 VPWR VGND \$2179 \$1991 \$1959 \$2059 sg13cmos5l_nand3b_1
X$856 VPWR VGND \$1903 \$1622 \$2189 \$2062 sg13cmos5l_nand3b_1
X$857 VPWR VGND \$443 \$1070 \$555 \$849 sg13cmos5l_nand3b_1
X$873 VGND \$1652 \$1443 VPWR sg13cmos5l_buf_8
X$874 VGND \$1692 \$1650 VPWR sg13cmos5l_buf_8
X$875 VGND clk_ref \$578 VPWR sg13cmos5l_buf_8
X$876 VGND \$1209 \$1256 VPWR sg13cmos5l_buf_8
X$877 VGND \$1124 \$1694 VPWR sg13cmos5l_buf_8
X$878 VGND \$1164 \$1689 VPWR sg13cmos5l_buf_8
X$879 VGND \$578 \$3490 VPWR sg13cmos5l_buf_8
X$880 VGND \$578 \$2075 VPWR sg13cmos5l_buf_8
X$881 VGND \$1652 \$1883 VPWR sg13cmos5l_buf_8
X$882 VGND \$1305 \$1692 VPWR sg13cmos5l_buf_8
X$883 VGND \$1416 \$539 VPWR sg13cmos5l_buf_8
X$884 VGND \$1599 \$1124 VPWR sg13cmos5l_buf_8
X$885 VGND \$578 \$1967 VPWR sg13cmos5l_buf_8
X$886 VGND \$1704 \$1652 VPWR sg13cmos5l_buf_8
X$887 VGND \$1657 VPWR \$1545 \$995 sg13cmos5l_xor2_1
X$888 VGND \$578 \$76 VPWR sg13cmos5l_buf_8
X$889 VGND \$1164 \$674 VPWR sg13cmos5l_buf_8
X$890 VGND \$1124 \$526 VPWR sg13cmos5l_buf_8
X$891 VGND \$1303 \$1209 VPWR sg13cmos5l_buf_8
X$892 VGND \$1305 \$1211 VPWR sg13cmos5l_buf_8
X$893 VGND \$578 \$1566 VPWR sg13cmos5l_buf_8
X$894 VGND \$578 \$1174 VPWR sg13cmos5l_buf_8
X$895 VGND \$578 \$3523 VPWR sg13cmos5l_buf_8
X$896 VGND \$1211 \$1164 VPWR sg13cmos5l_buf_8
X$897 VGND \$1257 \$1599 VPWR sg13cmos5l_buf_8
X$898 VGND \$1257 \$1416 VPWR sg13cmos5l_buf_8
X$899 VGND \$1303 \$1704 VPWR sg13cmos5l_buf_8
X$900 VPWR VGND \$2969 \$2964 \$2732 \$2960 \$2861 sg13cmos5l_nor4_1
X$901 VPWR VGND \$916 \$602 \$995 \$1070 \$291 sg13cmos5l_nor4_1
X$902 VPWR VGND \$3066 \$2559 \$2949 \$2699 \$3671 sg13cmos5l_nor4_1
X$903 VPWR VGND \$2969 \$3043 \$2742 \$3467 \$2677 sg13cmos5l_nor4_1
X$904 VPWR VGND \$2507 \$2442 \$2503 \$2504 \$2227 sg13cmos5l_nor4_1
X$905 VPWR VGND \$718 \$1205 \$911 \$1045 \$1073 sg13cmos5l_nor4_1
X$906 VPWR VGND \$934 \$1454 \$1361 \$718 \$1320 sg13cmos5l_nor4_1
X$907 VPWR VGND \$1767 \$1926 \$1772 \$2092 \$2309 sg13cmos5l_nor4_1
X$908 VPWR VGND \$683 \$352 \$465 \$579 \$743 sg13cmos5l_nor4_1
X$909 VGND \$953 \$224 \$91 \$348 VPWR sg13cmos5l_mux2_1
X$910 VGND \$2684 \$2189 \$2240 \$2683 VPWR sg13cmos5l_mux2_1
X$911 VGND \$2837 \$2189 \$2423 \$2677 VPWR sg13cmos5l_mux2_1
X$912 VGND \$2696 \$1982 \$2543 \$2434 VPWR sg13cmos5l_mux2_1
X$913 VGND \$935 \$611 \$1227 \$660 VPWR sg13cmos5l_mux2_1
X$914 VGND \$2592 \$2309 \$2547 \$2543 VPWR sg13cmos5l_mux2_1
X$915 \$408 VGND VPWR \$412 \$97 \$949 \$194 sg13cmos5l_a22oi_1
X$916 \$3062 VGND VPWR \$2423 \$2978 \$2980 \$2239 sg13cmos5l_a22oi_1
X$917 \$850 VGND VPWR \$851 \$1070 \$1057 \$846 sg13cmos5l_a22oi_1
X$918 \$1933 VGND VPWR \$2002 \$2020 \$1974 \$1975 sg13cmos5l_a22oi_1
X$919 \$195 VGND VPWR \$846 \$995 \$660 \$611 sg13cmos5l_a22oi_1
X$920 \$773 VGND VPWR \$839 \$396 \$442 \$17 sg13cmos5l_a22oi_1
X$921 \$518 VGND VPWR \$660 \$611 \$965 \$849 sg13cmos5l_a22oi_1
X$922 \$2978 VGND VPWR \$3096 \$2539 \$2240 \$2923 sg13cmos5l_a22oi_1
X$923 \$583 VGND VPWR \$195 \$658 \$582 \$404 sg13cmos5l_a22oi_1
X$924 \$2582 VGND VPWR \$2684 \$2302 \$2644 \$2194 sg13cmos5l_a22oi_1
X$925 \$2210 VGND VPWR \$1997 \$2217 \$2305 \$2221 sg13cmos5l_a22oi_1
X$926 \$877 VGND VPWR \$412 \$879 \$949 \$948 sg13cmos5l_a22oi_1
X$927 \$496 VGND VPWR \$588 \$396 \$717 \$17 sg13cmos5l_a22oi_1
X$928 VPWR VGND \$718 \$561 \$787 \$858 sg13cmos5l_or3_1
X$929 \$516 VGND VPWR \$291 \$16 \$556 \$175 sg13cmos5l_a22oi_1
X$1082 \$2858 \$3747 \$3622 VPWR VGND sg13cmos5l_or2_1
X$1083 \$2082 \$2458 \$2573 VPWR VGND sg13cmos5l_or2_1
X$1084 \$3004 \$3072 \$2050 VPWR VGND sg13cmos5l_or2_1
X$1085 \$2434 \$2477 \$1982 VPWR VGND sg13cmos5l_or2_1
X$1086 \$916 \$1227 \$995 VPWR VGND sg13cmos5l_or2_1
X$1087 \$934 \$1205 \$1298 VPWR VGND sg13cmos5l_or2_1
X$1088 \$2308 \$2306 \$2131 VPWR VGND sg13cmos5l_or2_1
X$1089 \$17 \$399 \$588 VPWR VGND sg13cmos5l_or2_1
X$1090 \$2002 \$3581 \$3646 VPWR VGND sg13cmos5l_or2_1
X$1091 \$1010 \$792 \$851 VPWR VGND sg13cmos5l_or2_1
X$1092 \$259 \$2032 \$443 VPWR VGND sg13cmos5l_or2_1
X$1093 \$352 \$573 \$465 VPWR VGND sg13cmos5l_or2_1
X$1094 VGND VPWR \$3968 \$3727 \$4103 sg13cmos5l_nor2b_1
X$1095 VGND VPWR \$3973 \$4013 \$3913 sg13cmos5l_nor2b_1
X$1096 VGND VPWR \$2808 \$2712 \$2654 sg13cmos5l_nor2b_1
X$1097 VGND VPWR \$3156 \$2960 \$2961 sg13cmos5l_nor2b_1
X$1098 VGND VPWR \$3433 \$3667 \$3961 sg13cmos5l_nor2b_1
X$1099 VGND VPWR \$1057 \$849 \$916 sg13cmos5l_nor2b_1
X$1100 VGND VPWR \$4030 \$3986 \$3984 sg13cmos5l_nor2b_1
X$1101 VGND VPWR \$3100 \$2503 \$3237 sg13cmos5l_nor2b_1
X$1102 VGND VPWR \$301 \$555 \$849 sg13cmos5l_nor2b_1
X$1103 VGND VPWR \$2170 \$2049 \$1872 sg13cmos5l_nor2b_1
X$1104 VGND VPWR \$3305 \$3237 \$3228 sg13cmos5l_nor2b_1
X$1105 VGND VPWR \$1529 \$1454 \$746 sg13cmos5l_nor2b_1
X$1171 VGND \$608 VPWR \$480 \$573 \$579 \$52 \$463 sg13cmos5l_a221oi_1
X$1172 VGND \$2850 VPWR \$2953 \$2082 \$2912 \$2613 \$2855 sg13cmos5l_a221oi_1
X$1173 VGND \$3152 VPWR \$3270 \$2916 \$2912 \$2613 \$3156 sg13cmos5l_a221oi_1
X$1174 VGND \$3562 VPWR \$3491 \$2224 \$2325 \$2930 \$3561 sg13cmos5l_a221oi_1
X$1175 VGND \$2847 VPWR \$2938 \$2930 \$2912 \$2613 \$2808 sg13cmos5l_a221oi_1
X$1176 VGND \$2696 VPWR \$2994 \$2930 \$2912 \$2592 \$2613 sg13cmos5l_a221oi_1
X$1177 VGND \$3067 VPWR \$3296 \$2930 \$2912 \$2613 \$2937 sg13cmos5l_a221oi_1
X$1178 VGND \$1107 VPWR \$1622 \$904 \$125 \$1432 \$978 sg13cmos5l_a221oi_1
X$1179 VGND \$2224 VPWR \$2222 \$2319 \$2325 \$2117 \$2227 sg13cmos5l_a221oi_1
X$1180 VGND \$283 VPWR \$270 \$170 \$228 \$16 \$48 sg13cmos5l_a221oi_1
X$1181 VGND \$3588 VPWR \$3646 \$2224 \$2460 \$2916 \$3463 sg13cmos5l_a221oi_1
X$1182 VGND \$3551 VPWR \$3554 \$3552 \$3367 \$3602 \$2949 sg13cmos5l_a221oi_1
X$1183 VGND \$949 VPWR \$1419 \$1650 \$1645 \$1256 \$1057 sg13cmos5l_a221oi_1
X$1184 VGND \$3624 VPWR \$3622 \$2224 \$2460 \$2916 \$3507 sg13cmos5l_a221oi_1
X$1185 VGND \$413 VPWR \$733 \$1419 \$346 \$877 \$1175 sg13cmos5l_a221oi_1
X$1186 VGND \$2087 VPWR \$2162 \$2224 \$2325 \$2082 \$2227 sg13cmos5l_a221oi_1
X$1187 VGND \$1057 VPWR \$1175 \$1127 \$602 \$441 \$301 sg13cmos5l_a221oi_1
X$1188 VGND \$3274 VPWR \$3272 \$2916 \$2912 \$2860 \$3090 sg13cmos5l_a221oi_1
X$1189 VGND \$3283 VPWR \$3278 \$2916 \$2912 \$2860 \$3092 sg13cmos5l_a221oi_1
X$1190 VGND \$2240 VPWR \$2093 \$2239 \$2114 \$1998 \$1800 sg13cmos5l_a221oi_1
X$1191 VPWR VGND \$995 \$916 \$846 sg13cmos5l_nand2b_1
X$1192 VPWR VGND \$2306 \$2321 \$2271 sg13cmos5l_nand2b_1
X$1193 VPWR VGND \$3671 \$2619 \$3506 sg13cmos5l_nand2b_1
X$1194 VPWR VGND \$1105 \$1077 \$1045 sg13cmos5l_nand2b_1
X$1195 VPWR VGND \$650 \$25 \$608 sg13cmos5l_nand2b_1
X$1196 VPWR VGND \$51 \$1707 \$1660 sg13cmos5l_nand2b_1
X$1197 VPWR VGND \$2270 \$2220 \$2087 sg13cmos5l_nand2b_1
X$1198 VPWR VGND \$555 \$849 \$965 sg13cmos5l_nand2b_1
X$1199 VPWR VGND \$52 \$195 \$322 sg13cmos5l_nand2b_1
X$1200 VPWR VGND \$3042 \$3091 \$3090 sg13cmos5l_nand2b_1
X$1201 VPWR VGND \$3465 \$2969 \$3587 sg13cmos5l_nand2b_1
X$1202 VPWR VGND \$1914 \$1738 \$1915 sg13cmos5l_nand2b_1
X$1203 VPWR VGND \$1934 \$1545 \$2085 sg13cmos5l_nand2_1
X$1204 VPWR VGND \$1900 \$1926 \$1767 sg13cmos5l_nand2_1
X$1205 VPWR VGND \$2402 \$2059 \$1660 sg13cmos5l_nand2_1
X$1206 VPWR VGND \$2626 \$1880 \$2557 sg13cmos5l_nand2_1
X$1207 VPWR VGND \$3284 \$2964 \$2675 sg13cmos5l_nand2_1
X$1208 VPWR VGND \$2630 \$2453 \$2573 sg13cmos5l_nand2_1
X$1209 VPWR VGND \$2573 \$2679 \$2677 sg13cmos5l_nand2_1
X$1210 VPWR VGND \$2671 \$2529 \$2557 sg13cmos5l_nand2_1
X$1211 VPWR VGND \$2086 \$1057 \$1543 sg13cmos5l_nand2_1
X$1212 VPWR VGND \$2568 \$2237 \$2092 sg13cmos5l_nand2_1
X$1213 VPWR VGND \$2335 \$2280 \$1660 sg13cmos5l_nand2_1
X$1214 VPWR VGND \$2071 \$1772 \$2002 sg13cmos5l_nand2_1
X$1215 VPWR VGND \$1745 \$1886 \$1660 sg13cmos5l_nand2_1
X$1216 VPWR VGND \$3096 \$2678 \$2675 sg13cmos5l_nand2_1
X$1217 VPWR VGND \$839 \$709 \$913 sg13cmos5l_nand2_1
X$1218 VPWR VGND \$1939 \$1872 \$1660 sg13cmos5l_nand2_1
X$1219 VPWR VGND \$2061 \$1959 \$1660 sg13cmos5l_nand2_1
X$1220 VPWR VGND \$2644 \$2194 \$2837 sg13cmos5l_nand2_1
X$1221 VPWR VGND \$2913 \$2239 \$2240 sg13cmos5l_nand2_1
X$1222 VPWR VGND \$2226 \$2087 \$2613 sg13cmos5l_nand2_1
X$1223 VPWR VGND \$3820 \$3148 \$2858 sg13cmos5l_nand2_1
X$1224 VPWR VGND \$2912 \$2460 \$2913 sg13cmos5l_nand2_1
X$1225 VPWR VGND \$3548 \$2239 \$3470 sg13cmos5l_nand2_1
X$1226 VPWR VGND \$2947 \$1788 \$2557 sg13cmos5l_nand2_1
X$1227 VPWR VGND \$303 \$347 \$301 sg13cmos5l_nand2_1
X$1229 VPWR VGND \$335 \$175 \$518 sg13cmos5l_nand2_1
X$1230 VPWR VGND \$3319 \$2619 \$2858 sg13cmos5l_nand2_1
X$1231 VPWR VGND \$2322 \$2613 \$2319 sg13cmos5l_nand2_1
X$1232 VPWR VGND \$718 \$792 \$746 sg13cmos5l_nand2_1
X$1233 VPWR VGND \$2955 \$3148 \$2626 sg13cmos5l_nand2_1
X$1234 VPWR VGND \$3746 \$2969 \$2002 sg13cmos5l_nand2_1
X$1235 VPWR VGND \$331 \$404 \$225 sg13cmos5l_nand2_1
X$1236 VPWR VGND \$500 \$602 \$346 sg13cmos5l_nand2_1
X$1237 VPWR VGND \$2117 \$1622 \$1662 sg13cmos5l_nand2_1
X$1238 VPWR VGND \$2344 \$2457 \$2093 sg13cmos5l_nand2_1
X$1239 VPWR VGND \$3864 \$3909 \$3148 sg13cmos5l_nand2_1
X$1240 VPWR VGND \$1141 \$611 \$301 sg13cmos5l_nand2_1
X$1241 VPWR VGND \$1809 \$860 \$1622 sg13cmos5l_nand2_1
X$1242 VPWR VGND \$1970 \$1929 \$1772 sg13cmos5l_nand2_1
X$1243 VPWR VGND \$3624 \$3467 \$3505 sg13cmos5l_nand2_1
X$1244 VPWR VGND \$2214 \$1857 \$1822 sg13cmos5l_nand2_1
X$1245 VPWR VGND \$275 \$93 \$274 sg13cmos5l_nand2_1
X$1246 VPWR VGND \$3679 \$2670 \$2858 sg13cmos5l_nand2_1
X$1247 VPWR VGND \$3966 \$3601 \$2559 sg13cmos5l_nand2_1
X$1248 VPWR VGND \$556 \$851 \$965 sg13cmos5l_nand2_1
X$1249 VPWR VGND \$2911 \$2747 \$2858 sg13cmos5l_nand2_1
X$1250 VPWR VGND \$3432 \$2944 \$2858 sg13cmos5l_nand2_1
X$1251 VPWR VGND \$3359 \$2985 \$2858 sg13cmos5l_nand2_1
X$1252 VPWR VGND \$2116 \$2069 \$1660 sg13cmos5l_nand2_1
X$1253 VPWR VGND \$3984 \$3987 \$3043 sg13cmos5l_nand2_1
X$1254 VPWR VGND \$2664 \$2622 \$2568 sg13cmos5l_nand2_1
X$1255 VPWR VGND \$3413 \$2964 \$2858 sg13cmos5l_nand2_1
X$1256 VPWR VGND \$1874 \$1726 \$1660 sg13cmos5l_nand2_1
X$1257 VPWR VGND \$442 \$502 \$443 sg13cmos5l_nand2_1
X$1258 VPWR VGND \$851 \$500 \$502 sg13cmos5l_nand2_1
X$1259 VPWR VGND \$2711 \$3066 \$2050 sg13cmos5l_nand2_1
X$1260 VPWR VGND \$3225 \$2559 \$2557 sg13cmos5l_nand2_1
X$1261 VPWR VGND \$413 \$539 \$412 sg13cmos5l_nand2_1
X$1262 VPWR VGND \$3207 \$2460 \$3062 sg13cmos5l_nand2_1
X$1266 VPWR VGND \$2678 \$2964 \$2969 sg13cmos5l_and2_1
X$1267 VPWR VGND \$330 \$399 \$292 sg13cmos5l_and2_1
X$1268 VPWR VGND \$989 \$611 \$504 sg13cmos5l_and2_1
X$1269 VPWR VGND \$2224 \$2453 \$2573 sg13cmos5l_and2_1
X$1270 VPWR VGND \$3119 \$3004 \$2050 sg13cmos5l_and2_1
X$1271 VPWR VGND \$1557 \$1537 \$1176 sg13cmos5l_and2_1
X$1272 VPWR VGND \$3170 \$2678 \$3100 sg13cmos5l_and2_1
X$1273 VPWR VGND \$641 \$329 \$290 sg13cmos5l_and2_1
X$1274 VPWR VGND \$4036 \$3925 \$2969 sg13cmos5l_and2_1
X$1275 VPWR VGND \$2937 \$2709 \$2896 sg13cmos5l_and2_1
X$1276 VPWR VGND \$2453 \$1622 \$1662 sg13cmos5l_and2_1
X$1277 VPWR VGND \$3367 \$3368 \$3066 sg13cmos5l_and2_1
X$1278 VPWR VGND \$2855 \$2820 \$2724 sg13cmos5l_and2_1
X$1279 VPWR VGND \$412 \$555 \$849 sg13cmos5l_and2_1
X$1280 VPWR VGND \$973 \$1529 \$1530 sg13cmos5l_and2_1
X$1281 VPWR VGND \$343 \$602 \$346 sg13cmos5l_and2_1
X$1282 VPWR VGND \$579 \$25 \$628 sg13cmos5l_and2_1
X$1283 VPWR VGND \$2817 \$2949 \$2947 sg13cmos5l_and2_1
X$1284 VPWR VGND \$3686 \$2239 \$2677 sg13cmos5l_and2_1
X$1285 VPWR VGND \$290 \$397 \$82 sg13cmos5l_and2_1
X$1286 VPWR VGND \$2732 \$2670 \$2671 sg13cmos5l_and2_1
X$1287 VPWR VGND \$1662 \$788 \$973 sg13cmos5l_and2_1
X$1288 VPWR VGND \$1543 \$1432 \$978 sg13cmos5l_and2_1
X$1289 VPWR VGND \$4012 \$3899 \$2619 sg13cmos5l_and2_1
X$1290 VPWR VGND \$1325 \$591 \$1141 sg13cmos5l_and2_1
X$1291 VPWR VGND \$82 \$59 \$30 sg13cmos5l_and2_1
X$1292 VPWR VGND \$30 \$175 \$150 sg13cmos5l_and2_1
X$1293 VPWR VGND \$2321 \$2308 \$2131 sg13cmos5l_and2_1
X$1294 VGND \$2662 VPWR \$2564 \$2712 \$2817 sg13cmos5l_o21ai_1
X$1295 VGND \$2249 VPWR \$2071 \$2247 \$2351 sg13cmos5l_o21ai_1
X$1296 VGND \$3446 VPWR \$3315 \$3617 \$2630 sg13cmos5l_o21ai_1
X$1297 VGND \$2459 VPWR \$2457 \$2456 \$2453 sg13cmos5l_o21ai_1
X$1298 VGND \$3456 VPWR \$2349 \$3579 \$2460 sg13cmos5l_o21ai_1
X$1299 VGND \$3364 VPWR \$3484 \$3433 \$2630 sg13cmos5l_o21ai_1
X$1300 VGND \$512 VPWR \$331 \$556 \$16 sg13cmos5l_o21ai_1
X$1301 VGND \$2621 VPWR \$2565 \$2564 \$2562 sg13cmos5l_o21ai_1
X$1302 VGND \$1913 VPWR \$1874 \$1955 \$1903 sg13cmos5l_o21ai_1
X$1303 VGND \$855 VPWR \$175 \$683 \$989 sg13cmos5l_o21ai_1
X$1304 VGND \$20 VPWR \$125 \$150 \$175 sg13cmos5l_o21ai_1
X$1305 VGND \$3546 VPWR \$3548 \$3544 \$3547 sg13cmos5l_o21ai_1
X$1306 VGND \$1990 VPWR \$2061 \$2053 \$1903 sg13cmos5l_o21ai_1
X$1307 VGND \$3442 VPWR \$3319 \$3244 \$3491 sg13cmos5l_o21ai_1
X$1308 VGND \$417 VPWR \$516 \$512 \$480 sg13cmos5l_o21ai_1
X$1309 VGND \$3017 VPWR \$3072 \$3119 \$2707 sg13cmos5l_o21ai_1
X$1310 VGND \$2051 VPWR \$2335 \$2394 \$1903 sg13cmos5l_o21ai_1
X$1311 VGND \$2675 VPWR \$2669 \$2821 \$2826 sg13cmos5l_o21ai_1
X$1312 VGND \$3297 VPWR \$2349 \$3364 \$2325 sg13cmos5l_o21ai_1
X$1313 VGND \$3544 VPWR \$3689 \$2742 \$3764 sg13cmos5l_o21ai_1
X$1314 VGND \$659 VPWR \$16 \$660 \$715 sg13cmos5l_o21ai_1
X$1315 VGND VPWR \$585 \$709 \$659 \$335 sg13cmos5l_nand3_1
X$1316 VGND \$3579 VPWR \$3630 \$3574 \$2630 sg13cmos5l_o21ai_1
X$1317 VGND \$2053 VPWR \$2179 \$1991 \$1959 sg13cmos5l_o21ai_1
X$1318 VGND \$1633 VPWR \$1531 \$1557 \$1534 sg13cmos5l_o21ai_1
X$1319 VGND \$3630 VPWR \$2916 \$3518 \$2227 sg13cmos5l_o21ai_1
X$1320 VGND \$3913 VPWR \$4016 \$3727 \$4012 sg13cmos5l_o21ai_1
X$1321 VGND \$3042 VPWR \$3043 \$2960 \$2732 sg13cmos5l_o21ai_1
X$1322 VGND \$3484 VPWR \$2930 \$3305 \$2227 sg13cmos5l_o21ai_1
X$1323 VGND \$2038 VPWR \$2041 \$443 \$259 sg13cmos5l_o21ai_1
X$1324 VGND \$3557 VPWR \$2930 \$3558 \$2227 sg13cmos5l_o21ai_1
X$1325 VGND \$2797 VPWR \$2911 \$2994 \$3113 sg13cmos5l_o21ai_1
X$1326 VGND \$1686 VPWR \$1545 \$1550 \$1773 sg13cmos5l_o21ai_1
X$1327 VGND \$3315 VPWR \$2930 \$3394 \$2227 sg13cmos5l_o21ai_1
X$1328 VGND \$2085 VPWR \$2086 \$1543 \$846 sg13cmos5l_o21ai_1
X$1329 VGND \$4103 VPWR \$3726 \$3554 \$3725 sg13cmos5l_o21ai_1
X$1330 VGND \$3507 VPWR \$2456 \$3320 \$3100 sg13cmos5l_o21ai_1
X$1331 VGND \$3463 VPWR \$2456 \$3333 \$3170 sg13cmos5l_o21ai_1
X$1332 VGND \$1645 VPWR \$602 \$846 \$1410 sg13cmos5l_o21ai_1
X$1333 VGND \$933 VPWR \$591 \$846 \$500 sg13cmos5l_o21ai_1
X$1334 VGND \$1530 VPWR \$792 \$1361 \$1325 sg13cmos5l_o21ai_1
X$1335 VGND \$2115 VPWR \$2116 \$2117 \$1707 sg13cmos5l_o21ai_1
X$1336 VGND \$2997 VPWR \$2930 \$2801 \$2227 sg13cmos5l_o21ai_1
X$1337 VGND \$2980 VPWR \$2453 \$2861 \$2923 sg13cmos5l_o21ai_1
X$1338 VGND \$3480 VPWR \$2349 \$3606 \$2325 sg13cmos5l_o21ai_1
X$1339 VGND \$3551 VPWR \$3966 \$3656 \$2429 sg13cmos5l_o21ai_1
X$1340 VGND \$3113 VPWR \$2349 \$2928 \$2325 sg13cmos5l_o21ai_1
X$1341 VGND \$3836 VPWR \$3679 \$3747 \$3270 sg13cmos5l_o21ai_1
X$1342 VGND \$2050 VPWR \$1905 \$443 \$259 sg13cmos5l_o21ai_1
X$1343 VGND \$788 VPWR \$831 \$490 \$663 sg13cmos5l_o21ai_1
X$1344 VGND \$787 VPWR \$861 \$935 \$83 sg13cmos5l_o21ai_1
X$1345 VGND \$3477 VPWR \$3432 \$2938 \$3480 sg13cmos5l_o21ai_1
X$1346 VGND \$2270 VPWR \$1767 \$2092 \$1772 sg13cmos5l_o21ai_1
X$1347 VGND \$4034 VPWR \$3984 \$3986 \$4107 sg13cmos5l_o21ai_1
X$1348 VGND \$283 VPWR \$164 \$282 \$249 sg13cmos5l_o21ai_1
X$1349 VGND \$884 VPWR \$735 \$953 \$443 sg13cmos5l_o21ai_1
X$1350 VGND \$3213 VPWR \$3359 \$3296 \$3297 sg13cmos5l_o21ai_1
X$1351 VGND \$1780 VPWR \$1939 \$1907 \$1903 sg13cmos5l_o21ai_1
X$1352 VGND \$1629 VPWR \$1745 \$1809 \$1707 sg13cmos5l_o21ai_1
X$1353 VGND \$782 VPWR \$756 \$850 \$658 sg13cmos5l_o21ai_1
X$1354 VGND \$3505 VPWR \$2670 \$3506 \$3148 sg13cmos5l_o21ai_1
X$1355 VGND \$3628 VPWR \$3413 \$3456 \$3272 sg13cmos5l_o21ai_1
X$1356 VGND \$3244 VPWR \$2349 \$2715 \$2912 sg13cmos5l_o21ai_1
X$1357 VGND \$285 VPWR \$322 \$282 \$249 sg13cmos5l_o21ai_1
X$1358 VGND \$3620 VPWR \$2349 \$3446 \$2325 sg13cmos5l_o21ai_1
X$1359 VGND \$2213 VPWR \$2214 \$1821 \$1970 sg13cmos5l_o21ai_1
X$1360 VGND \$1105 VPWR \$83 \$935 \$683 sg13cmos5l_o21ai_1
X$1361 VPWR VGND \$1009 \$1141 \$591 sg13cmos5l_xnor2_1
X$1362 VGND \$1204 VPWR \$1073 \$775 \$1050 sg13cmos5l_o21ai_1
X$1363 VGND \$853 VPWR \$783 \$782 \$828 sg13cmos5l_o21ai_1
X$1364 VGND \$863 VPWR \$793 \$641 \$668 sg13cmos5l_o21ai_1
X$1365 VGND \$1356 VPWR \$933 \$787 \$774 sg13cmos5l_o21ai_1
X$1366 VGND \$860 VPWR \$973 \$858 \$554 sg13cmos5l_o21ai_1
X$1367 VGND \$2928 VPWR \$2997 \$2630 \$2699 sg13cmos5l_o21ai_1
X$1368 VGND \$3821 VPWR \$3820 \$3620 \$2953 sg13cmos5l_o21ai_1
X$1369 VGND \$3606 VPWR \$3557 \$3556 \$2630 sg13cmos5l_o21ai_1
X$1370 VGND \$3681 VPWR \$3746 \$3278 \$3581 sg13cmos5l_o21ai_1
X$1371 VGND \$3961 VPWR \$3066 \$2699 \$2559 sg13cmos5l_o21ai_1
X$1812 VPWR VGND \$2960 \$3091 \$2732 \$2964 sg13cmos5l_nor3_1
X$1813 VPWR VGND \$1557 \$1556 \$1546 \$51 sg13cmos5l_nor3_1
X$1814 VPWR VGND \$2092 \$2220 \$1772 \$1767 sg13cmos5l_nor3_1
X$1815 VPWR VGND \$3554 \$3727 \$3726 \$3725 sg13cmos5l_nor3_1
X$1816 VPWR VGND \$1176 \$1080 \$1081 \$51 sg13cmos5l_nor3_1
X$1817 VPWR VGND \$683 \$927 \$989 \$175 sg13cmos5l_nor3_1
X$1818 VPWR VGND \$2699 \$3667 \$3066 \$2559 sg13cmos5l_nor3_1
X$1819 VPWR VGND \$641 \$394 \$546 \$12 sg13cmos5l_nor3_1
X$1820 VPWR VGND \$1543 \$1773 \$846 \$259 sg13cmos5l_nor3_1
X$1821 VPWR VGND \$1298 \$1361 \$934 \$1105 sg13cmos5l_nor3_1
X$1822 VPWR VGND \$290 \$108 \$262 \$12 sg13cmos5l_nor3_1
X$1823 VPWR VGND \$1950 \$2278 \$1903 \$2049 sg13cmos5l_nor3_1
X$1824 VPWR VGND \$625 \$828 \$707 \$743 sg13cmos5l_nor3_1
X$1825 VPWR VGND \$3338 \$3591 \$3592 \$2460 sg13cmos5l_nor3_1
X$1826 VPWR VGND \$27 \$207 \$93 \$12 sg13cmos5l_nor3_1
X$1827 VGND \$275 VPWR \$282 \$318 \$352 \$14 \$223 sg13cmos5l_a221oi_1
X$1828 VPWR VGND \$58 \$171 \$156 \$12 sg13cmos5l_nor3_1
X$1829 VPWR VGND \$150 \$152 \$107 \$12 sg13cmos5l_nor3_1
X$1830 VPWR VGND \$935 \$1077 \$1075 \$83 sg13cmos5l_nor3_1
X$1831 VPWR VGND \$2092 \$2136 \$1691 \$1975 sg13cmos5l_nor3_1
X$1832 VPWR VGND \$346 \$660 \$555 \$224 sg13cmos5l_nor3_1
X$1833 VPWR VGND \$291 \$401 \$343 \$175 sg13cmos5l_nor3_1
X$1834 VPWR VGND \$4016 \$4013 \$3727 \$4012 sg13cmos5l_nor3_1
X$1835 VPWR VGND \$2539 \$2423 \$2460 \$2351 sg13cmos5l_and3_1
X$1836 VPWR VGND \$2280 \$2170 \$1788 \$1991 sg13cmos5l_and3_1
X$1837 VPWR VGND \$602 \$346 \$849 \$650 sg13cmos5l_and3_1
X$1838 VPWR VGND \$602 \$1543 \$1057 \$1550 sg13cmos5l_and3_1
X$1839 VPWR VGND \$966 \$641 \$591 \$1176 sg13cmos5l_and3_1
X$1840 VPWR VGND \$2923 \$2861 \$2453 \$2423 sg13cmos5l_and3_1
X$1841 VPWR VGND \$3864 \$3914 \$3913 \$3979 sg13cmos5l_and3_1
X$1842 VPWR VGND \$1959 \$1991 \$2059 \$1950 sg13cmos5l_and3_1
X$1843 VPWR VGND \$2904 \$2901 sg13cmos5l_inv_1
X$1844 VPWR VGND \$1772 \$1691 sg13cmos5l_inv_1
X$1845 VPWR VGND \$441 \$440 sg13cmos5l_inv_1
X$1846 VPWR VGND \$2742 \$2923 sg13cmos5l_inv_1
X$1847 VPWR VGND \$773 \$775 sg13cmos5l_inv_1
X$1848 VPWR VGND \$1371 \$1410 sg13cmos5l_inv_1
X$1849 VPWR VGND \$2764 \$2821 sg13cmos5l_inv_1
X$1850 VPWR VGND \$446 \$348 sg13cmos5l_inv_1
X$1851 VPWR VGND \$64 \$121 sg13cmos5l_inv_1
X$1852 VPWR VGND \$16 \$658 sg13cmos5l_inv_1
X$1853 VPWR VGND \$194 \$437 sg13cmos5l_inv_1
X$1854 VPWR VGND \$1713 \$1811 sg13cmos5l_inv_1
X$1855 VPWR VGND \$948 \$1666 sg13cmos5l_inv_1
X$1856 VPWR VGND \$879 \$1474 sg13cmos5l_inv_1
X$1857 VPWR VGND \$52 \$404 sg13cmos5l_inv_1
X$1858 VPWR VGND \$1694 \$1604 sg13cmos5l_inv_1
X$1859 VPWR VGND \$1870 \$2041 sg13cmos5l_inv_1
X$1860 VPWR VGND \$1689 \$1602 sg13cmos5l_inv_1
X$1861 VPWR VGND \$863 \$887 sg13cmos5l_inv_1
X$1862 VPWR VGND \$347 \$445 sg13cmos5l_inv_1
X$1863 VPWR VGND \$97 \$380 sg13cmos5l_inv_1
X$1864 VPWR VGND \$1822 \$1975 sg13cmos5l_inv_1
X$1865 VPWR VGND \$496 \$497 sg13cmos5l_inv_1
X$1866 VPWR VGND \$3066 \$3004 sg13cmos5l_inv_1
X$1867 VPWR VGND \$1914 \$2113 sg13cmos5l_inv_1
X$1868 VPWR VGND \$2539 \$2302 sg13cmos5l_inv_1
X$1869 VPWR VGND \$1127 \$1672 sg13cmos5l_inv_1
X$1870 VPWR VGND \$168 \$166 sg13cmos5l_inv_1
X$1871 VPWR VGND \$2131 \$2221 sg13cmos5l_inv_1
X$1872 VPWR VGND \$2559 \$2434 sg13cmos5l_inv_1
X$1873 VPWR VGND \$1883 \$1701 sg13cmos5l_inv_1
X$1874 VPWR VGND \$50 \$140 sg13cmos5l_inv_1
X$1875 VPWR VGND \$3148 \$3255 sg13cmos5l_inv_1
X$1876 VPWR VGND \$225 \$463 sg13cmos5l_inv_1
X$1877 \$2826 VGND \$2723 VPWR \$2621 \$3086 sg13cmos5l_a21oi_1
X$1878 \$793 VGND \$641 VPWR \$668 \$51 sg13cmos5l_a21oi_1
X$1879 \$3237 VGND \$2477 VPWR \$3225 \$3004 sg13cmos5l_a21oi_1
X$1880 \$783 VGND \$850 VPWR \$658 \$927 sg13cmos5l_a21oi_1
X$1881 \$746 VGND \$851 VPWR \$1010 \$1178 sg13cmos5l_a21oi_1
X$1882 \$970 VGND \$641 VPWR \$591 \$966 sg13cmos5l_a21oi_1
X$1883 \$2189 VGND \$1800 VPWR \$1998 \$2114 sg13cmos5l_a21oi_1
X$1884 \$2114 VGND \$1662 VPWR \$1622 \$2113 sg13cmos5l_a21oi_1
X$1885 \$2429 VGND \$2306 VPWR \$2213 \$2321 sg13cmos5l_a21oi_1
X$1886 \$533 VGND \$408 VPWR \$303 \$500 sg13cmos5l_a21oi_1
X$1887 \$774 VGND \$691 VPWR \$633 \$663 sg13cmos5l_a21oi_1
X$1888 \$2960 VGND \$2820 VPWR \$2955 \$2764 sg13cmos5l_a21oi_1
X$1889 \$2153 VGND \$2092 VPWR \$1691 \$1900 sg13cmos5l_a21oi_1
X$1890 \$2801 VGND \$2547 VPWR \$1982 \$2750 sg13cmos5l_a21oi_1
X$1891 \$71 VGND \$27 VPWR \$25 \$52 sg13cmos5l_a21oi_1
X$1892 \$1298 VGND \$709 VPWR \$1141 \$591 sg13cmos5l_a21oi_1
X$1893 \$2921 VGND \$3170 VPWR \$2968 \$2302 sg13cmos5l_a21oi_1
X$1894 \$4107 VGND \$2670 VPWR \$3912 \$4017 sg13cmos5l_a21oi_1
X$1895 \$1531 VGND \$1557 VPWR \$1534 \$51 sg13cmos5l_a21oi_1
X$1896 \$2442 VGND \$2557 VPWR \$2559 \$2153 sg13cmos5l_a21oi_1
X$1897 \$2284 VGND \$1991 VPWR \$1880 \$2059 sg13cmos5l_a21oi_1
X$1898 \$2194 VGND \$2082 VPWR \$1809 \$1558 sg13cmos5l_a21oi_1
X$1899 \$2031 VGND \$683 VPWR \$1772 \$1822 sg13cmos5l_a21oi_1
X$1900 \$2449 VGND \$2170 VPWR \$1788 \$2280 sg13cmos5l_a21oi_1
X$1901 \$2712 VGND \$2709 VPWR \$2711 \$2710 sg13cmos5l_a21oi_1
X$1902 \$2305 VGND \$2216 VPWR \$2117 \$2002 sg13cmos5l_a21oi_1
X$1903 \$352 VGND \$274 VPWR \$140 \$121 sg13cmos5l_a21oi_1
X$1904 \$2240 VGND \$1662 VPWR \$1622 \$2634 sg13cmos5l_a21oi_1
X$1905 \$4017 VGND \$3913 VPWR \$3864 \$3914 sg13cmos5l_a21oi_1
X$1906 \$3415 VGND \$3587 VPWR \$2742 \$3686 sg13cmos5l_a21oi_1
X$1907 \$1050 VGND \$853 VPWR \$855 \$840 sg13cmos5l_a21oi_1
X$1908 \$2860 VGND \$2861 VPWR \$2866 \$2916 sg13cmos5l_a21oi_1
X$1909 \$1573 VGND \$904 VPWR \$1107 \$1543 sg13cmos5l_a21oi_1
X$1910 \$1610 VGND \$1562 VPWR \$1545 \$1613 sg13cmos5l_a21oi_1
X$1911 \$554 VGND \$330 VPWR \$417 \$497 sg13cmos5l_a21oi_1
X$1912 \$861 VGND \$935 VPWR \$83 \$1009 sg13cmos5l_a21oi_1
X$1913 \$3592 VGND \$3427 VPWR \$2456 \$2453 sg13cmos5l_a21oi_1
X$1914 \$3333 VGND \$3100 VPWR \$2964 \$3461 sg13cmos5l_a21oi_1
X$1915 \$707 VGND \$225 VPWR \$709 \$52 sg13cmos5l_a21oi_1
X$1916 \$3815 VGND \$3552 VPWR \$3551 \$3367 sg13cmos5l_a21oi_1
X$1917 \$2104 VGND \$2402 VPWR \$1903 \$2338 sg13cmos5l_a21oi_1
X$1918 \$913 VGND \$949 VPWR \$611 \$660 sg13cmos5l_a21oi_1
X$1919 \$2562 VGND \$2710 VPWR \$3017 \$2901 sg13cmos5l_a21oi_1
X$1920 \$1974 VGND \$2084 VPWR \$2082 \$2002 sg13cmos5l_a21oi_1
X$1921 \$717 VGND \$502 VPWR \$500 \$650 sg13cmos5l_a21oi_1
X$1922 VPWR VGND \$718 \$787 \$831 sg13cmos5l_nor2_1
X$1923 VPWR VGND \$2031 \$2136 \$2084 sg13cmos5l_nor2_1
X$1924 VPWR VGND \$2626 \$3255 \$3086 sg13cmos5l_nor2_1
X$1925 VPWR VGND \$2100 \$1950 \$1955 sg13cmos5l_nor2_1
X$1926 VPWR VGND \$1982 \$2434 \$2750 sg13cmos5l_nor2_1
X$1927 VPWR VGND \$683 \$933 \$934 sg13cmos5l_nor2_1
X$1928 VPWR VGND \$2949 \$3602 \$3725 sg13cmos5l_nor2_1
X$1929 VPWR VGND \$20 \$30 \$18 sg13cmos5l_nor2_1
X$1930 VPWR VGND \$3591 \$2002 \$3431 sg13cmos5l_nor2_1
X$1931 VPWR VGND \$2721 \$2453 \$2716 sg13cmos5l_nor2_1
X$1932 VPWR VGND \$2712 \$2817 \$2816 sg13cmos5l_nor2_1
X$1933 VPWR VGND \$500 \$555 \$223 sg13cmos5l_nor2_1
X$1934 VPWR VGND \$291 \$343 \$48 sg13cmos5l_nor2_1
X$1935 VPWR VGND \$48 \$335 \$228 sg13cmos5l_nor2_1
X$1936 VPWR VGND \$443 \$259 \$1075 sg13cmos5l_nor2_1
X$1937 VPWR VGND \$4017 \$3979 \$3981 sg13cmos5l_nor2_1
X$1938 VPWR VGND \$995 \$916 \$949 sg13cmos5l_nor2_1
X$1939 VPWR VGND \$2557 \$2470 \$2507 sg13cmos5l_nor2_1
X$1940 VPWR VGND \$290 \$329 \$546 sg13cmos5l_nor2_1
X$1941 VPWR VGND \$1573 \$1558 \$1545 sg13cmos5l_nor2_1
X$1942 VPWR VGND \$518 \$175 \$519 sg13cmos5l_nor2_1
X$1943 VPWR VGND \$2349 \$2923 \$3343 sg13cmos5l_nor2_1
X$1944 VPWR VGND \$291 \$125 \$978 sg13cmos5l_nor2_1
X$1945 VPWR VGND \$860 \$788 \$904 sg13cmos5l_nor2_1
X$1946 VPWR VGND \$846 \$500 \$715 sg13cmos5l_nor2_1
X$1947 VPWR VGND \$1075 \$125 \$1107 sg13cmos5l_nor2_1
X$1948 VPWR VGND \$2968 \$2239 \$2866 sg13cmos5l_nor2_1
X$1949 VPWR VGND \$195 \$15 \$218 sg13cmos5l_nor2_1
X$1950 VPWR VGND \$3415 \$2916 \$3338 sg13cmos5l_nor2_1
X$1951 VPWR VGND \$1176 \$1537 \$1456 sg13cmos5l_nor2_1
X$1952 VPWR VGND \$1867 \$1950 \$1907 sg13cmos5l_nor2_1
X$1953 VPWR VGND \$3447 \$2670 \$3320 sg13cmos5l_nor2_1
X$1954 VPWR VGND \$3043 \$3987 \$3986 sg13cmos5l_nor2_1
X$1955 VPWR VGND \$2449 \$1991 \$2447 sg13cmos5l_nor2_1
X$1956 VPWR VGND \$533 \$733 \$735 sg13cmos5l_nor2_1
X$1957 VPWR VGND \$30 \$59 \$65 sg13cmos5l_nor2_1
X$1958 VPWR VGND \$660 \$715 \$582 sg13cmos5l_nor2_1
X$1959 VPWR VGND \$3470 \$2239 \$3547 sg13cmos5l_nor2_1
X$1960 VPWR VGND \$82 \$397 \$262 sg13cmos5l_nor2_1
X$1961 VPWR VGND \$58 \$67 \$60 sg13cmos5l_nor2_1
X$1962 VPWR VGND \$628 \$25 \$625 sg13cmos5l_nor2_1
X$1963 VPWR VGND \$50 \$64 \$93 sg13cmos5l_nor2_1
X$1964 VPWR VGND \$3467 \$3043 \$3465 sg13cmos5l_nor2_1
X$1965 VPWR VGND \$2921 \$2453 \$2683 sg13cmos5l_nor2_1
X$1966 VPWR VGND \$218 \$49 \$170 sg13cmos5l_nor2_1
X$1967 VPWR VGND \$2447 \$1950 \$2394 sg13cmos5l_nor2_1
X$1968 VPWR VGND \$48 \$16 \$49 sg13cmos5l_nor2_1
X$1969 VPWR VGND \$140 \$121 \$27 sg13cmos5l_nor2_1
X$1970 VPWR VGND \$1545 \$916 \$1613 sg13cmos5l_nor2_1
X$1971 VPWR VGND \$223 \$25 \$249 sg13cmos5l_nor2_1
X$1972 VPWR VGND \$839 \$17 \$840 sg13cmos5l_nor2_1
X$1973 VPWR VGND \$442 \$396 \$911 sg13cmos5l_nor2_1
X$1974 VPWR VGND \$520 \$519 \$633 sg13cmos5l_nor2_1
X$1975 VPWR VGND \$3441 \$3255 \$3447 sg13cmos5l_nor2_1
X$1976 VPWR VGND \$717 \$396 \$561 sg13cmos5l_nor2_1
X$1977 VPWR VGND \$561 \$496 \$663 sg13cmos5l_nor2_1
X$1978 VPWR VGND sg13cmos5l_decap_8
X$1979 VPWR VGND sg13cmos5l_decap_8
X$1980 VPWR VGND sg13cmos5l_decap_8
X$1981 VPWR VGND sg13cmos5l_decap_8
X$1982 VPWR VGND sg13cmos5l_decap_8
X$1983 VPWR VGND sg13cmos5l_decap_8
X$1984 VPWR VGND sg13cmos5l_decap_8
X$1985 VPWR VGND sg13cmos5l_decap_8
X$1986 VPWR VGND sg13cmos5l_decap_8
X$1987 VPWR VGND sg13cmos5l_decap_8
X$1988 VPWR VGND sg13cmos5l_decap_8
X$1989 VPWR VGND sg13cmos5l_decap_8
X$1990 VPWR VGND sg13cmos5l_decap_8
X$1991 VPWR VGND sg13cmos5l_decap_8
X$1992 VPWR VGND sg13cmos5l_decap_8
X$1993 VPWR VGND sg13cmos5l_decap_8
X$1994 VPWR VGND sg13cmos5l_decap_8
X$1995 VPWR VGND sg13cmos5l_decap_8
X$1996 VPWR VGND sg13cmos5l_decap_8
X$1997 VPWR VGND sg13cmos5l_decap_8
X$1998 VPWR VGND sg13cmos5l_decap_8
X$1999 VPWR VGND sg13cmos5l_decap_8
X$2000 VPWR VGND sg13cmos5l_decap_8
X$2001 VPWR VGND sg13cmos5l_decap_8
X$2002 VPWR VGND sg13cmos5l_decap_8
X$2003 VPWR VGND sg13cmos5l_decap_8
X$2004 VPWR VGND sg13cmos5l_decap_8
X$2005 VPWR VGND sg13cmos5l_decap_8
X$2006 VPWR VGND sg13cmos5l_decap_8
X$2007 VPWR VGND sg13cmos5l_decap_8
X$2008 VPWR VGND sg13cmos5l_decap_8
X$2009 VPWR VGND sg13cmos5l_decap_8
X$2010 VPWR VGND sg13cmos5l_decap_8
X$2011 VPWR VGND sg13cmos5l_decap_8
X$2012 VPWR VGND sg13cmos5l_decap_8
X$2013 VPWR VGND sg13cmos5l_decap_8
X$2014 VPWR VGND sg13cmos5l_decap_8
X$2015 VPWR VGND sg13cmos5l_decap_8
X$2016 VPWR VGND sg13cmos5l_decap_8
X$2017 VPWR VGND sg13cmos5l_decap_8
X$2018 VPWR VGND sg13cmos5l_decap_8
X$2019 VPWR VGND sg13cmos5l_decap_8
X$2020 VPWR VGND sg13cmos5l_decap_8
X$2021 VPWR VGND sg13cmos5l_decap_8
X$2022 VPWR VGND sg13cmos5l_decap_8
X$2023 VPWR VGND \$520 \$519 \$270 \$401 \$490 sg13cmos5l_nor4_1
X$2024 VPWR VGND \$520 \$399 \$496 \$561 sg13cmos5l_nand3b_1
X$2025 VPWR VGND sg13cmos5l_decap_8
X$2026 VPWR VGND sg13cmos5l_decap_8
X$2027 VPWR VGND sg13cmos5l_decap_8
X$2028 VPWR VGND sg13cmos5l_decap_8
X$2029 VPWR VGND sg13cmos5l_decap_8
X$2030 VPWR VGND sg13cmos5l_decap_8
X$2031 VPWR VGND sg13cmos5l_decap_8
X$2032 VPWR VGND sg13cmos5l_decap_8
X$2033 VPWR VGND sg13cmos5l_decap_8
X$2034 VPWR VGND sg13cmos5l_decap_8
X$2035 VPWR VGND sg13cmos5l_decap_8
X$2036 VPWR VGND sg13cmos5l_decap_8
X$2037 VPWR VGND sg13cmos5l_decap_8
X$2038 VPWR VGND sg13cmos5l_decap_8
X$2039 VGND \$578 \$81 VPWR sg13cmos5l_buf_8
X$2040 VPWR VGND sg13cmos5l_decap_8
X$2041 VPWR VGND sg13cmos5l_decap_8
X$2042 VPWR VGND sg13cmos5l_decap_8
X$2043 VPWR VGND sg13cmos5l_decap_8
X$2044 VPWR VGND sg13cmos5l_decap_8
X$2045 VPWR VGND sg13cmos5l_decap_8
X$6975 \$72 \$292 \$291 VPWR VGND sg13cmos5l_or2_1
X$7113 VGND \$1654 \$1315 \$1610 \$1566 VPWR sg13cmos5l_dfrbpq_1
X$7114 VGND \$1654 \$1450 \$1657 \$1174 VPWR sg13cmos5l_dfrbpq_1
X$7115 VGND \$116 \$100 \$242 \$76 VPWR sg13cmos5l_dfrbpq_1
X$7116 VGND \$1444 \$1127 \$1672 \$1371 VPWR sg13cmos5l_dfrbpq_1
X$7117 VGND \$116 \$14 \$166 \$76 VPWR sg13cmos5l_dfrbpq_1
X$7119 VPWR VGND \$52 \$27 \$25 \$58 sg13cmos5l_and3_1
X$7120 VGND \$168 VPWR \$44 \$27 \$25 sg13cmos5l_o21ai_1
X$7121 VGND \$3788 \$3409 \$3628 \$1967 VPWR sg13cmos5l_dfrbpq_1
X$7122 VGND \$3699 \$3819 \$3968 \$3490 VPWR sg13cmos5l_dfrbpq_1
X$7123 VGND \$3788 \$2769 \$3836 \$3523 VPWR sg13cmos5l_dfrbpq_1
X$7124 VGND \$3788 \$3461 \$3681 \$3523 VPWR sg13cmos5l_dfrbpq_1
X$7125 VGND \$46 \$17 \$109 \$81 VPWR sg13cmos5l_dfrbpq_1
X$7126 VPWR VGND \$82 \$109 \$110 \$12 sg13cmos5l_nor3_1
X$7127 VGND \$1444 \$1257 \$1604 \$1443 VPWR sg13cmos5l_dfrbpq_1
X$7128 VGND \$1702 \$1454 \$1811 \$1174 VPWR sg13cmos5l_dfrbpq_1
X$7129 VGND \$1702 \$1707 \$1958 \$1174 VPWR sg13cmos5l_dfrbpq_1
X$7130 VGND \$3699 \$3783 \$3973 \$3490 VPWR sg13cmos5l_dfrbpq_1
X$7131 VGND \$1444 \$1371 \$1410 \$674 VPWR sg13cmos5l_dfrbpq_1
X$7132 VGND \$43 \$347 \$445 \$97 VPWR sg13cmos5l_dfrbpq_1
X$7133 VGND \$3293 \$3065 \$3477 \$2075 VPWR sg13cmos5l_dfrbpq_1
X$7134 VGND \$43 \$575 \$884 \$76 VPWR sg13cmos5l_dfrbpq_1
X$7135 VGND \$1479 \$1767 \$1825 \$1566 VPWR sg13cmos5l_dfrbpq_1
X$7136 VGND \$1479 \$1905 \$1781 \$1566 VPWR sg13cmos5l_dfrbpq_1
X$7137 VGND \$3788 \$3987 \$3837 \$3523 VPWR sg13cmos5l_dfrbpq_1
X$7138 VGND \$1702 \$1914 \$1882 \$1967 VPWR sg13cmos5l_dfrbpq_1
X$7139 VGND \$46 \$72 \$18 \$81 VPWR sg13cmos5l_dfrbpq_1
X$7140 VGND \$2234 \$2679 \$2421 \$1967 VPWR sg13cmos5l_dfrbpq_1
X$7141 VGND \$3699 \$3959 \$3771 \$3490 VPWR sg13cmos5l_dfrbpq_1
X$7142 VGND \$2408 \$2529 \$2286 \$1967 VPWR sg13cmos5l_dfrbpq_1
X$7143 VGND \$1702 \$1788 \$1728 \$1566 VPWR sg13cmos5l_dfrbpq_1
X$7144 VGND \$1702 \$1880 \$1793 \$1174 VPWR sg13cmos5l_dfrbpq_1
X$7145 VGND \$1702 \$2237 \$1909 \$1967 VPWR sg13cmos5l_dfrbpq_1
X$7146 VGND \$1479 \$1892 \$1760 \$1566 VPWR sg13cmos5l_dfrbpq_1
X$7147 VGND \$3788 \$3925 \$3841 \$3523 VPWR sg13cmos5l_dfrbpq_1
X$7148 VGND \$116 \$384 \$449 \$76 VPWR sg13cmos5l_dfrbpq_1
X$7149 \$465 VGND VPWR \$274 \$343 \$504 \$93 sg13cmos5l_a22oi_1
X$7150 VGND \$3788 \$3593 \$3846 \$3523 VPWR sg13cmos5l_dfrbpq_1
X$7151 VGND \$237 \$1010 \$1326 \$1174 VPWR sg13cmos5l_dfrbpq_1
X$7152 VGND \$237 \$591 \$887 \$81 VPWR sg13cmos5l_dfrbpq_1
X$7153 VGND \$3699 \$2622 \$3442 \$3490 VPWR sg13cmos5l_dfrbpq_1
X$7154 VGND \$43 \$446 \$348 \$347 VPWR sg13cmos5l_dfrbpq_1
X$7155 VGND \$1479 \$1290 \$1901 \$1566 VPWR sg13cmos5l_dfrbpq_1
X$7156 VGND \$1479 \$1305 \$1602 \$526 VPWR sg13cmos5l_dfrbpq_1
X$7157 VGND \$1479 \$948 \$1666 \$1127 VPWR sg13cmos5l_dfrbpq_1
X$7158 VGND \$43 \$92 \$91 \$441 VPWR sg13cmos5l_dfrbpq_1
X$7159 VGND \$3699 \$3292 \$3653 \$2075 VPWR sg13cmos5l_dfrbpq_1
X$7160 VGND \$1654 \$1178 \$1581 \$1174 VPWR sg13cmos5l_dfrbpq_1
X$7161 VGND \$2234 \$2470 \$2797 \$2075 VPWR sg13cmos5l_dfrbpq_1
X$7162 VGND \$2234 \$1926 \$2210 \$2075 VPWR sg13cmos5l_dfrbpq_1
X$7163 VGND \$2234 \$1870 \$2230 \$2075 VPWR sg13cmos5l_dfrbpq_1
X$7164 VGND \$2234 \$1920 \$2249 \$1967 VPWR sg13cmos5l_dfrbpq_1
X$7165 VGND \$116 \$97 \$380 \$194 VPWR sg13cmos5l_dfrbpq_1
X$7166 VGND \$3699 \$3191 \$3821 \$3490 VPWR sg13cmos5l_dfrbpq_1
X$7167 VGND \$3788 \$3829 \$3981 \$3523 VPWR sg13cmos5l_dfrbpq_1
X$7168 VGND \$1479 \$879 \$1474 \$948 VPWR sg13cmos5l_dfrbpq_1
X$7169 VGND \$46 \$16 \$152 \$81 VPWR sg13cmos5l_dfrbpq_1
X$7170 VGND \$46 \$15 \$171 \$81 VPWR sg13cmos5l_dfrbpq_1
X$7171 VPWR VGND \$150 \$67 \$58 sg13cmos5l_and2_1
X$7172 VGND \$3788 \$3796 \$3950 \$3523 VPWR sg13cmos5l_dfrbpq_1
X$7173 VGND \$46 \$83 \$394 \$81 VPWR sg13cmos5l_dfrbpq_1
X$7174 VGND \$43 \$10 \$207 \$76 VPWR sg13cmos5l_dfrbpq_1
X$7175 VGND \$1444 \$704 \$1485 \$76 VPWR sg13cmos5l_dfrbpq_1
X$7176 VGND \$2234 \$2666 \$3213 \$2075 VPWR sg13cmos5l_dfrbpq_1
X$7177 VGND \$3293 \$2968 \$3426 \$1967 VPWR sg13cmos5l_dfrbpq_1
X$7178 VGND \$1702 \$1303 \$1701 clk_fb VPWR sg13cmos5l_dfrbpq_1
X$7179 VGND \$3699 \$3857 \$3774 \$3490 VPWR sg13cmos5l_dfrbpq_1
X$7180 VGND \$2234 \$2474 \$2427 \$2075 VPWR sg13cmos5l_dfrbpq_1
X$7181 VGND \$1702 \$1738 \$1712 \$1174 VPWR sg13cmos5l_dfrbpq_1
X$7182 VGND \$43 \$194 \$437 \$92 VPWR sg13cmos5l_dfrbpq_1
X$7183 VGND \$43 \$441 \$440 \$879 VPWR sg13cmos5l_dfrbpq_1
X$7184 VGND \$46 \$396 \$108 \$81 VPWR sg13cmos5l_dfrbpq_1
X$7185 VGND \$1479 \$1858 \$1763 \$1566 VPWR sg13cmos5l_dfrbpq_1
X$7186 VGND \$3699 \$3885 \$3779 \$3490 VPWR sg13cmos5l_dfrbpq_1
X$7187 VPWR VGND \$979 \$1450 sg13cmos5l_dlygate4sd3_1
X$7188 VPWR VGND \$915 \$1315 sg13cmos5l_dlygate4sd3_1
X$7189 VPWR VGND \$1872 \$1905 sg13cmos5l_dlygate4sd3_1
X$7190 VPWR VGND \$2059 \$2529 sg13cmos5l_dlygate4sd3_1
X$7191 VPWR VGND \$1793 \$1990 sg13cmos5l_dlygate4sd3_1
X$7192 VPWR VGND \$3837 \$3989 sg13cmos5l_dlygate4sd3_1
X$7193 VPWR VGND \$449 \$575 sg13cmos5l_dlygate4sd3_1
X$7194 VPWR VGND \$4027 \$4107 sg13cmos5l_dlygate4sd3_1
X$7195 VPWR VGND \$2421 \$2582 sg13cmos5l_dlygate4sd3_1
X$7196 VPWR VGND \$1760 \$1931 sg13cmos5l_dlygate4sd3_1
X$7197 VPWR VGND \$1882 \$2115 sg13cmos5l_dlygate4sd3_1
X$7198 VPWR VGND \$50 \$77 sg13cmos5l_dlygate4sd3_1
X$7199 VPWR VGND \$1781 \$1780 sg13cmos5l_dlygate4sd3_1
X$7200 VPWR VGND \$1909 \$2051 sg13cmos5l_dlygate4sd3_1
X$7201 VPWR VGND \$1728 \$1913 sg13cmos5l_dlygate4sd3_1
X$7202 VPWR VGND \$1081 \$970 sg13cmos5l_dlygate4sd3_1
X$7203 VPWR VGND \$3736 \$2769 sg13cmos5l_dlygate4sd3_1
X$7204 VPWR VGND \$3841 \$3752 sg13cmos5l_dlygate4sd3_1
X$7205 VPWR VGND \$1822 \$1767 sg13cmos5l_dlygate4sd3_1
X$7206 VPWR VGND \$2286 \$2104 sg13cmos5l_dlygate4sd3_1
X$7207 VPWR VGND \$329 \$83 sg13cmos5l_dlygate4sd3_1
X$7208 VPWR VGND \$1959 \$1880 sg13cmos5l_dlygate4sd3_1
X$7209 VPWR VGND \$1763 \$1768 sg13cmos5l_dlygate4sd3_1
X$7210 VPWR VGND \$3935 \$3934 sg13cmos5l_dlygate4sd3_1
X$7211 VPWR VGND \$1886 \$1738 sg13cmos5l_dlygate4sd3_1
X$7212 VPWR VGND \$2280 \$2237 sg13cmos5l_dlygate4sd3_1
X$7213 VPWR VGND \$3909 \$3783 sg13cmos5l_dlygate4sd3_1
X$7214 VPWR VGND \$1581 \$1556 sg13cmos5l_dlygate4sd3_1
X$7215 VPWR VGND \$1326 \$1080 sg13cmos5l_dlygate4sd3_1
X$7216 VPWR VGND \$1558 \$1707 sg13cmos5l_dlygate4sd3_1
X$7217 VPWR VGND \$3178 \$3065 sg13cmos5l_dlygate4sd3_1
X$7218 VPWR VGND \$3899 \$3819 sg13cmos5l_dlygate4sd3_1
X$7219 VPWR VGND \$1712 \$1629 sg13cmos5l_dlygate4sd3_1
X$7220 VPWR VGND \$59 \$17 sg13cmos5l_dlygate4sd3_1
X$7221 VPWR VGND \$2747 \$2470 sg13cmos5l_dlygate4sd3_1
X$7222 VPWR VGND \$2062 \$1707 sg13cmos5l_dlygate4sd3_1
X$7223 VPWR VGND \$2131 \$1926 sg13cmos5l_dlygate4sd3_1
X$7224 VPWR VGND \$2073 \$1920 sg13cmos5l_dlygate4sd3_1
X$7225 VPWR VGND \$3860 \$3808 sg13cmos5l_dlygate4sd3_1
X$7226 VPWR VGND \$1929 \$1858 sg13cmos5l_dlygate4sd3_1
X$7227 VPWR VGND \$3724 \$2622 sg13cmos5l_dlygate4sd3_1
X$7228 VPWR VGND \$3368 \$3857 sg13cmos5l_dlygate4sd3_1
X$7229 VPWR VGND \$3470 \$3593 sg13cmos5l_dlygate4sd3_1
X$7230 VPWR VGND \$302 \$704 sg13cmos5l_dlygate4sd3_1
X$7231 VPWR VGND \$1930 \$1821 sg13cmos5l_dlygate4sd3_1
X$7232 VPWR VGND \$28 \$14 sg13cmos5l_dlygate4sd3_1
X$7233 VPWR VGND \$3779 \$3816 sg13cmos5l_dlygate4sd3_1
X$7234 VPWR VGND \$2308 \$2474 sg13cmos5l_dlygate4sd3_1
X$7235 VPWR VGND \$242 \$384 sg13cmos5l_dlygate4sd3_1
X$7236 VGND VPWR \$53 \$205 \$242 sg13cmos5l_nor2b_1
X$7237 VPWR VGND \$3093 \$3461 sg13cmos5l_dlygate4sd3_1
X$7238 VPWR VGND \$1230 \$1290 sg13cmos5l_dlygate4sd3_1
X$7239 VPWR VGND \$1825 \$1933 sg13cmos5l_dlygate4sd3_1
X$7240 VPWR VGND \$1691 \$1900 \$259 \$443 \$1982 sg13cmos5l_or4_1
X$7241 VPWR VGND \$3602 \$3885 sg13cmos5l_dlygate4sd3_1
X$7242 VPWR VGND \$110 \$65 sg13cmos5l_dlygate4sd3_1
X$7243 VPWR VGND \$1713 \$1633 sg13cmos5l_dlygate4sd3_1
X$7244 VPWR VGND \$205 \$100 sg13cmos5l_dlygate4sd3_1
X$7245 VPWR VGND \$3653 \$3550 sg13cmos5l_dlygate4sd3_1
X$7246 VPWR VGND \$1546 \$1456 sg13cmos5l_dlygate4sd3_1
X$7247 VPWR VGND \$2049 \$1870 sg13cmos5l_dlygate4sd3_1
X$7248 VPWR VGND \$3912 \$3829 sg13cmos5l_dlygate4sd3_1
X$7249 VPWR VGND \$107 \$60 sg13cmos5l_dlygate4sd3_1
X$7250 VPWR VGND \$668 \$591 sg13cmos5l_dlygate4sd3_1
X$7251 VPWR VGND \$1537 \$1178 sg13cmos5l_dlygate4sd3_1
X$7252 VPWR VGND \$1726 \$1788 sg13cmos5l_dlygate4sd3_1
X$7253 VPWR VGND \$67 \$16 sg13cmos5l_dlygate4sd3_1
X$7254 VPWR VGND \$149 \$72 sg13cmos5l_dlygate4sd3_1
X$7255 VPWR VGND \$966 \$1010 sg13cmos5l_dlygate4sd3_1
X$7256 VPWR VGND \$156 \$71 sg13cmos5l_dlygate4sd3_1
X$7257 VPWR VGND \$3950 \$3932 sg13cmos5l_dlygate4sd3_1
X$7258 VPWR VGND \$397 \$396 sg13cmos5l_dlygate4sd3_1
X$7259 VPWR VGND \$1857 \$1892 sg13cmos5l_dlygate4sd3_1
X$7260 VPWR VGND \$3923 \$3925 sg13cmos5l_dlygate4sd3_1
X$7261 VPWR VGND \$3771 \$3546 sg13cmos5l_dlygate4sd3_1
X$7262 VPWR VGND \$2539 \$2679 sg13cmos5l_dlygate4sd3_1
X$7263 VPWR VGND \$2985 \$2666 sg13cmos5l_dlygate4sd3_1
X$7264 VPWR VGND \$1534 \$1454 sg13cmos5l_dlygate4sd3_1
X$7265 VPWR VGND \$3601 \$3292 sg13cmos5l_dlygate4sd3_1
X$7266 VPWR VGND \$3734 \$3191 sg13cmos5l_dlygate4sd3_1
X$7267 VPWR VGND \$54 \$15 sg13cmos5l_dlygate4sd3_1
X$7268 VPWR VGND \$2338 \$2284 sg13cmos5l_dlygate4sd3_1
X$7269 VPWR VGND \$3764 \$3796 sg13cmos5l_dlygate4sd3_1
X$7270 VPWR VGND \$2069 \$1914 sg13cmos5l_dlygate4sd3_1
X$7300 VPWR VGND \$691 \$585 \$285 \$583 sg13cmos5l_a21o_1
X$7440 VGND vctrl_out VPWR \$36 sg13cmos5l_buf_1
X$7441 VPWR VGND sg13cmos5l_decap_4
X$7443 VPWR VGND \$64 \$10 sg13cmos5l_dlygate4sd3_1
X$7444 VGND \$43 \$77 \$13 \$76 VPWR sg13cmos5l_dfrbpq_1
X$7448 VPWR VGND sg13cmos5l_decap_8
X$7449 VPWR VGND \$12 \$50 \$13 sg13cmos5l_nor2_1
X$7450 \$44 VGND \$27 VPWR \$25 \$12 sg13cmos5l_a21oi_1
X$7451 VPWR VGND \$92 \$91 sg13cmos5l_inv_1
X$7453 VPWR VGND \$242 \$205 \$125 sg13cmos5l_nand2b_1
X$7454 VPWR VGND sg13cmos5l_decap_4
X$7455 VPWR VGND sg13cmos5l_decap_4
X$7456 VPWR VGND sg13cmos5l_decap_4
X$7457 VGND \$318 \$611 \$504 \$502 VPWR sg13cmos5l_mux2_1
X$7458 VPWR VGND sg13cmos5l_decap_4
X$7459 VPWR VGND sg13cmos5l_decap_4
X$7460 VPWR VGND sg13cmos5l_decap_4
X$7461 VPWR VGND sg13cmos5l_decap_4
X$7462 VPWR VGND sg13cmos5l_decap_4
X$7463 VPWR VGND sg13cmos5l_decap_4
X$7464 VPWR VGND sg13cmos5l_decap_4
X$7465 VPWR VGND sg13cmos5l_decap_4
X$7466 VPWR VGND sg13cmos5l_decap_4
X$7467 VPWR VGND sg13cmos5l_decap_4
X$7468 VPWR VGND sg13cmos5l_decap_4
X$7469 VPWR VGND sg13cmos5l_decap_4
X$7470 VPWR VGND sg13cmos5l_decap_4
X$7471 VPWR VGND sg13cmos5l_decap_4
X$7472 VPWR VGND sg13cmos5l_decap_4
X$7473 VPWR VGND sg13cmos5l_decap_4
X$7474 VPWR VGND sg13cmos5l_decap_4
X$7475 VPWR VGND sg13cmos5l_decap_4
X$7476 VPWR VGND sg13cmos5l_decap_4
X$7477 VPWR VGND sg13cmos5l_decap_4
X$7478 VPWR VGND sg13cmos5l_decap_4
X$7479 VPWR VGND sg13cmos5l_decap_4
X$7480 VPWR VGND sg13cmos5l_decap_4
X$7481 VPWR VGND sg13cmos5l_decap_4
X$7482 VPWR VGND sg13cmos5l_decap_4
X$7483 VPWR VGND sg13cmos5l_decap_4
X$7484 VPWR VGND sg13cmos5l_decap_4
X$7485 VPWR VGND sg13cmos5l_decap_4
X$7486 VPWR VGND sg13cmos5l_decap_4
X$7487 VPWR VGND sg13cmos5l_decap_4
X$7488 VPWR VGND sg13cmos5l_decap_4
X$7489 VPWR VGND sg13cmos5l_decap_4
X$7490 VPWR VGND sg13cmos5l_decap_4
X$7491 VPWR VGND sg13cmos5l_decap_4
X$7492 VPWR VGND sg13cmos5l_decap_4
X$7493 VPWR VGND sg13cmos5l_decap_4
X$7494 VGND \$1772 VPWR \$2073 sg13cmos5l_buf_1
X$7495 VGND \$3788 VPWR \$3293 sg13cmos5l_buf_1
X$7496 VGND \$709 VPWR \$2032 sg13cmos5l_buf_1
X$7497 VGND \$2964 VPWR \$3043 sg13cmos5l_buf_1
X$7498 VGND \$3699 VPWR \$3293 sg13cmos5l_buf_1
X$7499 VGND \$2349 VPWR \$2194 sg13cmos5l_buf_1
X$7500 VGND \$2858 VPWR \$2002 sg13cmos5l_buf_1
X$7501 VGND \$2944 VPWR \$3178 sg13cmos5l_buf_1
X$7502 VGND \$3043 VPWR \$3409 sg13cmos5l_buf_1
X$7503 VGND \$2742 VPWR \$2968 sg13cmos5l_buf_1
X$7504 VGND \$1702 VPWR \$1654 sg13cmos5l_buf_1
X$7505 VGND \$259 VPWR \$1230 sg13cmos5l_buf_1
X$7506 VGND \$1479 VPWR \$1654 sg13cmos5l_buf_1
X$7507 VGND \$995 VPWR \$979 sg13cmos5l_buf_1
X$7508 VGND \$1654 VPWR \$237 sg13cmos5l_buf_1
X$7509 VGND \$2325 VPWR \$2189 sg13cmos5l_buf_1
X$7510 VGND \$25 VPWR \$28 sg13cmos5l_buf_1
X$7511 VGND \$43 VPWR \$46 sg13cmos5l_buf_1
X$7512 VGND \$1070 VPWR \$302 sg13cmos5l_buf_1
X$7513 VGND \$52 VPWR \$54 sg13cmos5l_buf_1
X$7514 VGND \$116 VPWR \$46 sg13cmos5l_buf_1
X$7515 VGND \$916 VPWR \$915 sg13cmos5l_buf_1
X$7516 VGND \$224 VPWR \$259 sg13cmos5l_buf_1
X$7517 VGND \$3148 VPWR \$3734 sg13cmos5l_buf_1
X$7518 VGND \$2969 VPWR \$3093 sg13cmos5l_buf_1
X$7519 VGND \$2916 VPWR \$2082 sg13cmos5l_buf_1
X$7520 VGND \$3293 VPWR \$2234 sg13cmos5l_buf_1
X$7521 VGND \$I12072 VPWR \$1443 sg13cmos5l_buf_1
X$7522 VGND \$2613 VPWR \$2860 sg13cmos5l_buf_1
X$7523 VGND \$555 VPWR \$916 sg13cmos5l_buf_1
X$7524 VGND \$2559 VPWR \$2470 sg13cmos5l_buf_1
X$7525 VGND \$2460 VPWR \$2325 sg13cmos5l_buf_1
X$7526 VGND \$41 VPWR vctrl_b_in sg13cmos5l_buf_1
X$7527 VGND vctrl_b_out VPWR \$41 sg13cmos5l_buf_1
X$7528 VGND \$849 VPWR \$995 sg13cmos5l_buf_1
X$7529 VGND \$237 VPWR \$2408 sg13cmos5l_buf_1
X$7530 VGND \$46 VPWR \$237 sg13cmos5l_buf_1
X$7531 VPWR VGND \$164 \$52 \$195 sg13cmos5l_nand2_1
X$7532 VGND \$602 VPWR \$1290 sg13cmos5l_buf_1
X$7533 VGND \$2239 VPWR \$2302 sg13cmos5l_buf_1
X$7534 VGND dac_out VPWR \$3959 sg13cmos5l_buf_1
X$7535 VGND \$683 VPWR \$1075 sg13cmos5l_buf_1
X$7536 VGND \$I12058 VPWR \$526 sg13cmos5l_buf_1
X$7537 VGND \$I12057 VPWR \$674 sg13cmos5l_buf_1
X$7538 VGND \$2234 VPWR \$2408 sg13cmos5l_buf_1
X$7539 VGND \$1444 VPWR \$1654 sg13cmos5l_buf_1
X$7540 VGND \$611 VPWR \$343 sg13cmos5l_buf_1
X$7541 VGND \$36 VPWR vctrl_in sg13cmos5l_buf_1
X$7542 VGND \$2557 VPWR \$2092 sg13cmos5l_buf_1
X$7543 VGND \$2082 VPWR \$2117 sg13cmos5l_buf_1
X$7544 VGND \$2002 VPWR \$1997 sg13cmos5l_buf_1
X$7545 VGND \$12 VPWR \$51 sg13cmos5l_buf_1
X$7546 VGND \$346 VPWR \$302 sg13cmos5l_buf_1
X$7547 VGND \$2408 VPWR rst_ni sg13cmos5l_buf_1
X$7548 VGND \$2670 VPWR \$3736 sg13cmos5l_buf_1
X$7549 VGND \$2949 VPWR \$3065 sg13cmos5l_buf_1
X$7550 VGND \$2619 VPWR \$3724 sg13cmos5l_buf_1
X$7551 VGND \$3066 VPWR \$2666 sg13cmos5l_buf_1
X$7552 VGND \$2930 VPWR \$2082 sg13cmos5l_buf_1
X$7553 VGND \$175 VPWR \$149 sg13cmos5l_buf_1
X$7554 VGND \$2092 VPWR \$709 sg13cmos5l_buf_1
X$7555 VGND \$51 VPWR \$53 sg13cmos5l_buf_1
M$1 \$296 \$296 \$296 VAPWR sg13_hv_pmos L=0.5u W=4u AS=1.36p AD=1.36p PS=8.68u
+ PD=8.68u rfmode=0
M$2 \$364 \$364 VGND VGND sg13_hv_nmos L=0.5u W=8u AS=2.72p AD=2.72p PS=18.72u
+ PD=18.72u rfmode=0
M$3 \$297 \$297 \$297 VAPWR sg13_hv_pmos L=0.5u W=12u AS=4.08p AD=4.08p
+ PS=26.04u PD=26.04u rfmode=0
M$4 \$364 \$364 \$364 VGND sg13_hv_nmos L=0.5u W=2u AS=0.68p AD=0.68p PS=4.68u
+ PD=4.68u rfmode=0
M$5 \$364 \$364 \$364 VAPWR sg13_hv_pmos L=0.5u W=4u AS=1.36p AD=1.36p PS=8.68u
+ PD=8.68u rfmode=0
M$6 \$364 ACC_CAP \$297 VAPWR sg13_hv_pmos L=0.5u W=16u AS=5.44p AD=5.44p
+ PS=34.72u PD=34.72u rfmode=0
M$7 \$296 \$296 \$296 VGND sg13_hv_nmos L=0.5u W=2u AS=0.68p AD=0.68p PS=4.68u
+ PD=4.68u rfmode=0
M$8 \$296 vref0 \$297 VAPWR sg13_hv_pmos L=0.5u W=16u AS=5.44p AD=5.44p
+ PS=34.72u PD=34.72u rfmode=0
M$9 \$296 \$364 VGND VGND sg13_hv_nmos L=0.5u W=8u AS=2.72p AD=2.72p PS=18.72u
+ PD=18.72u rfmode=0
M$17 VGND VGND VGND VGND sg13_hv_nmos L=0.5u W=38.5u AS=13.09p AD=13.09p
+ PS=96.72u PD=96.72u rfmode=0
R$25 VGND vref0 VGND rhigh w=2u l=12.9u ps=0u b=0 m=1
M$26 \$1921 \$1923 VGND VGND sg13_hv_nmos L=0.5u W=8u AS=2.72p AD=2.72p
+ PS=18.72u PD=18.72u rfmode=0
M$27 \$1333 \$1333 \$1333 VAPWR sg13_hv_pmos L=0.5u W=12u AS=4.08p AD=4.08p
+ PS=26.04u PD=26.04u rfmode=0
M$28 \$1923 ACC_CAP \$1924 VAPWR sg13_hv_pmos L=0.5u W=16u AS=5.44p AD=5.44p
+ PS=34.72u PD=34.72u rfmode=0
M$29 \$1921 \$1921 \$1921 VGND sg13_hv_nmos L=0.5u W=2u AS=0.68p AD=0.68p
+ PS=4.68u PD=4.68u rfmode=0
M$30 \$1923 \$1923 \$1923 VGND sg13_hv_nmos L=0.5u W=2u AS=0.68p AD=0.68p
+ PS=4.68u PD=4.68u rfmode=0
M$31 \$1396 \$1396 \$1396 VAPWR sg13_hv_pmos L=0.5u W=4u AS=1.36p AD=1.36p
+ PS=8.68u PD=8.68u rfmode=0
R$32 vref0 vref1 VGND rhigh w=2u l=2.8u ps=0u b=0 m=1
M$33 \$1332 vref1 \$1333 VAPWR sg13_hv_pmos L=0.5u W=16u AS=5.44p AD=5.44p
+ PS=34.72u PD=34.72u rfmode=0
M$35 \$1396 \$1396 VGND VGND sg13_hv_nmos L=0.5u W=8u AS=2.72p AD=2.72p
+ PS=18.72u PD=18.72u rfmode=0
M$38 \$1332 \$1396 VGND VGND sg13_hv_nmos L=0.5u W=8u AS=2.72p AD=2.72p
+ PS=18.72u PD=18.72u rfmode=0
M$46 \$1396 ACC_CAP \$1333 VAPWR sg13_hv_pmos L=0.5u W=16u AS=5.44p AD=5.44p
+ PS=34.72u PD=34.72u rfmode=0
M$48 \$1332 \$1332 \$1332 VGND sg13_hv_nmos L=0.5u W=2u AS=0.68p AD=0.68p
+ PS=4.68u PD=4.68u rfmode=0
M$51 \$1396 \$1396 \$1396 VGND sg13_hv_nmos L=0.5u W=2u AS=0.68p AD=0.68p
+ PS=4.68u PD=4.68u rfmode=0
M$54 \$1332 \$1332 \$1332 VAPWR sg13_hv_pmos L=0.5u W=4u AS=1.36p AD=1.36p
+ PS=8.68u PD=8.68u rfmode=0
M$55 \$1924 \$1924 \$1924 VAPWR sg13_hv_pmos L=0.5u W=12u AS=4.08p AD=4.08p
+ PS=26.04u PD=26.04u rfmode=0
M$56 \$1923 \$1923 VGND VGND sg13_hv_nmos L=0.5u W=8u AS=2.72p AD=2.72p
+ PS=18.72u PD=18.72u rfmode=0
M$59 \$1921 vref2 \$1924 VAPWR sg13_hv_pmos L=0.5u W=16u AS=5.44p AD=5.44p
+ PS=34.72u PD=34.72u rfmode=0
R$69 \$1151 VGND VGND rhigh w=2u l=4.25u ps=0u b=0 m=1
R$70 \$181 VGND VGND rhigh w=2u l=13.71u ps=0.18u b=8 m=1
R$71 \$1242 VGND VGND rhigh w=2u l=13.71u ps=0.18u b=8 m=1
R$72 \$1839 VGND VGND rhigh w=2u l=13.71u ps=0.18u b=8 m=1
R$73 \$2778 VGND VGND rhigh w=2u l=13.71u ps=0.18u b=8 m=1
R$74 vcl \$1421 VGND rsil w=0.5u l=0.5u ps=0u b=0 m=1
R$75 dac_out vcl VGND rhigh w=1u l=61.395u ps=0.18u b=2 m=1
R$76 vref1 vref2 VGND rhigh w=2u l=1.4u ps=0u b=0 m=1
R$77 vref2 vref3 VGND rhigh w=2u l=1.4u ps=0u b=0 m=1
M$78 \$1921 \$1921 \$1921 VAPWR sg13_hv_pmos L=0.5u W=4u AS=1.36p AD=1.36p
+ PS=8.68u PD=8.68u rfmode=0
M$79 \$2781 \$2781 \$2781 VAPWR sg13_hv_pmos L=0.5u W=4u AS=1.36p AD=1.36p
+ PS=8.68u PD=8.68u rfmode=0
M$80 \$2783 \$2783 \$2783 VAPWR sg13_hv_pmos L=0.5u W=12u AS=4.08p AD=4.08p
+ PS=26.04u PD=26.04u rfmode=0
M$81 \$2873 \$2873 VGND VGND sg13_hv_nmos L=0.5u W=8u AS=2.72p AD=2.72p
+ PS=18.72u PD=18.72u rfmode=0
M$82 \$2873 ACC_CAP \$2783 VAPWR sg13_hv_pmos L=0.5u W=16u AS=5.44p AD=5.44p
+ PS=34.72u PD=34.72u rfmode=0
M$84 \$2781 vref3 \$2783 VAPWR sg13_hv_pmos L=0.5u W=16u AS=5.44p AD=5.44p
+ PS=34.72u PD=34.72u rfmode=0
M$88 \$1923 \$1923 \$1923 VAPWR sg13_hv_pmos L=0.5u W=4u AS=1.36p AD=1.36p
+ PS=8.68u PD=8.68u rfmode=0
R$89 VGND \$185 VGND rhigh w=2u l=9.27u ps=0.18u b=15 m=1
R$90 VGND \$1844 VGND rhigh w=2u l=9.27u ps=0.18u b=15 m=1
R$91 VGND \$1247 VGND rhigh w=2u l=9.27u ps=0.18u b=15 m=1
R$92 VGND \$2685 VGND rhigh w=2u l=9.27u ps=0.18u b=15 m=1
M$95 \$2781 \$2873 VGND VGND sg13_hv_nmos L=0.5u W=8u AS=2.72p AD=2.72p
+ PS=18.72u PD=18.72u rfmode=0
M$101 \$2873 \$2873 \$2873 VAPWR sg13_hv_pmos L=0.5u W=4u AS=1.36p AD=1.36p
+ PS=8.68u PD=8.68u rfmode=0
M$104 \$2781 \$2781 \$2781 VGND sg13_hv_nmos L=0.5u W=2u AS=0.68p AD=0.68p
+ PS=4.68u PD=4.68u rfmode=0
M$106 \$2873 \$2873 \$2873 VGND sg13_hv_nmos L=0.5u W=2u AS=0.68p AD=0.68p
+ PS=4.68u PD=4.68u rfmode=0
M$108 ACC_CAP ACC_CAP opm opm sg13_hv_pmos L=0.5u W=20u AS=4.1p AD=4.1p
+ PS=26.1u PD=26.1u rfmode=0
R$118 VGND \$3805 VGND rhigh w=2u l=10u ps=0u b=0 m=1
R$119 VGND opm VGND rhigh w=2u l=8u ps=0u b=0 m=1
R$120 \$870 rx_in VGND rhigh w=2u l=9.96u ps=0.18u b=3 m=1
R$121 \$3953 Cap_M21 VGND rhigh w=2u l=9.96u ps=0.18u b=3 m=1
R$122 \$2466 Cap_M2 VGND rhigh w=2u l=9.96u ps=0.18u b=3 m=1
R$123 VGND \$235 VGND rhigh w=2u l=4.95u ps=0.18u b=2 m=1
R$124 VGND \$4169 VGND rhigh w=2u l=4.95u ps=0.18u b=2 m=1
R$125 VGND \$1403 VGND rhigh w=2u l=4.95u ps=0.18u b=2 m=1
R$126 VGND \$2791 VGND rhigh w=2u l=4.95u ps=0.18u b=2 m=1
R$127 VGND \$1847 VGND rhigh w=2u l=4.95u ps=0.18u b=2 m=1
R$128 VGND \$3596 VGND rhigh w=2u l=4.95u ps=0.18u b=2 m=1
R$129 VAPWR \$236 VGND rhigh w=2u l=19.995u ps=0.18u b=9 m=1
R$130 VAPWR \$1851 VGND rhigh w=2u l=19.995u ps=0.18u b=9 m=1
R$131 VAPWR \$3599 VGND rhigh w=2u l=19.995u ps=0.18u b=9 m=1
R$132 VAPWR vref3 VGND rhigh w=2u l=28.8u ps=0u b=0 m=1
R$133 \$1252 VAPWR VGND rhigh w=2u l=22.72u ps=0.18u b=10 m=1
R$134 \$4116 VAPWR VGND rhigh w=2u l=22.72u ps=0.18u b=10 m=1
R$135 \$2693 VAPWR VGND rhigh w=2u l=22.72u ps=0.18u b=10 m=1
R$136 \$870 VAPWR VGND rhigh w=2u l=19.995u ps=0.18u b=9 m=1
R$137 \$3953 VAPWR VGND rhigh w=2u l=19.995u ps=0.18u b=9 m=1
R$138 \$2466 VAPWR VGND rhigh w=2u l=19.995u ps=0.18u b=9 m=1
M$143 VPWR VPWR VPWR VPWR sg13_hv_pmos L=4u W=8u AS=2.72p AD=2.72p PS=18.72u
+ PD=18.72u rfmode=0
M$144 q0 \$429 VPWR VPWR sg13_hv_pmos L=4u W=2u AS=0.68p AD=0.68p PS=4.68u
+ PD=4.68u rfmode=0
M$145 q0 q0 q0 VPWR sg13_hv_pmos L=4u W=2u AS=0.68p AD=0.68p PS=4.68u PD=4.68u
+ rfmode=0
M$146 VAPWR VAPWR VAPWR VAPWR sg13_hv_pmos L=4u W=8u AS=2.72p AD=2.72p
+ PS=18.72u PD=18.72u rfmode=0
M$147 \$429 \$296 VAPWR VAPWR sg13_hv_pmos L=4u W=2u AS=0.68p AD=0.68p PS=4.68u
+ PD=4.68u rfmode=0
M$148 \$429 \$429 \$429 VAPWR sg13_hv_pmos L=4u W=2u AS=0.68p AD=0.68p PS=4.68u
+ PD=4.68u rfmode=0
M$149 \$181 \$181 \$181 VGND sg13_hv_nmos L=4u W=2u AS=0.68p AD=0.68p PS=4.68u
+ PD=4.68u rfmode=0
M$150 \$429 \$296 \$181 VGND sg13_hv_nmos L=4u W=2u AS=0.68p AD=0.68p PS=4.68u
+ PD=4.68u rfmode=0
M$151 \$429 \$429 \$429 VGND sg13_hv_nmos L=4u W=2u AS=0.68p AD=0.68p PS=4.68u
+ PD=4.68u rfmode=0
M$152 \$1242 \$1242 \$1242 VGND sg13_hv_nmos L=4u W=2u AS=0.68p AD=0.68p
+ PS=4.68u PD=4.68u rfmode=0
M$153 \$1460 \$1332 \$1242 VGND sg13_hv_nmos L=4u W=2u AS=0.68p AD=0.68p
+ PS=4.68u PD=4.68u rfmode=0
M$154 \$1460 \$1460 \$1460 VGND sg13_hv_nmos L=4u W=2u AS=0.68p AD=0.68p
+ PS=4.68u PD=4.68u rfmode=0
M$156 q1 \$1460 VPWR VPWR sg13_hv_pmos L=4u W=2u AS=0.68p AD=0.68p PS=4.68u
+ PD=4.68u rfmode=0
M$157 q1 q1 q1 VPWR sg13_hv_pmos L=4u W=2u AS=0.68p AD=0.68p PS=4.68u PD=4.68u
+ rfmode=0
M$159 \$1460 \$1332 VAPWR VAPWR sg13_hv_pmos L=4u W=2u AS=0.68p AD=0.68p
+ PS=4.68u PD=4.68u rfmode=0
M$160 \$1460 \$1460 \$1460 VAPWR sg13_hv_pmos L=4u W=2u AS=0.68p AD=0.68p
+ PS=4.68u PD=4.68u rfmode=0
M$161 \$40 \$40 \$40 VPWR sg13_lv_pmos L=0.13u W=2u AS=0.68p AD=0.68p PS=4.68u
+ PD=4.68u rfmode=0
M$162 VPWR VPWR VPWR VPWR sg13_lv_pmos L=0.13u W=10.25u AS=3.485p AD=3.485p
+ PS=26.62u PD=26.62u rfmode=0
M$163 \$40 \$246 VPWR VPWR sg13_lv_pmos L=0.13u W=40u AS=7.9p AD=7.9p PS=49.9u
+ PD=49.9u rfmode=0
M$183 VGND VGND VGND VGND sg13_lv_nmos L=0.13u W=11u AS=3.74p AD=3.74p
+ PS=28.12u PD=28.12u rfmode=0
M$184 \$40 \$40 \$40 VGND sg13_lv_nmos L=0.13u W=1.8u AS=0.612p AD=0.612p
+ PS=4.28u PD=4.28u rfmode=0
M$185 \$40 \$246 VGND VGND sg13_lv_nmos L=0.13u W=18u AS=3.69p AD=3.69p
+ PS=23.9u PD=23.9u rfmode=0
M$196 tx_out tx_out tx_out VGND sg13_lv_nmos L=0.13u W=4u AS=1.36p AD=1.36p
+ PS=8.68u PD=8.68u rfmode=0
M$197 tx_out \$40 VGND VGND sg13_lv_nmos L=0.13u W=80u AS=15.8p AD=15.8p
+ PS=91.9u PD=91.9u rfmode=0
M$217 \$867 \$867 \$867 VGND sg13_lv_nmos L=0.13u W=0.4u AS=0.136p AD=0.136p
+ PS=1.48u PD=1.48u rfmode=0
M$218 \$1013 \$1013 \$1013 VGND sg13_lv_nmos L=0.13u W=1u AS=0.34p AD=0.34p
+ PS=3.36u PD=3.36u rfmode=0
M$219 \$867 \$1012 \$1013 VGND sg13_lv_nmos L=0.13u W=2u AS=0.44p AD=0.44p
+ PS=4.6u PD=4.6u rfmode=0
M$224 \$1011 \$1011 \$1011 VPWR sg13_lv_pmos L=0.13u W=0.95u AS=0.323p
+ AD=0.323p PS=3.26u PD=3.26u rfmode=0
M$226 \$1011 \$1034 VPWR VPWR sg13_lv_pmos L=0.13u W=5u AS=1.025p AD=1.025p
+ PS=9.6u PD=9.6u rfmode=0
M$236 clk_fb clk_fb clk_fb VPWR sg13_lv_pmos L=0.13u W=2.6u AS=0.884p AD=0.884p
+ PS=6.56u PD=6.56u rfmode=0
M$238 clk_fb \$482 VPWR VPWR sg13_lv_pmos L=0.13u W=13.5u AS=2.7675p AD=2.7675p
+ PS=18.95u PD=18.95u rfmode=0
M$249 \$482 \$482 \$482 VPWR sg13_lv_pmos L=0.13u W=0.45u AS=0.153p AD=0.153p
+ PS=1.58u PD=1.58u rfmode=0
M$250 \$482 \$867 VPWR VPWR sg13_lv_pmos L=0.13u W=4.5u AS=0.9225p AD=0.9225p
+ PS=9.05u PD=9.05u rfmode=0
M$260 \$482 \$482 \$482 VGND sg13_lv_nmos L=0.13u W=0.4u AS=0.136p AD=0.136p
+ PS=1.48u PD=1.48u rfmode=0
M$262 \$482 \$867 VGND VGND sg13_lv_nmos L=0.13u W=2u AS=0.44p AD=0.44p PS=4.6u
+ PD=4.6u rfmode=0
M$268 \$867 \$867 \$867 VPWR sg13_lv_pmos L=0.13u W=0.45u AS=0.153p AD=0.153p
+ PS=1.58u PD=1.58u rfmode=0
M$269 \$867 \$1012 \$1011 VPWR sg13_lv_pmos L=0.13u W=4.5u AS=0.9225p
+ AD=0.9225p PS=9.05u PD=9.05u rfmode=0
M$279 clk_fb clk_fb clk_fb VGND sg13_lv_nmos L=0.13u W=2.4u AS=0.816p AD=0.816p
+ PS=6.16u PD=6.16u rfmode=0
M$281 clk_fb \$482 VGND VGND sg13_lv_nmos L=0.13u W=6u AS=1.32p AD=1.32p
+ PS=9.4u PD=9.4u rfmode=0
M$286 \$246 \$246 \$246 VGND sg13_lv_nmos L=0.13u W=2.4u AS=0.816p AD=0.816p
+ PS=6.16u PD=6.16u rfmode=0
M$288 \$246 vctrl_b_out VGND VGND sg13_lv_nmos L=0.13u W=6u AS=1.32p AD=1.32p
+ PS=9.4u PD=9.4u rfmode=0
M$293 \$246 \$246 \$246 VPWR sg13_lv_pmos L=0.13u W=2.6u AS=0.884p AD=0.884p
+ PS=6.56u PD=6.56u rfmode=0
M$295 \$246 vctrl_b_out clk_fb VPWR sg13_lv_pmos L=0.13u W=13.5u AS=2.7675p
+ AD=2.7675p PS=18.95u PD=18.95u rfmode=0
M$305 tx_out tx_out tx_out VPWR sg13_lv_pmos L=0.13u W=4u AS=1.36p AD=1.36p
+ PS=8.68u PD=8.68u rfmode=0
M$307 tx_out \$40 VPWR VPWR sg13_lv_pmos L=0.13u W=200u AS=38.6p AD=38.6p
+ PS=223.3u PD=223.3u rfmode=0
M$359 \$1013 \$1027 VGND VGND sg13_lv_nmos L=0.13u W=3u AS=0.66p AD=0.66p
+ PS=5.8u PD=5.8u rfmode=0
M$365 VGND VGND VGND VPWR sg13_lv_pmos L=0.13u W=1.3u AS=0.442p AD=0.442p
+ PS=3.28u PD=3.28u rfmode=0
M$366 \$246 vctrl_out VGND VPWR sg13_lv_pmos L=0.13u W=13.5u AS=2.7675p
+ AD=2.7675p PS=18.95u PD=18.95u rfmode=0
M$378 \$246 vctrl_out clk_fb VGND sg13_lv_nmos L=0.13u W=6u AS=1.32p AD=1.32p
+ PS=9.4u PD=9.4u rfmode=0
M$383 \$1084 \$1084 \$1084 VGND sg13_lv_nmos L=0.13u W=0.4u AS=0.136p AD=0.136p
+ PS=1.48u PD=1.48u rfmode=0
M$384 \$1241 \$1241 \$1241 VGND sg13_lv_nmos L=0.13u W=1u AS=0.34p AD=0.34p
+ PS=3.36u PD=3.36u rfmode=0
M$385 \$1084 \$867 \$1241 VGND sg13_lv_nmos L=0.13u W=2u AS=0.44p AD=0.44p
+ PS=4.6u PD=4.6u rfmode=0
M$391 \$1027 \$1027 \$1027 VGND sg13_lv_nmos L=0.13u W=0.6u AS=0.204p AD=0.204p
+ PS=1.88u PD=1.88u rfmode=0
M$392 \$1027 \$1027 VGND VGND sg13_lv_nmos L=0.13u W=3u AS=0.66p AD=0.66p
+ PS=5.8u PD=5.8u rfmode=0
M$397 \$1027 \$1027 \$1027 VPWR sg13_lv_pmos L=0.13u W=0.5u AS=0.17p AD=0.17p
+ PS=1.68u PD=1.68u rfmode=0
M$399 \$1027 \$1034 VPWR VPWR sg13_lv_pmos L=0.13u W=5u AS=1.025p AD=1.025p
+ PS=9.6u PD=9.6u rfmode=0
M$410 \$1034 \$1034 \$1034 VPWR sg13_lv_pmos L=0.13u W=0.5u AS=0.17p AD=0.17p
+ PS=1.68u PD=1.68u rfmode=0
M$411 VPWR \$1034 \$1034 VPWR sg13_lv_pmos L=0.13u W=5u AS=1.025p AD=1.025p
+ PS=9.6u PD=9.6u rfmode=0
M$421 \$1034 \$1034 \$1034 VGND sg13_lv_nmos L=0.13u W=2u AS=0.68p AD=0.68p
+ PS=4.68u PD=4.68u rfmode=0
M$422 \$1151 \$1151 \$1151 VGND sg13_lv_nmos L=0.13u W=2u AS=0.68p AD=0.68p
+ PS=4.68u PD=4.68u rfmode=0
M$423 \$1151 \$1421 \$1034 VGND sg13_lv_nmos L=0.13u W=40u AS=7.9p AD=7.9p
+ PS=49.9u PD=49.9u rfmode=0
M$445 \$1241 \$1027 VGND VGND sg13_lv_nmos L=0.13u W=3u AS=0.66p AD=0.66p
+ PS=5.8u PD=5.8u rfmode=0
M$450 \$1238 \$1238 \$1238 VPWR sg13_lv_pmos L=0.13u W=0.95u AS=0.323p
+ AD=0.323p PS=3.26u PD=3.26u rfmode=0
M$452 \$1238 \$1034 VPWR VPWR sg13_lv_pmos L=0.13u W=5u AS=1.025p AD=1.025p
+ PS=9.6u PD=9.6u rfmode=0
M$463 \$1084 \$1084 \$1084 VPWR sg13_lv_pmos L=0.13u W=0.45u AS=0.153p
+ AD=0.153p PS=1.58u PD=1.58u rfmode=0
M$464 \$1084 \$867 \$1238 VPWR sg13_lv_pmos L=0.13u W=4.5u AS=0.9225p
+ AD=0.9225p PS=9.05u PD=9.05u rfmode=0
M$474 \$1148 \$1148 \$1148 VPWR sg13_lv_pmos L=0.13u W=0.95u AS=0.323p
+ AD=0.323p PS=3.26u PD=3.26u rfmode=0
M$475 \$1012 \$1012 \$1012 VPWR sg13_lv_pmos L=0.13u W=0.45u AS=0.153p
+ AD=0.153p PS=1.58u PD=1.58u rfmode=0
M$476 \$1012 \$1084 \$1148 VPWR sg13_lv_pmos L=0.13u W=4.5u AS=0.9225p
+ AD=0.9225p PS=9.05u PD=9.05u rfmode=0
M$486 \$1012 \$1012 \$1012 VGND sg13_lv_nmos L=0.13u W=0.4u AS=0.136p AD=0.136p
+ PS=1.48u PD=1.48u rfmode=0
M$487 \$1150 \$1150 \$1150 VGND sg13_lv_nmos L=0.13u W=1u AS=0.34p AD=0.34p
+ PS=3.36u PD=3.36u rfmode=0
M$488 \$1012 \$1084 \$1150 VGND sg13_lv_nmos L=0.13u W=2u AS=0.44p AD=0.44p
+ PS=4.6u PD=4.6u rfmode=0
M$495 \$1148 \$1034 VPWR VPWR sg13_lv_pmos L=0.13u W=5u AS=1.025p AD=1.025p
+ PS=9.6u PD=9.6u rfmode=0
M$507 \$1150 \$1027 VGND VGND sg13_lv_nmos L=0.13u W=3u AS=0.66p AD=0.66p
+ PS=5.8u PD=5.8u rfmode=0
M$513 \$2872 \$2781 VAPWR VAPWR sg13_hv_pmos L=4u W=2u AS=0.68p AD=0.68p
+ PS=4.68u PD=4.68u rfmode=0
M$514 \$2872 \$2872 \$2872 VAPWR sg13_hv_pmos L=4u W=2u AS=0.68p AD=0.68p
+ PS=4.68u PD=4.68u rfmode=0
M$515 \$185 \$185 \$185 VAPWR sg13_hv_pmos L=0.5u W=4u AS=1.36p AD=1.36p
+ PS=8.68u PD=8.68u rfmode=0
M$516 \$1844 \$1844 \$1844 VAPWR sg13_hv_pmos L=0.5u W=4u AS=1.36p AD=1.36p
+ PS=8.68u PD=8.68u rfmode=0
M$517 \$1247 \$1247 \$1247 VAPWR sg13_hv_pmos L=0.5u W=4u AS=1.36p AD=1.36p
+ PS=8.68u PD=8.68u rfmode=0
M$518 \$2685 \$2685 \$2685 VAPWR sg13_hv_pmos L=0.5u W=4u AS=1.36p AD=1.36p
+ PS=8.68u PD=8.68u rfmode=0
M$519 \$185 \$185 VAPWR VAPWR sg13_hv_pmos L=0.5u W=4u AS=1.36p AD=1.36p
+ PS=8.68u PD=8.68u rfmode=0
M$520 \$1844 \$1844 VAPWR VAPWR sg13_hv_pmos L=0.5u W=4u AS=1.36p AD=1.36p
+ PS=8.68u PD=8.68u rfmode=0
M$521 \$1247 \$1247 VAPWR VAPWR sg13_hv_pmos L=0.5u W=4u AS=1.36p AD=1.36p
+ PS=8.68u PD=8.68u rfmode=0
M$522 \$2685 \$2685 VAPWR VAPWR sg13_hv_pmos L=0.5u W=4u AS=1.36p AD=1.36p
+ PS=8.68u PD=8.68u rfmode=0
M$523 VAPWR VAPWR VAPWR VAPWR sg13_hv_pmos L=0.5u W=60u AS=20.4p AD=20.4p
+ PS=134.96u PD=134.96u rfmode=0
M$527 \$2778 \$2778 \$2778 VGND sg13_hv_nmos L=4u W=2u AS=0.68p AD=0.68p
+ PS=4.68u PD=4.68u rfmode=0
M$528 \$2872 \$2781 \$2778 VGND sg13_hv_nmos L=4u W=2u AS=0.68p AD=0.68p
+ PS=4.68u PD=4.68u rfmode=0
M$529 \$2872 \$2872 \$2872 VGND sg13_hv_nmos L=4u W=2u AS=0.68p AD=0.68p
+ PS=4.68u PD=4.68u rfmode=0
M$531 q3 \$2872 VPWR VPWR sg13_hv_pmos L=4u W=2u AS=0.68p AD=0.68p PS=4.68u
+ PD=4.68u rfmode=0
M$532 q3 q3 q3 VPWR sg13_hv_pmos L=4u W=2u AS=0.68p AD=0.68p PS=4.68u PD=4.68u
+ rfmode=0
M$533 \$3805 \$3805 \$3805 VAPWR sg13_hv_pmos L=0.5u W=2u AS=0.68p AD=0.68p
+ PS=4.68u PD=4.68u rfmode=0
M$535 \$3805 \$3805 VAPWR VAPWR sg13_hv_pmos L=0.5u W=14u AS=2.96p AD=2.96p
+ PS=18.96u PD=18.96u rfmode=0
M$542 opm opm opm VAPWR sg13_hv_pmos L=0.5u W=2u AS=0.68p AD=0.68p PS=4.68u
+ PD=4.68u rfmode=0
M$544 opm \$3805 VAPWR VAPWR sg13_hv_pmos L=0.5u W=14u AS=2.96p AD=2.96p
+ PS=18.96u PD=18.96u rfmode=0
M$551 \$1403 \$1403 \$1403 VAPWR sg13_hv_pmos L=0.5u W=2u AS=0.68p AD=0.68p
+ PS=4.68u PD=4.68u rfmode=0
M$552 \$4169 \$4169 \$4169 VAPWR sg13_hv_pmos L=0.5u W=2u AS=0.68p AD=0.68p
+ PS=4.68u PD=4.68u rfmode=0
M$553 \$2791 \$2791 \$2791 VAPWR sg13_hv_pmos L=0.5u W=2u AS=0.68p AD=0.68p
+ PS=4.68u PD=4.68u rfmode=0
M$557 \$1403 \$1403 VAPWR VAPWR sg13_hv_pmos L=0.5u W=14u AS=2.96p AD=2.96p
+ PS=18.96u PD=18.96u rfmode=0
M$564 \$4169 \$4169 VAPWR VAPWR sg13_hv_pmos L=0.5u W=14u AS=2.96p AD=2.96p
+ PS=18.96u PD=18.96u rfmode=0
M$571 \$2791 \$2791 VAPWR VAPWR sg13_hv_pmos L=0.5u W=14u AS=2.96p AD=2.96p
+ PS=18.96u PD=18.96u rfmode=0
M$578 Cap_M1 Cap_M1 Cap_M1 VGND sg13_hv_nmos L=0.5u W=1.5u AS=0.51p AD=0.51p
+ PS=4.36u PD=4.36u rfmode=0
M$579 Cap_M11 Cap_M11 Cap_M11 VGND sg13_hv_nmos L=0.5u W=1.5u AS=0.51p AD=0.51p
+ PS=4.36u PD=4.36u rfmode=0
M$580 lnaf lnaf lnaf VGND sg13_hv_nmos L=0.5u W=1.5u AS=0.51p AD=0.51p PS=4.36u
+ PD=4.36u rfmode=0
M$581 Cap_M1 \$1252 VGND VGND sg13_hv_nmos L=0.5u W=0.5u AS=0.17p AD=0.17p
+ PS=1.68u PD=1.68u rfmode=0
M$582 Cap_M11 \$2693 VGND VGND sg13_hv_nmos L=0.5u W=0.5u AS=0.17p AD=0.17p
+ PS=1.68u PD=1.68u rfmode=0
M$583 lnaf \$4116 VGND VGND sg13_hv_nmos L=0.5u W=0.5u AS=0.17p AD=0.17p
+ PS=1.68u PD=1.68u rfmode=0
M$587 Cap_M1 Cap_M1 Cap_M1 VAPWR sg13_hv_pmos L=0.5u W=2.7u AS=0.918p AD=0.918p
+ PS=6.76u PD=6.76u rfmode=0
M$588 Cap_M11 Cap_M11 Cap_M11 VAPWR sg13_hv_pmos L=0.5u W=2.7u AS=0.918p
+ AD=0.918p PS=6.76u PD=6.76u rfmode=0
M$589 lnaf lnaf lnaf VAPWR sg13_hv_pmos L=0.5u W=2.7u AS=0.918p AD=0.918p
+ PS=6.76u PD=6.76u rfmode=0
M$593 Cap_M1 \$1403 VAPWR VAPWR sg13_hv_pmos L=0.5u W=14u AS=2.96p AD=2.96p
+ PS=18.96u PD=18.96u rfmode=0
M$600 Cap_M11 \$2791 VAPWR VAPWR sg13_hv_pmos L=0.5u W=14u AS=2.96p AD=2.96p
+ PS=18.96u PD=18.96u rfmode=0
M$607 lnaf \$4169 VAPWR VAPWR sg13_hv_pmos L=0.5u W=14u AS=2.96p AD=2.96p
+ PS=18.96u PD=18.96u rfmode=0
M$614 \$870 \$870 \$870 VGND sg13_hv_nmos L=0.5u W=1u AS=0.34p AD=0.34p
+ PS=2.68u PD=2.68u rfmode=0
M$615 \$3953 \$3953 \$3953 VGND sg13_hv_nmos L=0.5u W=1u AS=0.34p AD=0.34p
+ PS=2.68u PD=2.68u rfmode=0
M$616 \$2466 \$2466 \$2466 VGND sg13_hv_nmos L=0.5u W=1u AS=0.34p AD=0.34p
+ PS=2.68u PD=2.68u rfmode=0
M$620 \$870 \$870 VGND VGND sg13_hv_nmos L=0.5u W=2u AS=0.53p AD=0.53p PS=4.06u
+ PD=4.06u rfmode=0
M$622 \$3953 \$3953 VGND VGND sg13_hv_nmos L=0.5u W=2u AS=0.53p AD=0.53p
+ PS=4.06u PD=4.06u rfmode=0
M$624 \$2466 \$2466 VGND VGND sg13_hv_nmos L=0.5u W=2u AS=0.53p AD=0.53p
+ PS=4.06u PD=4.06u rfmode=0
M$629 \$1152 \$1152 \$1152 VGND sg13_hv_nmos L=0.5u W=2u AS=0.68p AD=0.68p
+ PS=5.36u PD=5.36u rfmode=0
M$630 \$2686 \$2686 \$2686 VGND sg13_hv_nmos L=0.5u W=2u AS=0.68p AD=0.68p
+ PS=5.36u PD=5.36u rfmode=0
M$631 \$4109 \$4109 \$4109 VGND sg13_hv_nmos L=0.5u W=2u AS=0.68p AD=0.68p
+ PS=5.36u PD=5.36u rfmode=0
M$632 \$1152 rx_in VGND VGND sg13_hv_nmos L=0.5u W=18u AS=3.57p AD=3.57p
+ PS=26.14u PD=26.14u rfmode=0
M$650 \$2686 Cap_M2 VGND VGND sg13_hv_nmos L=0.5u W=18u AS=3.57p AD=3.57p
+ PS=26.14u PD=26.14u rfmode=0
M$668 \$4109 Cap_M21 VGND VGND sg13_hv_nmos L=0.5u W=18u AS=3.57p AD=3.57p
+ PS=26.14u PD=26.14u rfmode=0
M$686 \$1252 \$1252 \$1252 VGND sg13_hv_nmos L=0.5u W=0.5u AS=0.17p AD=0.17p
+ PS=1.68u PD=1.68u rfmode=0
M$687 \$2693 \$2693 \$2693 VGND sg13_hv_nmos L=0.5u W=0.5u AS=0.17p AD=0.17p
+ PS=1.68u PD=1.68u rfmode=0
M$688 \$4116 \$4116 \$4116 VGND sg13_hv_nmos L=0.5u W=0.5u AS=0.17p AD=0.17p
+ PS=1.68u PD=1.68u rfmode=0
M$689 \$1252 \$1252 VGND VGND sg13_hv_nmos L=0.5u W=0.5u AS=0.17p AD=0.17p
+ PS=1.68u PD=1.68u rfmode=0
M$690 \$2693 \$2693 VGND VGND sg13_hv_nmos L=0.5u W=0.5u AS=0.17p AD=0.17p
+ PS=1.68u PD=1.68u rfmode=0
M$691 \$4116 \$4116 VGND VGND sg13_hv_nmos L=0.5u W=0.5u AS=0.17p AD=0.17p
+ PS=1.68u PD=1.68u rfmode=0
M$695 VGND VGND VGND VAPWR sg13_hv_pmos L=0.5u W=2.1u AS=0.714p AD=0.714p
+ PS=6.24u PD=6.24u rfmode=0
M$698 VGND \$371 Cap_M1 VAPWR sg13_hv_pmos L=0.5u W=0.7u AS=0.238p AD=0.238p
+ PS=2.08u PD=2.08u rfmode=0
M$699 VGND \$3696 lnaf VAPWR sg13_hv_pmos L=0.5u W=0.7u AS=0.238p AD=0.238p
+ PS=2.08u PD=2.08u rfmode=0
M$700 VGND \$1850 Cap_M11 VAPWR sg13_hv_pmos L=0.5u W=0.7u AS=0.238p AD=0.238p
+ PS=2.08u PD=2.08u rfmode=0
M$710 Cap_M1 VAPWR \$1152 VGND sg13_hv_nmos L=0.5u W=2u AS=0.53p AD=0.53p
+ PS=4.06u PD=4.06u rfmode=0
M$712 Cap_M11 VAPWR \$2686 VGND sg13_hv_nmos L=0.5u W=2u AS=0.53p AD=0.53p
+ PS=4.06u PD=4.06u rfmode=0
M$714 lnaf VAPWR \$4109 VGND sg13_hv_nmos L=0.5u W=2u AS=0.53p AD=0.53p
+ PS=4.06u PD=4.06u rfmode=0
M$716 \$731 \$731 \$731 VGND sg13_hv_nmos L=0.5u W=0.5u AS=0.17p AD=0.17p
+ PS=1.68u PD=1.68u rfmode=0
M$717 \$3877 \$3877 \$3877 VGND sg13_hv_nmos L=0.5u W=0.5u AS=0.17p AD=0.17p
+ PS=1.68u PD=1.68u rfmode=0
M$718 \$2258 \$2258 \$2258 VGND sg13_hv_nmos L=0.5u W=0.5u AS=0.17p AD=0.17p
+ PS=1.68u PD=1.68u rfmode=0
M$719 \$731 Cap_M1 VGND VGND sg13_hv_nmos L=0.5u W=0.5u AS=0.17p AD=0.17p
+ PS=1.68u PD=1.68u rfmode=0
M$720 \$3877 lnaf VGND VGND sg13_hv_nmos L=0.5u W=0.5u AS=0.17p AD=0.17p
+ PS=1.68u PD=1.68u rfmode=0
M$721 \$2258 Cap_M11 VGND VGND sg13_hv_nmos L=0.5u W=0.5u AS=0.17p AD=0.17p
+ PS=1.68u PD=1.68u rfmode=0
M$725 VAPWR VAPWR VAPWR VGND sg13_hv_nmos L=0.5u W=4.5u AS=1.53p AD=1.53p
+ PS=11.04u PD=11.04u rfmode=0
M$728 VAPWR \$3877 \$3696 VGND sg13_hv_nmos L=0.5u W=1.5u AS=0.51p AD=0.51p
+ PS=3.68u PD=3.68u rfmode=0
M$729 VAPWR \$2258 \$1850 VGND sg13_hv_nmos L=0.5u W=1.5u AS=0.51p AD=0.51p
+ PS=3.68u PD=3.68u rfmode=0
M$730 VAPWR \$731 \$371 VGND sg13_hv_nmos L=0.5u W=1.5u AS=0.51p AD=0.51p
+ PS=3.68u PD=3.68u rfmode=0
M$731 \$3696 \$3696 \$3696 VGND sg13_hv_nmos L=0.5u W=3.5u AS=1.19p AD=1.19p
+ PS=8.36u PD=8.36u rfmode=0
M$732 \$1850 \$1850 \$1850 VGND sg13_hv_nmos L=0.5u W=3.5u AS=1.19p AD=1.19p
+ PS=8.36u PD=8.36u rfmode=0
M$733 \$371 \$371 \$371 VGND sg13_hv_nmos L=0.5u W=3.5u AS=1.19p AD=1.19p
+ PS=8.36u PD=8.36u rfmode=0
M$740 \$371 \$236 VGND VGND sg13_hv_nmos L=0.5u W=10u AS=2.2p AD=2.2p PS=14.2u
+ PD=14.2u rfmode=0
M$745 \$3696 \$3599 VGND VGND sg13_hv_nmos L=0.5u W=10u AS=2.2p AD=2.2p
+ PS=14.2u PD=14.2u rfmode=0
M$750 \$1850 \$1851 VGND VGND sg13_hv_nmos L=0.5u W=10u AS=2.2p AD=2.2p
+ PS=14.2u PD=14.2u rfmode=0
M$758 \$236 \$236 \$236 VGND sg13_hv_nmos L=0.5u W=2u AS=0.68p AD=0.68p
+ PS=4.68u PD=4.68u rfmode=0
M$759 \$3599 \$3599 \$3599 VGND sg13_hv_nmos L=0.5u W=2u AS=0.68p AD=0.68p
+ PS=4.68u PD=4.68u rfmode=0
M$760 \$1851 \$1851 \$1851 VGND sg13_hv_nmos L=0.5u W=2u AS=0.68p AD=0.68p
+ PS=4.68u PD=4.68u rfmode=0
M$761 \$236 \$236 VGND VGND sg13_hv_nmos L=0.5u W=10u AS=2.2p AD=2.2p PS=14.2u
+ PD=14.2u rfmode=0
M$766 \$3599 \$3599 VGND VGND sg13_hv_nmos L=0.5u W=10u AS=2.2p AD=2.2p
+ PS=14.2u PD=14.2u rfmode=0
M$771 \$1851 \$1851 VGND VGND sg13_hv_nmos L=0.5u W=10u AS=2.2p AD=2.2p
+ PS=14.2u PD=14.2u rfmode=0
M$779 \$731 \$731 \$731 VAPWR sg13_hv_pmos L=0.5u W=2u AS=0.68p AD=0.68p
+ PS=4.68u PD=4.68u rfmode=0
M$780 \$3877 \$3877 \$3877 VAPWR sg13_hv_pmos L=0.5u W=2u AS=0.68p AD=0.68p
+ PS=4.68u PD=4.68u rfmode=0
M$781 \$2258 \$2258 \$2258 VAPWR sg13_hv_pmos L=0.5u W=2u AS=0.68p AD=0.68p
+ PS=4.68u PD=4.68u rfmode=0
M$782 \$731 \$235 VAPWR VAPWR sg13_hv_pmos L=0.5u W=14u AS=2.96p AD=2.96p
+ PS=18.96u PD=18.96u rfmode=0
M$789 \$3877 \$3596 VAPWR VAPWR sg13_hv_pmos L=0.5u W=14u AS=2.96p AD=2.96p
+ PS=18.96u PD=18.96u rfmode=0
M$796 \$2258 \$1847 VAPWR VAPWR sg13_hv_pmos L=0.5u W=14u AS=2.96p AD=2.96p
+ PS=18.96u PD=18.96u rfmode=0
M$803 \$235 \$235 \$235 VAPWR sg13_hv_pmos L=0.5u W=2u AS=0.68p AD=0.68p
+ PS=4.68u PD=4.68u rfmode=0
M$804 \$3596 \$3596 \$3596 VAPWR sg13_hv_pmos L=0.5u W=2u AS=0.68p AD=0.68p
+ PS=4.68u PD=4.68u rfmode=0
M$805 \$1847 \$1847 \$1847 VAPWR sg13_hv_pmos L=0.5u W=2u AS=0.68p AD=0.68p
+ PS=4.68u PD=4.68u rfmode=0
M$809 \$235 \$235 VAPWR VAPWR sg13_hv_pmos L=0.5u W=14u AS=2.96p AD=2.96p
+ PS=18.96u PD=18.96u rfmode=0
M$816 \$3596 \$3596 VAPWR VAPWR sg13_hv_pmos L=0.5u W=14u AS=2.96p AD=2.96p
+ PS=18.96u PD=18.96u rfmode=0
M$823 \$1847 \$1847 VAPWR VAPWR sg13_hv_pmos L=0.5u W=14u AS=2.96p AD=2.96p
+ PS=18.96u PD=18.96u rfmode=0
M$830 VGND VGND VGND VGND sg13_hv_nmos L=4u W=8u AS=2.72p AD=2.72p PS=18.72u
+ PD=18.72u rfmode=0
M$831 q0 \$429 VGND VGND sg13_hv_nmos L=4u W=2u AS=0.68p AD=0.68p PS=4.68u
+ PD=4.68u rfmode=0
M$832 q0 q0 q0 VGND sg13_hv_nmos L=4u W=2u AS=0.68p AD=0.68p PS=4.68u PD=4.68u
+ rfmode=0
M$834 q2 \$2003 VGND VGND sg13_hv_nmos L=4u W=2u AS=0.68p AD=0.68p PS=4.68u
+ PD=4.68u rfmode=0
M$835 q2 q2 q2 VGND sg13_hv_nmos L=4u W=2u AS=0.68p AD=0.68p PS=4.68u PD=4.68u
+ rfmode=0
M$836 \$1839 \$1839 \$1839 VGND sg13_hv_nmos L=4u W=2u AS=0.68p AD=0.68p
+ PS=4.68u PD=4.68u rfmode=0
M$837 \$2003 \$1921 \$1839 VGND sg13_hv_nmos L=4u W=2u AS=0.68p AD=0.68p
+ PS=4.68u PD=4.68u rfmode=0
M$838 \$2003 \$2003 \$2003 VGND sg13_hv_nmos L=4u W=2u AS=0.68p AD=0.68p
+ PS=4.68u PD=4.68u rfmode=0
M$840 q2 \$2003 VPWR VPWR sg13_hv_pmos L=4u W=2u AS=0.68p AD=0.68p PS=4.68u
+ PD=4.68u rfmode=0
M$841 q2 q2 q2 VPWR sg13_hv_pmos L=4u W=2u AS=0.68p AD=0.68p PS=4.68u PD=4.68u
+ rfmode=0
M$843 \$2003 \$1921 VAPWR VAPWR sg13_hv_pmos L=4u W=2u AS=0.68p AD=0.68p
+ PS=4.68u PD=4.68u rfmode=0
M$844 \$2003 \$2003 \$2003 VAPWR sg13_hv_pmos L=4u W=2u AS=0.68p AD=0.68p
+ PS=4.68u PD=4.68u rfmode=0
M$849 \$297 \$185 VAPWR VAPWR sg13_hv_pmos L=0.5u W=4u AS=1.36p AD=1.36p
+ PS=8.68u PD=8.68u rfmode=0
M$850 \$2783 \$2685 VAPWR VAPWR sg13_hv_pmos L=0.5u W=4u AS=1.36p AD=1.36p
+ PS=8.68u PD=8.68u rfmode=0
M$851 \$1333 \$1247 VAPWR VAPWR sg13_hv_pmos L=0.5u W=4u AS=1.36p AD=1.36p
+ PS=8.68u PD=8.68u rfmode=0
M$852 \$1924 \$1844 VAPWR VAPWR sg13_hv_pmos L=0.5u W=4u AS=1.36p AD=1.36p
+ PS=8.68u PD=8.68u rfmode=0
M$858 q1 \$1460 VGND VGND sg13_hv_nmos L=4u W=2u AS=0.68p AD=0.68p PS=4.68u
+ PD=4.68u rfmode=0
M$859 q1 q1 q1 VGND sg13_hv_nmos L=4u W=2u AS=0.68p AD=0.68p PS=4.68u PD=4.68u
+ rfmode=0
M$861 q3 \$2872 VGND VGND sg13_hv_nmos L=4u W=2u AS=0.68p AD=0.68p PS=4.68u
+ PD=4.68u rfmode=0
M$862 q3 q3 q3 VGND sg13_hv_nmos L=4u W=2u AS=0.68p AD=0.68p PS=4.68u PD=4.68u
+ rfmode=0
.ENDS ook_analog_system

.SUBCKT sg13cmos5l_or4_1 VDD VSS B D A C X
M$1 VSS D \$7 VSS sg13_lv_nmos L=0.13u W=0.55u AS=0.187p AD=0.1045p PS=1.78u
+ PD=0.93u rfmode=0
M$2 VSS C \$7 VSS sg13_lv_nmos L=0.13u W=0.55u AS=0.16755p AD=0.1045p PS=1.165u
+ PD=0.93u rfmode=0
M$3 VSS B \$7 VSS sg13_lv_nmos L=0.13u W=0.55u AS=0.16755p AD=0.1045p PS=1.165u
+ PD=0.93u rfmode=0
M$4 VSS A \$7 VSS sg13_lv_nmos L=0.13u W=0.55u AS=0.14135p AD=0.1045p PS=1.14u
+ PD=0.93u rfmode=0
M$5 VSS \$7 X VSS sg13_lv_nmos L=0.13u W=0.74u AS=0.14135p AD=0.2516p PS=1.14u
+ PD=2.16u rfmode=0
M$6 \$7 D \$11 VDD sg13_lv_pmos L=0.13u W=1u AS=0.34p AD=0.19p PS=2.68u
+ PD=1.38u rfmode=0
M$7 \$11 C \$10 VDD sg13_lv_pmos L=0.13u W=1u AS=0.19p AD=0.2925p PS=1.38u
+ PD=1.585u rfmode=0
M$8 \$10 B \$9 VDD sg13_lv_pmos L=0.13u W=1u AS=0.2925p AD=0.19p PS=1.585u
+ PD=1.38u rfmode=0
M$9 VDD A \$9 VDD sg13_lv_pmos L=0.13u W=1u AS=0.2144p AD=0.19p PS=1.52u
+ PD=1.38u rfmode=0
M$10 VDD \$7 X VDD sg13_lv_pmos L=0.13u W=1.12u AS=0.2144p AD=0.3808p PS=1.52u
+ PD=2.92u rfmode=0
.ENDS sg13cmos5l_or4_1

.SUBCKT sg13cmos5l_mux2_1 VSS X S A1 A0 VDD
M$1 VSS S \$2 VSS sg13_lv_nmos L=0.13u W=0.55u AS=0.18945p AD=0.187p PS=1.27u
+ PD=1.78u rfmode=0
M$2 VSS S \$8 VSS sg13_lv_nmos L=0.13u W=0.74u AS=0.18945p AD=0.13135p PS=1.27u
+ PD=1.095u rfmode=0
M$3 \$8 A1 \$3 VSS sg13_lv_nmos L=0.13u W=0.74u AS=0.13135p AD=0.1628p
+ PS=1.095u PD=1.18u rfmode=0
M$4 \$3 A0 \$9 VSS sg13_lv_nmos L=0.13u W=0.74u AS=0.1628p AD=0.3367p PS=1.18u
+ PD=1.65u rfmode=0
M$5 \$9 \$2 VSS VSS sg13_lv_nmos L=0.13u W=0.74u AS=0.3367p AD=0.148p PS=1.65u
+ PD=1.14u rfmode=0
M$6 VSS \$3 X VSS sg13_lv_nmos L=0.13u W=0.74u AS=0.148p AD=0.4033p PS=1.14u
+ PD=2.57u rfmode=0
M$7 \$2 S VDD VDD sg13_lv_pmos L=0.13u W=0.84u AS=0.2856p AD=0.253p PS=2.36u
+ PD=1.53u rfmode=0
M$8 VDD S \$10 VDD sg13_lv_pmos L=0.13u W=1u AS=0.253p AD=0.3325p PS=1.53u
+ PD=1.665u rfmode=0
M$9 \$10 A0 \$3 VDD sg13_lv_pmos L=0.13u W=1u AS=0.3325p AD=0.2225p PS=1.665u
+ PD=1.445u rfmode=0
M$10 \$3 A1 \$11 VDD sg13_lv_pmos L=0.13u W=1u AS=0.2225p AD=0.2975p PS=1.445u
+ PD=1.595u rfmode=0
M$11 \$11 \$2 VDD VDD sg13_lv_pmos L=0.13u W=1u AS=0.2975p AD=0.2198p PS=1.595u
+ PD=1.52u rfmode=0
M$12 VDD \$3 X VDD sg13_lv_pmos L=0.13u W=1.12u AS=0.2198p AD=0.6048p PS=1.52u
+ PD=3.32u rfmode=0
.ENDS sg13cmos5l_mux2_1

.SUBCKT sg13cmos5l_nand4_1 VDD A VSS Y B C D
M$1 VSS D \$10 VSS sg13_lv_nmos L=0.13u W=0.74u AS=0.2516p AD=0.1406p PS=2.16u
+ PD=1.12u rfmode=0
M$2 \$10 C \$9 VSS sg13_lv_nmos L=0.13u W=0.74u AS=0.1406p AD=0.1406p PS=1.12u
+ PD=1.12u rfmode=0
M$3 \$9 B \$8 VSS sg13_lv_nmos L=0.13u W=0.74u AS=0.1406p AD=0.1406p PS=1.12u
+ PD=1.12u rfmode=0
M$4 \$8 A Y VSS sg13_lv_nmos L=0.13u W=0.74u AS=0.1406p AD=0.2516p PS=1.12u
+ PD=2.16u rfmode=0
M$5 VDD D Y VDD sg13_lv_pmos L=0.13u W=1.12u AS=0.3808p AD=0.2128p PS=2.92u
+ PD=1.5u rfmode=0
M$6 Y C VDD VDD sg13_lv_pmos L=0.13u W=1.12u AS=0.2128p AD=0.2128p PS=1.5u
+ PD=1.5u rfmode=0
M$7 VDD B Y VDD sg13_lv_pmos L=0.13u W=1.12u AS=0.2128p AD=0.2128p PS=1.5u
+ PD=1.5u rfmode=0
M$8 Y A VDD VDD sg13_lv_pmos L=0.13u W=1.12u AS=0.2128p AD=0.3808p PS=1.5u
+ PD=2.92u rfmode=0
.ENDS sg13cmos5l_nand4_1

.SUBCKT sg13cmos5l_a22oi_1 Y VSS VDD A2 B2 B1 A1
M$1 VSS B1 \$10 VSS sg13_lv_nmos L=0.13u W=0.74u AS=0.2553p AD=0.13875p
+ PS=2.17u PD=1.115u rfmode=0
M$2 \$10 B2 Y VSS sg13_lv_nmos L=0.13u W=0.74u AS=0.13875p AD=0.2664p PS=1.115u
+ PD=1.46u rfmode=0
M$3 Y A1 \$9 VSS sg13_lv_nmos L=0.13u W=0.74u AS=0.2664p AD=0.0962p PS=1.46u
+ PD=1u rfmode=0
M$4 \$9 A2 VSS VSS sg13_lv_nmos L=0.13u W=0.74u AS=0.0962p AD=0.2516p PS=1u
+ PD=2.16u rfmode=0
M$5 VDD A1 \$5 VDD sg13_lv_pmos L=0.13u W=1.12u AS=0.3808p AD=0.2716p PS=2.92u
+ PD=1.605u rfmode=0
M$6 \$5 B1 Y VDD sg13_lv_pmos L=0.13u W=1.12u AS=0.2716p AD=0.2128p PS=1.605u
+ PD=1.5u rfmode=0
M$7 Y B2 \$5 VDD sg13_lv_pmos L=0.13u W=1.12u AS=0.2128p AD=0.2744p PS=1.5u
+ PD=1.61u rfmode=0
M$8 \$5 A2 VDD VDD sg13_lv_pmos L=0.13u W=1.12u AS=0.2744p AD=0.3808p PS=1.61u
+ PD=2.92u rfmode=0
.ENDS sg13cmos5l_a22oi_1

.SUBCKT sg13cmos5l_buf_8 VSS A X VDD
M$1 \$2 A VSS VSS sg13_lv_nmos L=0.13u W=2.22u AS=0.5365p AD=0.4218p PS=4.41u
+ PD=3.36u rfmode=0
M$4 VSS \$2 X VSS sg13_lv_nmos L=0.13u W=5.92u AS=1.1248p AD=1.2358p PS=8.96u
+ PD=10u rfmode=0
M$12 \$2 A VDD VDD sg13_lv_pmos L=0.13u W=3.36u AS=0.8064p AD=0.6384p PS=5.92u
+ PD=4.5u rfmode=0
M$15 VDD \$2 X VDD sg13_lv_pmos L=0.13u W=8.96u AS=1.7024p AD=1.876p PS=12u
+ PD=13.43u rfmode=0
.ENDS sg13cmos5l_buf_8

.SUBCKT sg13cmos5l_nand3_1 VSS VDD Y B C A
M$1 VSS C \$8 VSS sg13_lv_nmos L=0.13u W=0.74u AS=0.2886p AD=0.1406p PS=2.26u
+ PD=1.12u rfmode=0
M$2 \$8 B \$7 VSS sg13_lv_nmos L=0.13u W=0.74u AS=0.1406p AD=0.1406p PS=1.12u
+ PD=1.12u rfmode=0
M$3 \$7 A Y VSS sg13_lv_nmos L=0.13u W=0.74u AS=0.1406p AD=0.2516p PS=1.12u
+ PD=2.16u rfmode=0
M$4 VDD C Y VDD sg13_lv_pmos L=0.13u W=1.12u AS=0.3808p AD=0.2128p PS=2.92u
+ PD=1.5u rfmode=0
M$5 Y B VDD VDD sg13_lv_pmos L=0.13u W=1.12u AS=0.2128p AD=0.2128p PS=1.5u
+ PD=1.5u rfmode=0
M$6 VDD A Y VDD sg13_lv_pmos L=0.13u W=1.12u AS=0.2128p AD=0.3808p PS=1.5u
+ PD=2.92u rfmode=0
.ENDS sg13cmos5l_nand3_1

.SUBCKT sg13cmos5l_or3_1 VDD VSS C A B X
M$1 \$6 C VSS VSS sg13_lv_nmos L=0.13u W=0.55u AS=0.187p AD=0.1045p PS=1.78u
+ PD=0.93u rfmode=0
M$2 VSS B \$6 VSS sg13_lv_nmos L=0.13u W=0.55u AS=0.1045p AD=0.198p PS=0.93u
+ PD=1.27u rfmode=0
M$3 \$6 A VSS VSS sg13_lv_nmos L=0.13u W=0.55u AS=0.198p AD=0.13395p PS=1.27u
+ PD=1.12u rfmode=0
M$4 VSS \$6 X VSS sg13_lv_nmos L=0.13u W=0.74u AS=0.13395p AD=0.2516p PS=1.12u
+ PD=2.16u rfmode=0
M$5 \$6 C \$9 VDD sg13_lv_pmos L=0.13u W=1u AS=0.34p AD=0.19p PS=2.68u PD=1.38u
+ rfmode=0
M$6 \$9 B \$8 VDD sg13_lv_pmos L=0.13u W=1u AS=0.19p AD=0.1575p PS=1.38u
+ PD=1.315u rfmode=0
M$7 \$8 A VDD VDD sg13_lv_pmos L=0.13u W=1u AS=0.1575p AD=0.3822p PS=1.315u
+ PD=1.84u rfmode=0
M$8 VDD \$6 X VDD sg13_lv_pmos L=0.13u W=1.12u AS=0.3822p AD=0.3808p PS=1.84u
+ PD=2.92u rfmode=0
.ENDS sg13cmos5l_or3_1

.SUBCKT sg13cmos5l_nor4_1 VDD VSS B A C D Y
M$1 VSS A Y VSS sg13_lv_nmos L=0.13u W=0.74u AS=0.2516p AD=0.1406p PS=2.16u
+ PD=1.12u rfmode=0
M$2 Y B VSS VSS sg13_lv_nmos L=0.13u W=0.74u AS=0.1406p AD=0.1406p PS=1.12u
+ PD=1.12u rfmode=0
M$3 VSS C Y VSS sg13_lv_nmos L=0.13u W=0.74u AS=0.1406p AD=0.1406p PS=1.12u
+ PD=1.12u rfmode=0
M$4 Y D VSS VSS sg13_lv_nmos L=0.13u W=0.74u AS=0.1406p AD=0.237575p PS=1.12u
+ PD=2.16u rfmode=0
M$5 VDD A \$9 VDD sg13_lv_pmos L=0.13u W=1.12u AS=0.3808p AD=0.2128p PS=2.92u
+ PD=1.5u rfmode=0
M$6 \$9 B \$8 VDD sg13_lv_pmos L=0.13u W=1.12u AS=0.2128p AD=0.2128p PS=1.5u
+ PD=1.5u rfmode=0
M$7 \$8 C \$10 VDD sg13_lv_pmos L=0.13u W=1.12u AS=0.2128p AD=0.2128p PS=1.5u
+ PD=1.5u rfmode=0
M$8 \$10 D Y VDD sg13_lv_pmos L=0.13u W=1.12u AS=0.2128p AD=0.4368p PS=1.5u
+ PD=3.02u rfmode=0
.ENDS sg13cmos5l_nor4_1

.SUBCKT sg13cmos5l_decap_4 VDD VSS
M$1 VSS VDD VSS VSS sg13_lv_nmos L=1u W=0.42u AS=0.1428p AD=0.1428p PS=1.52u
+ PD=1.52u rfmode=0
M$2 VDD VSS VDD VDD sg13_lv_pmos L=1u W=1u AS=0.34p AD=0.34p PS=2.68u PD=2.68u
+ rfmode=0
.ENDS sg13cmos5l_decap_4

.SUBCKT sg13cmos5l_nor2b_1 VSS VDD Y A B_N
M$1 VSS B_N \$5 VSS sg13_lv_nmos L=0.13u W=0.55u AS=0.17255p AD=0.187p PS=1.25u
+ PD=1.78u rfmode=0
M$2 VSS \$5 Y VSS sg13_lv_nmos L=0.13u W=0.74u AS=0.17255p AD=0.1406p PS=1.25u
+ PD=1.12u rfmode=0
M$3 Y A VSS VSS sg13_lv_nmos L=0.13u W=0.74u AS=0.1406p AD=0.2516p PS=1.12u
+ PD=2.16u rfmode=0
M$4 \$5 B_N VDD VDD sg13_lv_pmos L=0.13u W=0.84u AS=0.2856p AD=0.2618p PS=2.36u
+ PD=1.63u rfmode=0
M$5 VDD \$5 \$7 VDD sg13_lv_pmos L=0.13u W=1.12u AS=0.2618p AD=0.1176p PS=1.63u
+ PD=1.33u rfmode=0
M$6 \$7 A Y VDD sg13_lv_pmos L=0.13u W=1.12u AS=0.1176p AD=0.3808p PS=1.33u
+ PD=2.92u rfmode=0
.ENDS sg13cmos5l_nor2b_1

.SUBCKT sg13cmos5l_and2_1 VDD VSS X A B
M$1 \$4 A \$7 VSS sg13_lv_nmos L=0.13u W=0.64u AS=0.2176p AD=0.1216p PS=1.96u
+ PD=1.02u rfmode=0
M$2 VSS B \$7 VSS sg13_lv_nmos L=0.13u W=0.64u AS=0.1331p AD=0.1216p PS=1.12u
+ PD=1.02u rfmode=0
M$3 VSS \$4 X VSS sg13_lv_nmos L=0.13u W=0.74u AS=0.1331p AD=0.2516p PS=1.12u
+ PD=2.16u rfmode=0
M$4 VDD A \$4 VDD sg13_lv_pmos L=0.13u W=0.84u AS=0.2856p AD=0.1596p PS=2.36u
+ PD=1.22u rfmode=0
M$5 VDD B \$4 VDD sg13_lv_pmos L=0.13u W=0.84u AS=0.1918p AD=0.1596p PS=1.5u
+ PD=1.22u rfmode=0
M$6 VDD \$4 X VDD sg13_lv_pmos L=0.13u W=1.12u AS=0.1918p AD=0.3808p PS=1.5u
+ PD=2.92u rfmode=0
.ENDS sg13cmos5l_and2_1

.SUBCKT sg13cmos5l_or2_1 A X B VDD VSS
M$1 VSS B \$6 VSS sg13_lv_nmos L=0.13u W=0.55u AS=0.187p AD=0.1045p PS=1.78u
+ PD=0.93u rfmode=0
M$2 \$6 A VSS VSS sg13_lv_nmos L=0.13u W=0.55u AS=0.1045p AD=0.1469p PS=0.93u
+ PD=1.155u rfmode=0
M$3 VSS \$6 X VSS sg13_lv_nmos L=0.13u W=0.74u AS=0.1469p AD=0.2516p PS=1.155u
+ PD=2.16u rfmode=0
M$4 \$6 B \$7 VDD sg13_lv_pmos L=0.13u W=0.84u AS=0.2856p AD=0.1596p PS=2.36u
+ PD=1.22u rfmode=0
M$5 VDD A \$7 VDD sg13_lv_pmos L=0.13u W=0.84u AS=0.2226p AD=0.1596p PS=1.535u
+ PD=1.22u rfmode=0
M$6 VDD \$6 X VDD sg13_lv_pmos L=0.13u W=1.12u AS=0.2226p AD=0.3976p PS=1.535u
+ PD=2.95u rfmode=0
.ENDS sg13cmos5l_or2_1

.SUBCKT sg13cmos5l_nand2_1 VDD VSS Y A B
M$1 VSS B \$6 VSS sg13_lv_nmos L=0.13u W=0.74u AS=0.2516p AD=0.1406p PS=2.16u
+ PD=1.12u rfmode=0
M$2 \$6 A Y VSS sg13_lv_nmos L=0.13u W=0.74u AS=0.1406p AD=0.2516p PS=1.12u
+ PD=2.16u rfmode=0
M$3 VDD B Y VDD sg13_lv_pmos L=0.13u W=1.12u AS=0.3808p AD=0.2128p PS=2.92u
+ PD=1.5u rfmode=0
M$4 Y A VDD VDD sg13_lv_pmos L=0.13u W=1.12u AS=0.2128p AD=0.3808p PS=1.5u
+ PD=2.92u rfmode=0
.ENDS sg13cmos5l_nand2_1

.SUBCKT sg13cmos5l_decap_8 VDD VSS
M$1 VSS VDD VSS VSS sg13_lv_nmos L=1u W=0.84u AS=0.2226p AD=0.2226p PS=2.32u
+ PD=2.32u rfmode=0
M$3 VDD VSS VDD VDD sg13_lv_pmos L=1u W=2u AS=0.53p AD=0.53p PS=4.06u PD=4.06u
+ rfmode=0
.ENDS sg13cmos5l_decap_8

.SUBCKT sg13cmos5l_a221oi_1 VSS B1 VDD Y B2 C1 A1 A2
M$1 Y A1 \$11 VSS sg13_lv_nmos L=0.13u W=0.74u AS=0.2516p AD=0.1406p PS=2.16u
+ PD=1.12u rfmode=0
M$2 \$11 A2 VSS VSS sg13_lv_nmos L=0.13u W=0.74u AS=0.1406p AD=0.2516p PS=1.12u
+ PD=2.16u rfmode=0
M$3 Y C1 VSS VSS sg13_lv_nmos L=0.13u W=0.74u AS=0.2516p AD=0.1406p PS=2.16u
+ PD=1.12u rfmode=0
M$4 VSS B2 \$12 VSS sg13_lv_nmos L=0.13u W=0.74u AS=0.1406p AD=0.1406p PS=1.12u
+ PD=1.12u rfmode=0
M$5 \$12 B1 Y VSS sg13_lv_nmos L=0.13u W=0.74u AS=0.1406p AD=0.2516p PS=1.12u
+ PD=2.16u rfmode=0
M$6 VDD A1 \$9 VDD sg13_lv_pmos L=0.13u W=1.12u AS=0.3808p AD=0.2128p PS=2.92u
+ PD=1.5u rfmode=0
M$7 \$9 A2 VDD VDD sg13_lv_pmos L=0.13u W=1.12u AS=0.2128p AD=0.3808p PS=1.5u
+ PD=2.92u rfmode=0
M$8 Y C1 \$6 VDD sg13_lv_pmos L=0.13u W=1.12u AS=0.3808p AD=0.2128p PS=2.92u
+ PD=1.5u rfmode=0
M$9 \$6 B2 \$9 VDD sg13_lv_pmos L=0.13u W=1.12u AS=0.2128p AD=0.2128p PS=1.5u
+ PD=1.5u rfmode=0
M$10 \$9 B1 \$6 VDD sg13_lv_pmos L=0.13u W=1.12u AS=0.2128p AD=0.3808p PS=1.5u
+ PD=2.92u rfmode=0
.ENDS sg13cmos5l_a221oi_1

.SUBCKT sg13cmos5l_xnor2_1 VDD VSS Y B A
M$1 VSS A \$9 VSS sg13_lv_nmos L=0.13u W=0.64u AS=0.2272p AD=0.0784p PS=1.99u
+ PD=0.885u rfmode=0
M$2 \$9 B \$7 VSS sg13_lv_nmos L=0.13u W=0.64u AS=0.0784p AD=0.2176p PS=0.885u
+ PD=1.96u rfmode=0
M$3 VSS A \$3 VSS sg13_lv_nmos L=0.13u W=0.74u AS=0.1898p AD=0.2516p PS=1.36u
+ PD=2.16u rfmode=0
M$4 VSS B \$3 VSS sg13_lv_nmos L=0.13u W=0.74u AS=0.1898p AD=0.1406p PS=1.36u
+ PD=1.12u rfmode=0
M$5 \$3 \$7 Y VSS sg13_lv_nmos L=0.13u W=0.74u AS=0.1406p AD=0.2516p PS=1.12u
+ PD=2.16u rfmode=0
M$6 VDD A \$7 VDD sg13_lv_pmos L=0.13u W=0.84u AS=0.4536p AD=0.1596p PS=2.76u
+ PD=1.22u rfmode=0
M$7 VDD B \$7 VDD sg13_lv_pmos L=0.13u W=0.84u AS=0.2891p AD=0.1596p PS=1.695u
+ PD=1.22u rfmode=0
M$8 VDD A \$8 VDD sg13_lv_pmos L=0.13u W=1.12u AS=0.2891p AD=0.1428p PS=1.695u
+ PD=1.375u rfmode=0
M$9 \$8 B Y VDD sg13_lv_pmos L=0.13u W=1.12u AS=0.1428p AD=0.2408p PS=1.375u
+ PD=1.55u rfmode=0
M$10 Y \$7 VDD VDD sg13_lv_pmos L=0.13u W=1.12u AS=0.2408p AD=0.3808p PS=1.55u
+ PD=2.92u rfmode=0
.ENDS sg13cmos5l_xnor2_1

.SUBCKT sg13cmos5l_nor3_1 VDD VSS C Y B A
M$1 VSS A Y VSS sg13_lv_nmos L=0.13u W=0.77u AS=0.2618p AD=0.1694p PS=2.22u
+ PD=1.21u rfmode=0
M$2 Y B VSS VSS sg13_lv_nmos L=0.13u W=0.77u AS=0.1694p AD=0.1463p PS=1.21u
+ PD=1.15u rfmode=0
M$3 VSS C Y VSS sg13_lv_nmos L=0.13u W=0.77u AS=0.1463p AD=0.2618p PS=1.15u
+ PD=2.22u rfmode=0
M$4 VDD A \$8 VDD sg13_lv_pmos L=0.13u W=1.12u AS=0.3808p AD=0.2464p PS=2.92u
+ PD=1.56u rfmode=0
M$5 \$8 B \$7 VDD sg13_lv_pmos L=0.13u W=1.12u AS=0.2464p AD=0.2128p PS=1.56u
+ PD=1.5u rfmode=0
M$6 \$7 C Y VDD sg13_lv_pmos L=0.13u W=1.12u AS=0.2128p AD=0.3808p PS=1.5u
+ PD=2.92u rfmode=0
.ENDS sg13cmos5l_nor3_1

.SUBCKT sg13cmos5l_dfrbpq_1 VSS RESET_B Q D CLK VDD
M$1 VSS \$4 \$19 VSS sg13_lv_nmos L=0.13u W=0.74u AS=0.317325p AD=0.2516p
+ PS=1.805u PD=2.16u rfmode=0
M$2 VSS CLK \$4 VSS sg13_lv_nmos L=0.13u W=0.74u AS=0.317325p AD=0.2516p
+ PS=1.805u PD=2.16u rfmode=0
M$3 \$14 \$4 \$7 VSS sg13_lv_nmos L=0.13u W=0.42u AS=0.12665p AD=0.1428p
+ PS=1.145u PD=1.52u rfmode=0
M$4 \$3 \$19 \$14 VSS sg13_lv_nmos L=0.13u W=0.74u AS=0.3473p AD=0.12665p
+ PS=2.71u PD=1.145u rfmode=0
M$5 \$5 D \$15 VSS sg13_lv_nmos L=0.13u W=0.42u AS=0.1428p AD=0.0609p PS=1.52u
+ PD=0.71u rfmode=0
M$6 \$15 RESET_B VSS VSS sg13_lv_nmos L=0.13u W=0.42u AS=0.0609p AD=0.1626p
+ PS=0.71u PD=1.415u rfmode=0
M$7 VSS \$12 \$3 VSS sg13_lv_nmos L=0.13u W=0.74u AS=0.1626p AD=0.2516p
+ PS=1.415u PD=2.16u rfmode=0
M$8 \$9 \$14 VSS VSS sg13_lv_nmos L=0.13u W=0.74u AS=0.2516p AD=0.1406p
+ PS=2.16u PD=1.12u rfmode=0
M$9 VSS \$9 Q VSS sg13_lv_nmos L=0.13u W=0.74u AS=0.1406p AD=0.2516p PS=1.12u
+ PD=2.16u rfmode=0
M$10 \$5 \$4 \$12 VSS sg13_lv_nmos L=0.13u W=0.42u AS=0.1296p AD=0.0798p
+ PS=1.52u PD=0.8u rfmode=0
M$11 \$12 \$19 \$6 VSS sg13_lv_nmos L=0.13u W=0.42u AS=0.0798p AD=0.2373p
+ PS=0.8u PD=1.97u rfmode=0
M$12 \$7 \$8 VSS VSS sg13_lv_nmos L=0.13u W=0.42u AS=0.1428p AD=0.0798p
+ PS=1.52u PD=0.8u rfmode=0
M$13 VSS RESET_B \$17 VSS sg13_lv_nmos L=0.13u W=0.42u AS=0.0798p AD=0.0378p
+ PS=0.8u PD=0.6u rfmode=0
M$14 \$17 \$14 \$8 VSS sg13_lv_nmos L=0.13u W=0.42u AS=0.0378p AD=0.1428p
+ PS=0.6u PD=1.52u rfmode=0
M$15 VSS RESET_B \$16 VSS sg13_lv_nmos L=0.13u W=0.42u AS=0.1701p AD=0.0378p
+ PS=1.65u PD=0.6u rfmode=0
M$16 \$16 \$3 \$6 VSS sg13_lv_nmos L=0.13u W=0.42u AS=0.0378p AD=0.1428p
+ PS=0.6u PD=1.52u rfmode=0
M$17 \$14 \$19 \$21 VDD sg13_lv_pmos L=0.13u W=0.42u AS=0.2048p AD=0.09345p
+ PS=1.63u PD=0.865u rfmode=0
M$18 \$21 \$8 VDD VDD sg13_lv_pmos L=0.13u W=0.42u AS=0.09345p AD=0.204p
+ PS=0.865u PD=1.835u rfmode=0
M$19 VDD RESET_B \$8 VDD sg13_lv_pmos L=0.13u W=0.42u AS=0.204p AD=0.0798p
+ PS=1.835u PD=0.8u rfmode=0
M$20 \$8 \$14 VDD VDD sg13_lv_pmos L=0.13u W=0.42u AS=0.0798p AD=0.4659p
+ PS=0.8u PD=3.65u rfmode=0
M$21 \$3 \$4 \$14 VDD sg13_lv_pmos L=0.13u W=1u AS=0.34p AD=0.2048p PS=2.68u
+ PD=1.63u rfmode=0
M$22 \$9 \$14 VDD VDD sg13_lv_pmos L=0.13u W=1.12u AS=0.3864p AD=0.2128p
+ PS=2.93u PD=1.5u rfmode=0
M$23 VDD \$9 Q VDD sg13_lv_pmos L=0.13u W=1.12u AS=0.2128p AD=0.3808p PS=1.5u
+ PD=2.92u rfmode=0
M$24 VDD D \$5 VDD sg13_lv_pmos L=0.13u W=0.42u AS=0.1428p AD=0.0798p PS=1.52u
+ PD=0.8u rfmode=0
M$25 VDD RESET_B \$5 VDD sg13_lv_pmos L=0.13u W=0.42u AS=0.3623875p AD=0.0798p
+ PS=2.605u PD=0.8u rfmode=0
M$26 VDD \$12 \$3 VDD sg13_lv_pmos L=0.13u W=1u AS=0.3623875p AD=0.34p
+ PS=2.605u PD=2.68u rfmode=0
M$27 \$19 \$4 VDD VDD sg13_lv_pmos L=0.13u W=1.12u AS=0.3864p AD=0.41165p
+ PS=2.93u PD=2.12u rfmode=0
M$28 VDD CLK \$4 VDD sg13_lv_pmos L=0.13u W=1.12u AS=0.41165p AD=0.4088p
+ PS=2.12u PD=2.97u rfmode=0
M$29 \$12 RESET_B VDD VDD sg13_lv_pmos L=0.13u W=0.42u AS=0.147p AD=0.1563p
+ PS=1.54u PD=1.22u rfmode=0
M$30 VDD \$3 \$20 VDD sg13_lv_pmos L=0.13u W=0.42u AS=0.1563p AD=0.063p
+ PS=1.22u PD=0.72u rfmode=0
M$31 \$20 \$4 \$12 VDD sg13_lv_pmos L=0.13u W=0.42u AS=0.063p AD=0.0798p
+ PS=0.72u PD=0.8u rfmode=0
M$32 \$12 \$19 \$5 VDD sg13_lv_pmos L=0.13u W=0.42u AS=0.0798p AD=0.1428p
+ PS=0.8u PD=1.52u rfmode=0
.ENDS sg13cmos5l_dfrbpq_1

.SUBCKT sg13cmos5l_o21ai_1 VSS Y VDD B1 A2 A1
M$1 \$2 A1 VSS VSS sg13_lv_nmos L=0.15u W=0.74u AS=0.2516p AD=0.1406p PS=2.16u
+ PD=1.12u rfmode=0
M$2 VSS A2 \$2 VSS sg13_lv_nmos L=0.15u W=0.74u AS=0.1406p AD=0.1406p PS=1.12u
+ PD=1.12u rfmode=0
M$3 \$2 B1 Y VSS sg13_lv_nmos L=0.15u W=0.74u AS=0.1406p AD=0.2516p PS=1.12u
+ PD=2.16u rfmode=0
M$4 VDD A1 \$8 VDD sg13_lv_pmos L=0.15u W=1.12u AS=0.3808p AD=0.2128p PS=2.92u
+ PD=1.5u rfmode=0
M$5 \$8 A2 Y VDD sg13_lv_pmos L=0.15u W=1.12u AS=0.2128p AD=0.2128p PS=1.5u
+ PD=1.5u rfmode=0
M$6 Y B1 VDD VDD sg13_lv_pmos L=0.15u W=1.12u AS=0.2128p AD=0.3808p PS=1.5u
+ PD=2.92u rfmode=0
.ENDS sg13cmos5l_o21ai_1

.SUBCKT sg13cmos5l_nand3b_1 VDD VSS Y B C A_N
M$1 VSS A_N \$6 VSS sg13_lv_nmos L=0.13u W=0.55u AS=0.18575p AD=0.187p PS=1.26u
+ PD=1.78u rfmode=0
M$2 VSS C \$9 VSS sg13_lv_nmos L=0.13u W=0.74u AS=0.18575p AD=0.1406p PS=1.26u
+ PD=1.12u rfmode=0
M$3 \$9 B \$8 VSS sg13_lv_nmos L=0.13u W=0.74u AS=0.1406p AD=0.1406p PS=1.12u
+ PD=1.12u rfmode=0
M$4 \$8 \$6 Y VSS sg13_lv_nmos L=0.13u W=0.74u AS=0.1406p AD=0.3404p PS=1.12u
+ PD=2.4u rfmode=0
M$5 \$6 A_N VDD VDD sg13_lv_pmos L=0.13u W=0.84u AS=0.2856p AD=0.2198p PS=2.36u
+ PD=1.53u rfmode=0
M$6 VDD C Y VDD sg13_lv_pmos L=0.13u W=1.12u AS=0.2198p AD=0.2128p PS=1.53u
+ PD=1.5u rfmode=0
M$7 Y B VDD VDD sg13_lv_pmos L=0.13u W=1.12u AS=0.2128p AD=0.2128p PS=1.5u
+ PD=1.5u rfmode=0
M$8 VDD \$6 Y VDD sg13_lv_pmos L=0.13u W=1.12u AS=0.2128p AD=0.3808p PS=1.5u
+ PD=2.92u rfmode=0
.ENDS sg13cmos5l_nand3b_1

.SUBCKT sg13cmos5l_inv_1 VDD VSS A Y
M$1 VSS A Y VSS sg13_lv_nmos L=0.13u W=0.74u AS=0.2516p AD=0.2516p PS=2.16u
+ PD=2.16u rfmode=0
M$2 VDD A Y VDD sg13_lv_pmos L=0.13u W=1.12u AS=0.3808p AD=0.3808p PS=2.92u
+ PD=2.92u rfmode=0
.ENDS sg13cmos5l_inv_1

.SUBCKT sg13cmos5l_nor2_1 VDD VSS B A Y
M$1 VSS A Y VSS sg13_lv_nmos L=0.13u W=0.74u AS=0.2516p AD=0.1406p PS=2.16u
+ PD=1.12u rfmode=0
M$2 Y B VSS VSS sg13_lv_nmos L=0.13u W=0.74u AS=0.1406p AD=0.2516p PS=1.12u
+ PD=2.16u rfmode=0
M$3 VDD A \$6 VDD sg13_lv_pmos L=0.13u W=1.12u AS=0.4032p AD=0.1176p PS=2.96u
+ PD=1.33u rfmode=0
M$4 \$6 B Y VDD sg13_lv_pmos L=0.13u W=1.12u AS=0.1176p AD=0.3808p PS=1.33u
+ PD=2.92u rfmode=0
.ENDS sg13cmos5l_nor2_1

.SUBCKT sg13cmos5l_dlygate4sd3_1 VDD VSS X A
M$1 VSS \$5 \$4 VSS sg13_lv_nmos L=0.5u W=0.42u AS=0.1426p AD=0.1428p PS=1.16u
+ PD=1.52u rfmode=0
M$2 VSS \$4 X VSS sg13_lv_nmos L=0.13u W=0.74u AS=0.1426p AD=0.2516p PS=1.16u
+ PD=2.16u rfmode=0
M$3 \$6 A VSS VSS sg13_lv_nmos L=0.13u W=0.42u AS=0.1428p AD=0.0798p PS=1.52u
+ PD=0.8u rfmode=0
M$4 VSS \$6 \$5 VSS sg13_lv_nmos L=0.5u W=0.42u AS=0.0798p AD=0.1428p PS=0.8u
+ PD=1.52u rfmode=0
M$5 \$4 \$5 VDD VDD sg13_lv_pmos L=0.5u W=1u AS=0.34p AD=0.2254p PS=2.68u
+ PD=1.53u rfmode=0
M$6 VDD \$4 X VDD sg13_lv_pmos L=0.13u W=1.12u AS=0.2254p AD=0.4256p PS=1.53u
+ PD=3u rfmode=0
M$7 VDD A \$6 VDD sg13_lv_pmos L=0.13u W=0.42u AS=0.1523p AD=0.1428p PS=1.38u
+ PD=1.52u rfmode=0
M$8 VDD \$6 \$5 VDD sg13_lv_pmos L=0.5u W=1u AS=0.1523p AD=0.34p PS=1.38u
+ PD=2.68u rfmode=0
.ENDS sg13cmos5l_dlygate4sd3_1

.SUBCKT sg13cmos5l_and3_1 VDD VSS A C B X
M$1 \$7 A \$9 VSS sg13_lv_nmos L=0.13u W=0.64u AS=0.2176p AD=0.1216p PS=1.96u
+ PD=1.02u rfmode=0
M$2 \$9 B \$8 VSS sg13_lv_nmos L=0.13u W=0.64u AS=0.1216p AD=0.1216p PS=1.02u
+ PD=1.02u rfmode=0
M$3 VSS C \$8 VSS sg13_lv_nmos L=0.13u W=0.64u AS=0.1371p AD=0.1216p PS=1.12u
+ PD=1.02u rfmode=0
M$4 VSS \$7 X VSS sg13_lv_nmos L=0.13u W=0.74u AS=0.1371p AD=0.2516p PS=1.12u
+ PD=2.16u rfmode=0
M$5 \$7 A VDD VDD sg13_lv_pmos L=0.13u W=0.84u AS=0.2856p AD=0.1596p PS=2.36u
+ PD=1.22u rfmode=0
M$6 VDD B \$7 VDD sg13_lv_pmos L=0.13u W=0.84u AS=0.1596p AD=0.1596p PS=1.22u
+ PD=1.22u rfmode=0
M$7 VDD C \$7 VDD sg13_lv_pmos L=0.13u W=0.84u AS=0.36195p AD=0.1596p PS=1.84u
+ PD=1.22u rfmode=0
M$8 VDD \$7 X VDD sg13_lv_pmos L=0.13u W=1.12u AS=0.36195p AD=0.3808p PS=1.84u
+ PD=2.92u rfmode=0
.ENDS sg13cmos5l_and3_1

.SUBCKT sg13cmos5l_a21oi_1 Y VSS A2 VDD A1 B1
M$1 VSS B1 Y VSS sg13_lv_nmos L=0.13u W=0.74u AS=0.2516p AD=0.1406p PS=2.16u
+ PD=1.12u rfmode=0
M$2 Y A1 \$8 VSS sg13_lv_nmos L=0.13u W=0.74u AS=0.1406p AD=0.1406p PS=1.12u
+ PD=1.12u rfmode=0
M$3 \$8 A2 VSS VSS sg13_lv_nmos L=0.13u W=0.74u AS=0.1406p AD=0.2516p PS=1.12u
+ PD=2.16u rfmode=0
M$4 Y B1 \$3 VDD sg13_lv_pmos L=0.13u W=1.12u AS=0.3808p AD=0.2128p PS=2.92u
+ PD=1.5u rfmode=0
M$5 \$3 A1 VDD VDD sg13_lv_pmos L=0.13u W=1.12u AS=0.2128p AD=0.2128p PS=1.5u
+ PD=1.5u rfmode=0
M$6 VDD A2 \$3 VDD sg13_lv_pmos L=0.13u W=1.12u AS=0.2128p AD=0.3808p PS=1.5u
+ PD=2.92u rfmode=0
.ENDS sg13cmos5l_a21oi_1

.SUBCKT sg13cmos5l_buf_1 VSS X VDD A
M$1 VSS A \$1 VSS sg13_lv_nmos L=0.13u W=0.55u AS=0.14875p AD=0.187p PS=1.16u
+ PD=1.78u rfmode=0
M$2 VSS \$1 X VSS sg13_lv_nmos L=0.13u W=0.74u AS=0.14875p AD=0.2886p PS=1.16u
+ PD=2.26u rfmode=0
M$3 VDD A \$1 VDD sg13_lv_pmos L=0.13u W=0.84u AS=0.2114p AD=0.2856p PS=1.54u
+ PD=2.36u rfmode=0
M$4 VDD \$1 X VDD sg13_lv_pmos L=0.13u W=1.12u AS=0.2114p AD=0.42p PS=1.54u
+ PD=2.99u rfmode=0
.ENDS sg13cmos5l_buf_1

.SUBCKT sg13cmos5l_a21o_1 VDD VSS X B1 A1 A2
M$1 X \$6 VSS VSS sg13_lv_nmos L=0.13u W=0.74u AS=0.2351p AD=0.15745p PS=2.16u
+ PD=1.175u rfmode=0
M$2 VSS B1 \$6 VSS sg13_lv_nmos L=0.13u W=0.64u AS=0.15745p AD=0.1216p
+ PS=1.175u PD=1.02u rfmode=0
M$3 \$6 A1 \$9 VSS sg13_lv_nmos L=0.13u W=0.64u AS=0.1216p AD=0.0816p PS=1.02u
+ PD=0.895u rfmode=0
M$4 \$9 A2 VSS VSS sg13_lv_nmos L=0.13u W=0.64u AS=0.0816p AD=0.2176p PS=0.895u
+ PD=1.96u rfmode=0
M$5 \$6 B1 \$5 VDD sg13_lv_pmos L=0.13u W=1u AS=0.35p AD=0.2125p PS=2.7u
+ PD=1.425u rfmode=0
M$6 \$5 A1 VDD VDD sg13_lv_pmos L=0.13u W=1u AS=0.2125p AD=0.19p PS=1.425u
+ PD=1.38u rfmode=0
M$7 VDD A2 \$5 VDD sg13_lv_pmos L=0.13u W=1u AS=0.19p AD=0.34p PS=1.38u
+ PD=2.68u rfmode=0
M$8 X \$6 VDD VDD sg13_lv_pmos L=0.13u W=1.12u AS=0.3808p AD=0.3808p PS=2.92u
+ PD=2.92u rfmode=0
.ENDS sg13cmos5l_a21o_1

.SUBCKT sg13cmos5l_nand2b_1 VDD VSS B A_N Y
M$1 VSS A_N \$6 VSS sg13_lv_nmos L=0.13u W=0.55u AS=0.14505p AD=0.187p PS=1.15u
+ PD=1.78u rfmode=0
M$2 VSS B \$7 VSS sg13_lv_nmos L=0.13u W=0.74u AS=0.14505p AD=0.1406p PS=1.15u
+ PD=1.12u rfmode=0
M$3 \$7 \$6 Y VSS sg13_lv_nmos L=0.13u W=0.74u AS=0.1406p AD=0.333p PS=1.12u
+ PD=2.38u rfmode=0
M$4 \$6 A_N VDD VDD sg13_lv_pmos L=0.13u W=0.84u AS=0.2856p AD=0.2198p PS=2.36u
+ PD=1.53u rfmode=0
M$5 VDD B Y VDD sg13_lv_pmos L=0.13u W=1.12u AS=0.2198p AD=0.2128p PS=1.53u
+ PD=1.5u rfmode=0
M$6 Y \$6 VDD VDD sg13_lv_pmos L=0.13u W=1.12u AS=0.2128p AD=0.3808p PS=1.5u
+ PD=2.92u rfmode=0
.ENDS sg13cmos5l_nand2b_1

.SUBCKT sg13cmos5l_xor2_1 VSS X VDD B A
M$1 VSS A \$1 VSS sg13_lv_nmos L=0.13u W=0.55u AS=0.374p AD=0.174625p PS=2.46u
+ PD=1.185u rfmode=0
M$2 VSS B \$1 VSS sg13_lv_nmos L=0.13u W=0.55u AS=0.15245p AD=0.174625p
+ PS=1.17u PD=1.185u rfmode=0
M$3 VSS A \$9 VSS sg13_lv_nmos L=0.13u W=0.74u AS=0.15245p AD=0.0888p PS=1.17u
+ PD=0.98u rfmode=0
M$4 \$9 B X VSS sg13_lv_nmos L=0.13u W=0.74u AS=0.0888p AD=0.1628p PS=0.98u
+ PD=1.18u rfmode=0
M$5 X \$1 VSS VSS sg13_lv_nmos L=0.13u W=0.74u AS=0.1628p AD=0.3108p PS=1.18u
+ PD=2.32u rfmode=0
M$6 \$3 A VDD VDD sg13_lv_pmos L=0.13u W=1.12u AS=0.3808p AD=0.2128p PS=2.92u
+ PD=1.5u rfmode=0
M$7 VDD B \$3 VDD sg13_lv_pmos L=0.13u W=1.12u AS=0.2128p AD=0.2128p PS=1.5u
+ PD=1.5u rfmode=0
M$8 \$3 \$1 X VDD sg13_lv_pmos L=0.13u W=1.12u AS=0.2128p AD=0.3808p PS=1.5u
+ PD=2.92u rfmode=0
M$9 VDD A \$8 VDD sg13_lv_pmos L=0.13u W=1u AS=0.36p AD=0.1225p PS=2.72u
+ PD=1.245u rfmode=0
M$10 \$8 B \$1 VDD sg13_lv_pmos L=0.13u W=1u AS=0.1225p AD=0.34p PS=1.245u
+ PD=2.68u rfmode=0
.ENDS sg13cmos5l_xor2_1
