** sch_path: /home/belal/HeiChips/heichips26-on-off/macros/heichips26_ook/macros/ook_analog_system/schematic/xschem/ook_receiver.sch
.subckt ook_receiver VDD1_5 opm q0 vref0 q1 vref1 ACC_CAP q2 vref2 vref3 q3 VDD3_3 Cap_M11 Cap_M21 Cap_M1 Cap_M2 vin VSS lnaf
*.PININFO VSS:B vin:I q3:B VDD3_3:B VDD1_5:B q2:B q1:B q0:B ACC_CAP:B Cap_M2:B Cap_M1:B Cap_M21:B Cap_M11:B vref3:B vref2:B
*+ vref1:B vref0:B opm:B lnaf:B
x2 VDD1_5 VDD3_3 ACC_CAP net2 vref0 VSS net3 vref1 net4 vref2 net5 vref3 simple_comparator_stage
x1 Cap_M2 Cap_M1 VDD3_3 lnaf vin VSS Cap_M21 Cap_M11 lna_stage
MM24 net1 net1 VDD3_3 VDD3_3 sg13_hv_pmos w=14u l=0.5u ng=7
MM25 opm net1 VDD3_3 VDD3_3 sg13_hv_pmos w=14u l=0.5u ng=7
RR5 net1 VSS 7.0188k $SUB=VSS $[rhigh] w=2e-6 l=10e-6 b=0 m=1 ps=0
MM13 VDD3_3 VDD3_3 VDD3_3 VDD3_3 sg13_hv_pmos w=2u l=0.5u ng=1
MM26 VDD3_3 VDD3_3 VDD3_3 VDD3_3 sg13_hv_pmos w=2u l=0.5u ng=1
MM27 opm opm opm VDD3_3 sg13_hv_pmos w=2u l=0.5u ng=1
MM28 net1 net1 net1 VDD3_3 sg13_hv_pmos w=2u l=0.5u ng=1
RR3 opm VSS 5.631k $SUB=VSS $[rhigh] w=2e-6 l=8e-6 b=0 m=1 ps=0
MM2 ACC_CAP ACC_CAP opm opm sg13_hv_pmos w=20u l=0.5u ng=10
.ends

* expanding   symbol:  simple_comparator_stage.sym # of pins=12
** sym_path: /home/belal/HeiChips/heichips26-on-off/macros/heichips26_ook/macros/ook_analog_system/schematic/xschem/simple_comparator_stage.sym
** sch_path: /home/belal/HeiChips/heichips26-on-off/macros/heichips26_ook/macros/ook_analog_system/schematic/xschem/simple_comparator_stage.sch
.subckt simple_comparator_stage VDD1_5 VDD3_3 vin q0 vref0 VSS q1 vref1 q2 vref2 q3 vref3
*.PININFO VDD3_3:B VSS:B VDD1_5:B vin:I q0:O vref3:I vref2:I vref1:I vref0:I q1:O q2:O q3:O
x2 VDD1_5 VSS VDD3_3 vref0 vin q0 simple_comparator
RR1 VDD3_3 vref3 20.064k $SUB=VSS $[rhigh] w=2e-6 l=28.8e-6 b=0
RR5 vref0 VSS 9.031k $SUB=VSS $[rhigh] w=2e-6 l=12.9e-6 b=0
x1 VDD1_5 VSS VDD3_3 vref1 vin q1 simple_comparator
x3 VDD1_5 VSS VDD3_3 vref2 vin q2 simple_comparator
x4 VDD1_5 VSS VDD3_3 vref3 vin q3 simple_comparator
RR4 vref1 vref0 2.0229k $SUB=VSS $[rhigh] w=2e-6 l=2.8e-6 b=0
RR3 vref2 vref1 1.0514k $SUB=VSS $[rhigh] w=2e-6 l=1.4e-6 b=0
RR2 vref3 vref2 1.0514k $SUB=VSS $[rhigh] w=2e-6 l=1.4e-6 b=0
.ends

* expanding   symbol:  lna_stage.sym # of pins=8
** sym_path: /home/belal/HeiChips/heichips26-on-off/macros/heichips26_ook/macros/ook_analog_system/schematic/xschem/lna_stage.sym
** sch_path: /home/belal/HeiChips/heichips26-on-off/macros/heichips26_ook/macros/ook_analog_system/schematic/xschem/lna_stage.sch
.subckt lna_stage Cap_M2 Cap_M1 VDD vout vin VSS Cap_M21 Cap_M11
*.PININFO vin:I VSS:B VDD:B Cap_M2:B Cap_M1:B vout:B Cap_M21:B Cap_M11:B
x2 VDD Cap_M1 vin VSS lna
x1 VDD Cap_M11 Cap_M2 VSS lna
x3 VDD vout Cap_M21 VSS lna
.ends

* expanding   symbol:  simple_comparator.sym # of pins=6
** sym_path: /home/belal/HeiChips/heichips26-on-off/macros/heichips26_ook/macros/ook_analog_system/schematic/xschem/simple_comparator.sym
** sch_path: /home/belal/HeiChips/heichips26-on-off/macros/heichips26_ook/macros/ook_analog_system/schematic/xschem/simple_comparator.sch
.subckt simple_comparator VDDL VSS VDD vref vin comp_out
*.PININFO vin:I vref:I VDD:B VSS:B comp_out:O VDDL:B
MMBIAS vbias vbias VDD VDD sg13_hv_pmos w=4u l=0.5u ng=1
RRBIAS vbias VSS 126.92k $SUB=VSS $[rhigh] w=2e-6 l=9.27e-6 b=15 m=1 ps=0.18e-6
MM3P net4 vbias VDD VDD sg13_hv_pmos w=4u l=0.5u ng=1
MM1P outn vin net4 VDD sg13_hv_pmos w=4u l=0.5u ng=1 m=4
MM2P net1 vref net4 VDD sg13_hv_pmos w=4u l=0.5u ng=1 m=4
MM4N outn outn VSS VSS sg13_hv_nmos w=2u l=0.5u ng=1 m=4
MM5N net1 outn VSS VSS sg13_hv_nmos w=2u l=0.5u ng=1 m=4
MMP1 net2 net1 VDD VDD sg13_hv_pmos w=2u l=4u ng=1
MMN1 net2 net1 net3 VSS sg13_hv_nmos w=2u l=4u ng=1
MMP2 comp_out net2 VDDL VDDL sg13_hv_pmos w=2u l=4u ng=1
MMBIAS1 vbias vbias vbias VDD sg13_hv_pmos w=4u l=0.5u ng=1
MMBIAS2 VDD VDD VDD VDD sg13_hv_pmos w=4u l=0.5u ng=1
MM1 VDD VDD VDD VDD sg13_hv_pmos w=4u l=0.5u ng=1
MM2 net4 net4 net4 VDD sg13_hv_pmos w=4u l=0.5u ng=1
MMP3 net2 net2 net2 VDD sg13_hv_pmos w=2u l=4u ng=1
MMP4 VDD VDD VDD VDD sg13_hv_pmos w=2u l=4u ng=1
MMP5 VDDL VDDL VDDL VDDL sg13_hv_pmos w=2u l=4u ng=1
MMP6 comp_out comp_out comp_out VDDL sg13_hv_pmos w=2u l=4u ng=1
MMN3 comp_out comp_out comp_out VSS sg13_hv_nmos w=2u l=4u ng=1
MMN4 VSS VSS VSS VSS sg13_hv_nmos w=2u l=4u ng=1
MMN5 net2 net2 net2 VSS sg13_hv_nmos w=2u l=4u ng=1
MMN6 net3 net3 net3 VSS sg13_hv_nmos w=2u l=4u ng=1
MM3 net4 net4 net4 VDD sg13_hv_pmos w=4u l=0.5u ng=1
MM4 outn outn outn VDD sg13_hv_pmos w=4u l=0.5u ng=1
MM5 net1 net1 net1 VSS sg13_hv_nmos w=2u l=0.5u ng=1
MM6 VSS VSS VSS VSS sg13_hv_nmos w=2u l=0.5u ng=1
MM7 net4 net4 net4 VDD sg13_hv_pmos w=4u l=0.5u ng=1
MM8 net1 net1 net1 VDD sg13_hv_pmos w=4u l=0.5u ng=1
MM9 outn outn outn VSS sg13_hv_nmos w=2u l=0.5u ng=1
MM10 VSS VSS VSS VSS sg13_hv_nmos w=2u l=0.5u ng=1
RRBIAS1 net3 VSS 98.458k $SUB=VSS $[rhigh] w=2e-6 l=13.71e-6 b=8 m=1 ps=0.18e-6
MMN8 comp_out net2 VSS VSS sg13_hv_nmos w=2u l=4u ng=1
.ends

* expanding   symbol:  lna.sym # of pins=4
** sym_path: /home/belal/HeiChips/heichips26-on-off/macros/heichips26_ook/macros/ook_analog_system/schematic/xschem/lna.sym
** sch_path: /home/belal/HeiChips/heichips26-on-off/macros/heichips26_ook/macros/ook_analog_system/schematic/xschem/lna.sch
.subckt lna VDD vout vin VSS
*.PININFO VDD:B VSS:B vin:I vout:B
MM14 vout VDD net6 VSS sg13_hv_nmos w=2.0u l=0.5u ng=2
MM15 net6 vin VSS VSS sg13_hv_nmos w=18.0u l=0.5u ng=18
MM16 net1 net1 VSS VSS sg13_hv_nmos w=2.00u l=0.5u ng=2
MM17 isource1 vout VSS VSS sg13_hv_nmos w=0.5u l=0.5u ng=1
MM18 VDD isource1 isink1 VSS sg13_hv_nmos w=1.5u l=0.5u ng=1
MM19 VSS isink1 vout VDD sg13_hv_pmos w=0.7u l=0.5u ng=1
MM20 net2 net2 VSS VSS sg13_hv_nmos w=10.0u l=0.5u ng=5
MM21 isink1 net2 VSS VSS sg13_hv_nmos w=10.0u l=0.5u ng=5
MM22 net3 net3 VDD VDD sg13_hv_pmos w=14u l=0.5u ng=7
MM23 isource1 net3 VDD VDD sg13_hv_pmos w=14u l=0.5u ng=7
MM24 net4 net4 VDD VDD sg13_hv_pmos w=14u l=0.5u ng=7
MM25 vout net4 VDD VDD sg13_hv_pmos w=14u l=0.5u ng=7
RR2 net1 vin 32.509k $SUB=VSS $[rhigh] w=2.0e-6 l=9.96e-6 b=3 m=1 ps=0.18e-6
RR5 net4 VSS 13.574k $SUB=VSS $[rhigh] w=2e-6 l=4.95e-6 b=2 m=1 ps=0.18e-6
RR1 VDD net1 153.18k $SUB=VSS $[rhigh] w=2e-6 l=19.995e-6 b=9 m=1 ps=0.18e-6
RR6 VDD net2 153.18k $SUB=VSS $[rhigh] w=2.0e-6 l=19.995e-6 b=9 m=1 ps=0.18e-6
MM2 net5 net5 VSS VSS sg13_hv_nmos w=0.5u l=0.5u ng=1
MM3 vout net5 VSS VSS sg13_hv_nmos w=0.5u l=0.5u ng=1
RR4 net3 VSS 13.574k $SUB=VSS $[rhigh] w=2e-6 l=4.95e-6 b=2 m=1 ps=0.18e-6
RR13 VDD net5 189.44k $SUB=VSS $[rhigh] w=2e-6 l=22.72e-6 b=10 m=1 ps=0.18e-6
MM1 VSS VSS VSS VDD sg13_hv_pmos w=0.7u l=0.5u ng=1
MM4 vout vout vout VDD sg13_hv_pmos w=0.7u l=0.5u ng=1
MM5 VSS VSS VSS VSS sg13_hv_nmos w=0.5u l=0.5u ng=1
MM6 isource1 isource1 isource1 VSS sg13_hv_nmos w=0.5u l=0.5u ng=1
MM7 isink1 isink1 isink1 VSS sg13_hv_nmos w=1.5u l=0.5u ng=1
MM8 VDD VDD VDD VSS sg13_hv_nmos w=1.5u l=0.5u ng=1
MM9 isource1 isource1 isource1 VDD sg13_hv_pmos w=2u l=0.5u ng=1
MM10 VDD VDD VDD VDD sg13_hv_pmos w=2u l=0.5u ng=1
MM11 VDD VDD VDD VDD sg13_hv_pmos w=2u l=0.5u ng=1
MM12 net3 net3 net3 VDD sg13_hv_pmos w=2u l=0.5u ng=1
MM13 VDD VDD VDD VDD sg13_hv_pmos w=2u l=0.5u ng=1
MM26 VDD VDD VDD VDD sg13_hv_pmos w=2u l=0.5u ng=1
MM27 vout vout vout VDD sg13_hv_pmos w=2u l=0.5u ng=1
MM28 net4 net4 net4 VDD sg13_hv_pmos w=2u l=0.5u ng=1
MM29 isink1 isink1 isink1 VSS sg13_hv_nmos w=2.0u l=0.5u ng=1
MM30 VSS VSS VSS VSS sg13_hv_nmos w=2.0u l=0.5u ng=1
MM31 net2 net2 net2 VSS sg13_hv_nmos w=2.0u l=0.5u ng=1
MM32 VSS VSS VSS VSS sg13_hv_nmos w=2.0u l=0.5u ng=1
MM33 vout vout vout VSS sg13_hv_nmos w=0.5u l=0.5u ng=1
MM34 VSS VSS VSS VSS sg13_hv_nmos w=0.5u l=0.5u ng=1
MM35 net5 net5 net5 VSS sg13_hv_nmos w=0.5u l=0.5u ng=1
MM36 VSS VSS VSS VSS sg13_hv_nmos w=0.5u l=0.5u ng=1
MM37 vout vout vout VSS sg13_hv_nmos w=1.0u l=0.5u ng=1
MM38 net6 net6 net6 VSS sg13_hv_nmos w=1.0u l=0.5u ng=1
MM39 net6 net6 net6 VSS sg13_hv_nmos w=1.0u l=0.5u ng=1
MM40 VSS VSS VSS VSS sg13_hv_nmos w=1.0u l=0.5u ng=1
MM41 net1 net1 net1 VSS sg13_hv_nmos w=1.00u l=0.5u ng=1
MM42 VSS VSS VSS VSS sg13_hv_nmos w=1.00u l=0.5u ng=1
.ends
