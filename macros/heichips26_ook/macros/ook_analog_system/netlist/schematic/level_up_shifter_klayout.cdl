** sch_path: /home/belal/HeiChips/heichips26-on-off/macros/heichips26_ook/macros/ook_analog_system/schematic/xschem/level_up_shifter.sch
.subckt level_up_shifter VDD2 A B VSS VDD1
*.PININFO VSS:B VDD2:B B:O A:I VDD1:B
MM1 net1 AB VSS VSS sg13_hv_nmos w=10u l=0.5u ng=1
MM4 T net1 VDD2 VDD2 sg13_hv_pmos w=1u l=0.5u ng=1
MM3 net1 T VDD2 VDD2 sg13_hv_pmos w=1u l=0.5u ng=1
MM2 T AM VSS VSS sg13_hv_nmos w=10u l=0.5u ng=1
MM5 B T VDD2 VDD2 sg13_hv_pmos w=3u l=0.5u ng=1
MM6 B T VSS VSS sg13_hv_nmos w=1u l=0.5u ng=1
MM7 VSS VSS VSS VSS sg13_hv_nmos w=1u l=0.5u ng=1
MM8 VDD2 VDD2 VDD2 VDD2 sg13_hv_pmos w=3u l=0.5u ng=1
MM9 VDD1 VDD1 VDD1 VDD1 sg13_lv_pmos w=1u l=0.13u ng=1
MM12 AB A VDD1 VDD1 sg13_lv_pmos w=1u l=0.13u ng=1
MM10 VSS VSS VSS VSS sg13_lv_nmos w=1u l=0.13u ng=1
MM11 VDD1 VDD1 VDD1 VDD1 sg13_lv_pmos w=1u l=0.13u ng=1
MM14 AM AB VDD1 VDD1 sg13_lv_pmos w=1u l=0.13u ng=1
MM15 VSS VSS VSS VSS sg13_lv_nmos w=1u l=0.13u ng=1
MM17 AB A VSS VSS sg13_lv_nmos w=1u l=0.13u ng=1
MM13 AM AB VSS VSS sg13_lv_nmos w=1u l=0.13u ng=1
MM16 AB AB AB VSS sg13_lv_nmos w=1u l=0.13u ng=1
MM18 AB AB AB VDD1 sg13_lv_pmos w=1u l=0.13u ng=1
MM19 AM AM AM VDD1 sg13_lv_pmos w=1u l=0.13u ng=1
MM20 AM AM AM VSS sg13_lv_nmos w=1u l=0.13u ng=1
MM21 B B B VDD2 sg13_hv_pmos w=3u l=0.5u ng=1
MM22 B B B VSS sg13_hv_nmos w=1u l=0.5u ng=1
.ends
