** sch_path: /home/belal/HeiChips/heichips26-on-off/macros/heichips26_ook/macros/ook_analog_system/schematic/xschem/ook_analog_system.sch
.subckt ook_analog_system VAPWR vcl VPWR q3 q2 tx_out rx_in q1 q0 vctrl_in vctrl_b_out vctrl_b_in vctrl_out ACC_CAP Cap_M2 Cap_M1
+ Cap_M21 Cap_M11 vref0 clk_ref vref1 clk_fb rst_ni dac_out VGND vref2 vref3 opm lnaf
*.PININFO tx_out:B VPWR:B VGND:B vcl:B dac_out:B clk_fb:B clk_ref:B rst_ni:B vctrl_in:B vctrl_b_in:B vctrl_out:B vctrl_b_out:B
*+ q0:B q1:B q2:B q3:B ACC_CAP:B rx_in:B VAPWR:B Cap_M2:B Cap_M1:B Cap_M21:B Cap_M11:B vref0:B vref1:B vref3:B vref2:B opm:B lnaf:B
x1 VPWR opm q0 vref0 q1 vref1 ACC_CAP q2 vref2 vref3 q3 VAPWR Cap_M11 Cap_M21 Cap_M1 Cap_M2 rx_in VGND lnaf ook_receiver
x2 clk_ref rst_ni vctrl_in vctrl_b_in dac_out clk_fb vcl VGND VPWR tx_out vctrl_out vctrl_b_out ook_transmitter
.ends

* expanding   symbol:  ook_receiver.sym # of pins=19
** sym_path: /home/belal/HeiChips/heichips26-on-off/macros/heichips26_ook/macros/ook_analog_system/schematic/xschem/ook_receiver.sym
** sch_path: /home/belal/HeiChips/heichips26-on-off/macros/heichips26_ook/macros/ook_analog_system/schematic/xschem/ook_receiver.sch
.subckt ook_receiver VDD1_5 opm q0 vref0 q1 vref1 ACC_CAP q2 vref2 vref3 q3 VDD3_3 Cap_M11 Cap_M21 Cap_M1 Cap_M2 vin VSS lnaf
*.PININFO VSS:B vin:I q3:B VDD3_3:B VDD1_5:B q2:B q1:B q0:B ACC_CAP:B Cap_M2:B Cap_M1:B Cap_M21:B Cap_M11:B vref3:B vref2:B
*+ vref1:B vref0:B opm:B lnaf:B
x2 VDD1_5 VDD3_3 ACC_CAP q0 vref0 VSS q1 vref1 q2 vref2 q3 vref3 simple_comparator_stage
x1 Cap_M2 Cap_M1 VDD3_3 lnaf vin VSS Cap_M21 Cap_M11 lna_stage
MM24 net1 net1 VDD3_3 VDD3_3 sg13_hv_pmos w=14u l=0.5u ng=7
MM25 opm net1 VDD3_3 VDD3_3 sg13_hv_pmos w=14u l=0.5u ng=7
RR5 net1 VSS 7.0188k $SUB=VSS $[rhigh] w=2e-6 l=10e-6 b=0 m=1 ps=0
MM13 VDD3_3 VDD3_3 VDD3_3 VDD3_3 sg13_hv_pmos w=2u l=0.5u ng=1
MM26 VDD3_3 VDD3_3 VDD3_3 VDD3_3 sg13_hv_pmos w=2u l=0.5u ng=1
MM27 opm opm opm VDD3_3 sg13_hv_pmos w=2u l=0.5u ng=1
MM28 net1 net1 net1 VDD3_3 sg13_hv_pmos w=2u l=0.5u ng=1
RR3 opm VSS 5.631k $SUB=VSS $[rhigh] w=2e-6 l=8e-6 b=0 m=1 ps=0
MM2 ACC_CAP ACC_CAP opm opm sg13_hv_pmos w=20u l=0.5u ng=10
.ends

* expanding   symbol:  ook_transmitter.sym # of pins=12
** sym_path: /home/belal/HeiChips/heichips26-on-off/macros/heichips26_ook/macros/ook_analog_system/schematic/xschem/ook_transmitter.sym
** sch_path: /home/belal/HeiChips/heichips26-on-off/macros/heichips26_ook/macros/ook_analog_system/schematic/xschem/ook_transmitter.sch
.subckt ook_transmitter clk_ref rst_ni vctrl_in vctrl_b_in dac_out clk_fb vcl VGND VPWR vout vctrl_out vctrl_b_out
*.PININFO vout:B VPWR:B VGND:B vcl:B dac_out:B clk_fb:B clk_ref:B rst_ni:B vctrl_in:B vctrl_b_in:B vctrl_out:B vctrl_b_out:B
RR1 vcl dac_out 264.54k $SUB=VGND $[rhigh] w=1e-6 l=61.395e-6 b=2 m=1 ps=0.18e-6
x1 net1 VPWR VGND net2 vco
x2 clk_fb vctrl_out VPWR net1 vout VGND vctrl_b_out output_buffer
RR2 net2 vcl 24.863 $SUB=VGND $[rsil] w=0.5e-6 l=0.5e-6
x7 VGND VPWR clk_fb clk_ref dac_out rst_ni vctrl_b_in vctrl_b_out vctrl_in vctrl_out dac
.ends

* expanding   symbol:  simple_comparator_stage.sym # of pins=12
** sym_path: /home/belal/HeiChips/heichips26-on-off/macros/heichips26_ook/macros/ook_analog_system/schematic/xschem/simple_comparator_stage.sym
** sch_path: /home/belal/HeiChips/heichips26-on-off/macros/heichips26_ook/macros/ook_analog_system/schematic/xschem/simple_comparator_stage.sch
.subckt simple_comparator_stage VDD1_5 VDD3_3 vin q0 vref0 VSS q1 vref1 q2 vref2 q3 vref3
*.PININFO VDD3_3:B VSS:B VDD1_5:B vin:I q0:O vref3:I vref2:I vref1:I vref0:I q1:O q2:O q3:O
x2 VDD1_5 VSS VDD3_3 vref0 vin q0 simple_comparator
RR1 VDD3_3 vref3 20.064k $SUB=VSS $[rhigh] w=2e-6 l=28.8e-6 b=0
RR5 vref0 VSS 9.031k $SUB=VSS $[rhigh] w=2e-6 l=12.9e-6 b=0
x1 VDD1_5 VSS VDD3_3 vref1 vin q1 simple_comparator
x3 VDD1_5 VSS VDD3_3 vref2 vin q2 simple_comparator
x4 VDD1_5 VSS VDD3_3 vref3 vin q3 simple_comparator
RR4 vref1 vref0 2.0229k $SUB=VSS $[rhigh] w=2e-6 l=2.8e-6 b=0
RR3 vref2 vref1 1.0514k $SUB=VSS $[rhigh] w=2e-6 l=1.4e-6 b=0
RR2 vref3 vref2 1.0514k $SUB=VSS $[rhigh] w=2e-6 l=1.4e-6 b=0
.ends

* expanding   symbol:  lna_stage.sym # of pins=8
** sym_path: /home/belal/HeiChips/heichips26-on-off/macros/heichips26_ook/macros/ook_analog_system/schematic/xschem/lna_stage.sym
** sch_path: /home/belal/HeiChips/heichips26-on-off/macros/heichips26_ook/macros/ook_analog_system/schematic/xschem/lna_stage.sch
.subckt lna_stage Cap_M2 Cap_M1 VDD vout vin VSS Cap_M21 Cap_M11
*.PININFO vin:I VSS:B VDD:B Cap_M2:B Cap_M1:B vout:B Cap_M21:B Cap_M11:B
x2 VDD Cap_M1 vin VSS lna
x1 VDD Cap_M11 Cap_M2 VSS lna
x3 VDD vout Cap_M21 VSS lna
.ends

* expanding   symbol:  vco.sym # of pins=4
** sym_path: /home/belal/HeiChips/heichips26-on-off/macros/heichips26_ook/macros/ook_analog_system/schematic/xschem/vco.sym
** sch_path: /home/belal/HeiChips/heichips26-on-off/macros/heichips26_ook/macros/ook_analog_system/schematic/xschem/vco.sch
.subckt vco vout VDD VSS VCL
*.PININFO vout:O VDD:B VSS:B VCL:I
MM1 net1 vosc net4 VDD sg13_lv_pmos w=4.5u l=0.13u ng=10
MM2 net1 vosc net7 VSS sg13_lv_nmos w=2u l=0.13u ng=5
MM3 net2 net1 net5 VDD sg13_lv_pmos w=4.5u l=0.13u ng=10
MM4 net2 net1 net8 VSS sg13_lv_nmos w=2u l=0.13u ng=5
MM5 vosc net2 net6 VDD sg13_lv_pmos w=4.5u l=0.13u ng=10
MM6 vosc net2 net9 VSS sg13_lv_nmos w=2u l=0.13u ng=5
MM7 vout vosc VDD VDD sg13_lv_pmos w=4.5u l=0.13u ng=10
MM8 vout vosc VSS VSS sg13_lv_nmos w=2u l=0.13u ng=5
MM9 net4 VCH VDD VDD sg13_lv_pmos w=5u l=0.13u ng=10
MM10 net5 VCH VDD VDD sg13_lv_pmos w=5u l=0.13u ng=10
MM11 net6 VCH VDD VDD sg13_lv_pmos w=5u l=0.13u ng=10
MM12 net7 VCL_L VSS VSS sg13_lv_nmos w=3u l=0.13u ng=5
MM13 net8 VCL_L VSS VSS sg13_lv_nmos w=3u l=0.13u ng=5
MM14 net9 VCL_L VSS VSS sg13_lv_nmos w=3u l=0.13u ng=5
MM15 VCH VCH VDD VDD sg13_lv_pmos w=5u l=0.13u ng=10
MM16 VCH VCL net3 VSS sg13_lv_nmos w=40u l=0.13u ng=20
MM17 VCL_L VCH VDD VDD sg13_lv_pmos w=5u l=0.13u ng=10
MM18 VCL_L VCL_L VSS VSS sg13_lv_nmos w=3u l=0.13u ng=5
RR1 net3 VSS 3.029k $SUB=VSS $[rhigh] w=2e-6 l=4.25e-6 b=0
MM19 VDD VDD VDD VDD sg13_lv_pmos w=0.5u l=0.13u ng=1
MM20 VCH VCH VCH VDD sg13_lv_pmos w=0.5u l=0.13u ng=1
MM21 VCH VCH VCH VSS sg13_lv_nmos w=2u l=0.13u ng=1
MM22 net3 net3 net3 VSS sg13_lv_nmos w=2u l=0.13u ng=1
MM23 VDD VDD VDD VDD sg13_lv_pmos w=0.5u l=0.13u ng=1
MM24 VCL_L VCL_L VCL_L VDD sg13_lv_pmos w=0.5u l=0.13u ng=1
MM25 VCL_L VCL_L VCL_L VSS sg13_lv_nmos w=0.6u l=0.13u ng=1
MM26 VSS VSS VSS VSS sg13_lv_nmos w=0.6u l=0.13u ng=1
MM27 VDD VDD VDD VDD sg13_lv_pmos w=0.5u l=0.13u ng=1
MM28 VDD VDD VDD VDD sg13_lv_pmos w=0.5u l=0.13u ng=1
MM29 VDD VDD VDD VDD sg13_lv_pmos w=0.5u l=0.13u ng=1
MM30 net4 net4 net4 VDD sg13_lv_pmos w=0.5u l=0.13u ng=1
MM31 net5 net5 net5 VDD sg13_lv_pmos w=0.5u l=0.13u ng=1
MM32 net6 net6 net6 VDD sg13_lv_pmos w=0.5u l=0.13u ng=1
MM33 net7 net7 net7 VSS sg13_lv_nmos w=0.6u l=0.13u ng=1
MM34 net8 net8 net8 VSS sg13_lv_nmos w=0.6u l=0.13u ng=1
MM35 net9 net9 net9 VSS sg13_lv_nmos w=0.6u l=0.13u ng=1
MM36 VSS VSS VSS VSS sg13_lv_nmos w=0.6u l=0.13u ng=1
MM37 VSS VSS VSS VSS sg13_lv_nmos w=0.6u l=0.13u ng=1
MM38 VSS VSS VSS VSS sg13_lv_nmos w=0.6u l=0.13u ng=1
MM39 net7 net7 net7 VSS sg13_lv_nmos w=0.4u l=0.13u ng=1
MM40 net8 net8 net8 VSS sg13_lv_nmos w=0.4u l=0.13u ng=1
MM41 net9 net9 net9 VSS sg13_lv_nmos w=0.4u l=0.13u ng=1
MM42 net1 net1 net1 VSS sg13_lv_nmos w=0.4u l=0.13u ng=1
MM43 net2 net2 net2 VSS sg13_lv_nmos w=0.4u l=0.13u ng=1
MM44 vosc vosc vosc VSS sg13_lv_nmos w=0.4u l=0.13u ng=1
MM45 net1 net1 net1 VDD sg13_lv_pmos w=0.45u l=0.13u ng=1
MM46 net2 net2 net2 VDD sg13_lv_pmos w=0.45u l=0.13u ng=1
MM47 vosc vosc vosc VDD sg13_lv_pmos w=0.45u l=0.13u ng=1
MM48 net4 net4 net4 VDD sg13_lv_pmos w=0.45u l=0.13u ng=1
MM49 net5 net5 net5 VDD sg13_lv_pmos w=0.45u l=0.13u ng=1
MM50 net6 net6 net6 VDD sg13_lv_pmos w=0.45u l=0.13u ng=1
MM51 VSS VSS VSS VSS sg13_lv_nmos w=0.4u l=0.13u ng=1
MM52 vout vout vout VSS sg13_lv_nmos w=0.4u l=0.13u ng=1
MM53 vout vout vout VDD sg13_lv_pmos w=0.45u l=0.13u ng=1
MM54 VDD VDD VDD VDD sg13_lv_pmos w=0.45u l=0.13u ng=1
.ends

* expanding   symbol:  output_buffer.sym # of pins=7
** sym_path: /home/belal/HeiChips/heichips26-on-off/macros/heichips26_ook/macros/ook_analog_system/schematic/xschem/output_buffer.sym
** sch_path: /home/belal/HeiChips/heichips26-on-off/macros/heichips26_ook/macros/ook_analog_system/schematic/xschem/output_buffer.sch
.subckt output_buffer vout_fb vctrl VDD vin vout VSS vctrl_b
*.PININFO VDD:B VSS:B vin:I vout:O vctrl:I vout_fb:O vctrl_b:I
MM7 vout_fb vin VDD VDD sg13_lv_pmos w=13.5u l=0.13u ng=10
MM8 vout_fb vin VSS VSS sg13_lv_nmos w=6u l=0.13u ng=5
MM3 net2 net1 VDD VDD sg13_lv_pmos w=40u l=0.13u ng=20
MM4 net2 net1 VSS VSS sg13_lv_nmos w=18u l=0.13u ng=10
MM1 vout net2 VDD VDD sg13_lv_pmos w=200u l=0.13u ng=50
MM2 vout net2 VSS VSS sg13_lv_nmos w=80u l=0.13u ng=20
MM5 net1 vctrl_b vout_fb VDD sg13_lv_pmos w=13.5u l=0.13u ng=10
MM6 net1 vctrl vout_fb VSS sg13_lv_nmos w=6u l=0.13u ng=5
MM11 net1 vctrl VSS VDD sg13_lv_pmos w=13.5u l=0.13u ng=10
MM12 net1 vctrl_b VSS VSS sg13_lv_nmos w=6u l=0.13u ng=5
MM17 VDD VDD VDD VDD sg13_lv_pmos w=1.3u l=0.13u ng=1
MM18 vout_fb vout_fb vout_fb VDD sg13_lv_pmos w=1.3u l=0.13u ng=1
MM19 vout_fb vout_fb vout_fb VSS sg13_lv_nmos w=1.2u l=0.13u ng=1
MM20 VSS VSS VSS VSS sg13_lv_nmos w=1.2u l=0.13u ng=1
MM21 vout_fb vout_fb vout_fb VDD sg13_lv_pmos w=1.3u l=0.13u ng=1
MM22 vout_fb vout_fb vout_fb VSS sg13_lv_nmos w=1.2u l=0.13u ng=1
MM23 VSS VSS VSS VSS sg13_lv_nmos w=1.2u l=0.13u ng=1
MM24 VSS VSS VSS VDD sg13_lv_pmos w=1.3u l=0.13u ng=1
MM25 net1 net1 net1 VDD sg13_lv_pmos w=1.3u l=0.13u ng=1
MM26 net1 net1 net1 VSS sg13_lv_nmos w=1.2u l=0.13u ng=1
MM27 net1 net1 net1 VSS sg13_lv_nmos w=1.2u l=0.13u ng=1
MM28 net1 net1 net1 VDD sg13_lv_pmos w=1.3u l=0.13u ng=1
MM29 VDD VDD VDD VDD sg13_lv_pmos w=2u l=0.13u ng=1
MM30 net2 net2 net2 VDD sg13_lv_pmos w=2u l=0.13u ng=1
MM31 net2 net2 net2 VSS sg13_lv_nmos w=1.8u l=0.13u ng=1
MM32 VSS VSS VSS VSS sg13_lv_nmos w=1.8u l=0.13u ng=1
MM33 VDD VDD VDD VDD sg13_lv_pmos w=4u l=0.13u ng=1
MM34 vout vout vout VDD sg13_lv_pmos w=4u l=0.13u ng=1
MM35 vout vout vout VSS sg13_lv_nmos w=4u l=0.13u ng=1
MM36 VSS VSS VSS VSS sg13_lv_nmos w=4u l=0.13u ng=1
.ends

* expanding   symbol:  simple_comparator.sym # of pins=6
** sym_path: /home/belal/HeiChips/heichips26-on-off/macros/heichips26_ook/macros/ook_analog_system/schematic/xschem/simple_comparator.sym
** sch_path: /home/belal/HeiChips/heichips26-on-off/macros/heichips26_ook/macros/ook_analog_system/schematic/xschem/simple_comparator.sch
.subckt simple_comparator VDDL VSS VDD vref vin comp_out
*.PININFO vin:I vref:I VDD:B VSS:B comp_out:O VDDL:B
MMBIAS vbias vbias VDD VDD sg13_hv_pmos w=4u l=0.5u ng=1
RRBIAS vbias VSS 126.92k $SUB=VSS $[rhigh] w=2e-6 l=9.27e-6 b=15 m=1 ps=0.18e-6
MM3P net4 vbias VDD VDD sg13_hv_pmos w=4u l=0.5u ng=1
MM1P outn vin net4 VDD sg13_hv_pmos w=4u l=0.5u ng=1 m=4
MM2P net1 vref net4 VDD sg13_hv_pmos w=4u l=0.5u ng=1 m=4
MM4N outn outn VSS VSS sg13_hv_nmos w=2u l=0.5u ng=1 m=4
MM5N net1 outn VSS VSS sg13_hv_nmos w=2u l=0.5u ng=1 m=4
MMP1 net2 net1 VDD VDD sg13_hv_pmos w=2u l=4u ng=1
MMN1 net2 net1 net3 VSS sg13_hv_nmos w=2u l=4u ng=1
MMP2 comp_out net2 VDDL VDDL sg13_hv_pmos w=2u l=4u ng=1
MMBIAS1 vbias vbias vbias VDD sg13_hv_pmos w=4u l=0.5u ng=1
MMBIAS2 VDD VDD VDD VDD sg13_hv_pmos w=4u l=0.5u ng=1
MM1 VDD VDD VDD VDD sg13_hv_pmos w=4u l=0.5u ng=1
MM2 net4 net4 net4 VDD sg13_hv_pmos w=4u l=0.5u ng=1
MMP3 net2 net2 net2 VDD sg13_hv_pmos w=2u l=4u ng=1
MMP4 VDD VDD VDD VDD sg13_hv_pmos w=2u l=4u ng=1
MMP5 VDDL VDDL VDDL VDDL sg13_hv_pmos w=2u l=4u ng=1
MMP6 comp_out comp_out comp_out VDDL sg13_hv_pmos w=2u l=4u ng=1
MMN3 comp_out comp_out comp_out VSS sg13_hv_nmos w=2u l=4u ng=1
MMN4 VSS VSS VSS VSS sg13_hv_nmos w=2u l=4u ng=1
MMN5 net2 net2 net2 VSS sg13_hv_nmos w=2u l=4u ng=1
MMN6 net3 net3 net3 VSS sg13_hv_nmos w=2u l=4u ng=1
MM3 net4 net4 net4 VDD sg13_hv_pmos w=4u l=0.5u ng=1
MM4 outn outn outn VDD sg13_hv_pmos w=4u l=0.5u ng=1
MM5 net1 net1 net1 VSS sg13_hv_nmos w=2u l=0.5u ng=1
MM6 VSS VSS VSS VSS sg13_hv_nmos w=2u l=0.5u ng=1
MM7 net4 net4 net4 VDD sg13_hv_pmos w=4u l=0.5u ng=1
MM8 net1 net1 net1 VDD sg13_hv_pmos w=4u l=0.5u ng=1
MM9 outn outn outn VSS sg13_hv_nmos w=2u l=0.5u ng=1
MM10 VSS VSS VSS VSS sg13_hv_nmos w=2u l=0.5u ng=1
RRBIAS1 net3 VSS 98.458k $SUB=VSS $[rhigh] w=2e-6 l=13.71e-6 b=8 m=1 ps=0.18e-6
MMN8 comp_out net2 VSS VSS sg13_hv_nmos w=2u l=4u ng=1
.ends

* expanding   symbol:  lna.sym # of pins=4
** sym_path: /home/belal/HeiChips/heichips26-on-off/macros/heichips26_ook/macros/ook_analog_system/schematic/xschem/lna.sym
** sch_path: /home/belal/HeiChips/heichips26-on-off/macros/heichips26_ook/macros/ook_analog_system/schematic/xschem/lna.sch
.subckt lna VDD vout vin VSS
*.PININFO VDD:B VSS:B vin:I vout:B
MM14 vout VDD net6 VSS sg13_hv_nmos w=2.0u l=0.5u ng=2
MM15 net6 vin VSS VSS sg13_hv_nmos w=18.0u l=0.5u ng=18
MM16 net1 net1 VSS VSS sg13_hv_nmos w=2.00u l=0.5u ng=2
MM17 isource1 vout VSS VSS sg13_hv_nmos w=0.5u l=0.5u ng=1
MM18 VDD isource1 isink1 VSS sg13_hv_nmos w=1.5u l=0.5u ng=1
MM19 VSS isink1 vout VDD sg13_hv_pmos w=0.7u l=0.5u ng=1
MM20 net2 net2 VSS VSS sg13_hv_nmos w=10.0u l=0.5u ng=5
MM21 isink1 net2 VSS VSS sg13_hv_nmos w=10.0u l=0.5u ng=5
MM22 net3 net3 VDD VDD sg13_hv_pmos w=14u l=0.5u ng=7
MM23 isource1 net3 VDD VDD sg13_hv_pmos w=14u l=0.5u ng=7
MM24 net4 net4 VDD VDD sg13_hv_pmos w=14u l=0.5u ng=7
MM25 vout net4 VDD VDD sg13_hv_pmos w=14u l=0.5u ng=7
RR2 net1 vin 32.509k $SUB=VSS $[rhigh] w=2.0e-6 l=9.96e-6 b=3 m=1 ps=0.18e-6
RR5 net4 VSS 13.574k $SUB=VSS $[rhigh] w=2e-6 l=4.95e-6 b=2 m=1 ps=0.18e-6
RR1 VDD net1 153.18k $SUB=VSS $[rhigh] w=2e-6 l=19.995e-6 b=9 m=1 ps=0.18e-6
RR6 VDD net2 153.18k $SUB=VSS $[rhigh] w=2.0e-6 l=19.995e-6 b=9 m=1 ps=0.18e-6
MM2 net5 net5 VSS VSS sg13_hv_nmos w=0.5u l=0.5u ng=1
MM3 vout net5 VSS VSS sg13_hv_nmos w=0.5u l=0.5u ng=1
RR4 net3 VSS 13.574k $SUB=VSS $[rhigh] w=2e-6 l=4.95e-6 b=2 m=1 ps=0.18e-6
RR13 VDD net5 189.44k $SUB=VSS $[rhigh] w=2e-6 l=22.72e-6 b=10 m=1 ps=0.18e-6
MM1 VSS VSS VSS VDD sg13_hv_pmos w=0.7u l=0.5u ng=1
MM4 vout vout vout VDD sg13_hv_pmos w=0.7u l=0.5u ng=1
MM5 VSS VSS VSS VSS sg13_hv_nmos w=0.5u l=0.5u ng=1
MM6 isource1 isource1 isource1 VSS sg13_hv_nmos w=0.5u l=0.5u ng=1
MM7 isink1 isink1 isink1 VSS sg13_hv_nmos w=1.5u l=0.5u ng=1
MM8 VDD VDD VDD VSS sg13_hv_nmos w=1.5u l=0.5u ng=1
MM9 isource1 isource1 isource1 VDD sg13_hv_pmos w=2u l=0.5u ng=1
MM10 VDD VDD VDD VDD sg13_hv_pmos w=2u l=0.5u ng=1
MM11 VDD VDD VDD VDD sg13_hv_pmos w=2u l=0.5u ng=1
MM12 net3 net3 net3 VDD sg13_hv_pmos w=2u l=0.5u ng=1
MM13 VDD VDD VDD VDD sg13_hv_pmos w=2u l=0.5u ng=1
MM26 VDD VDD VDD VDD sg13_hv_pmos w=2u l=0.5u ng=1
MM27 vout vout vout VDD sg13_hv_pmos w=2u l=0.5u ng=1
MM28 net4 net4 net4 VDD sg13_hv_pmos w=2u l=0.5u ng=1
MM29 isink1 isink1 isink1 VSS sg13_hv_nmos w=2.0u l=0.5u ng=1
MM30 VSS VSS VSS VSS sg13_hv_nmos w=2.0u l=0.5u ng=1
MM31 net2 net2 net2 VSS sg13_hv_nmos w=2.0u l=0.5u ng=1
MM32 VSS VSS VSS VSS sg13_hv_nmos w=2.0u l=0.5u ng=1
MM33 vout vout vout VSS sg13_hv_nmos w=0.5u l=0.5u ng=1
MM34 VSS VSS VSS VSS sg13_hv_nmos w=0.5u l=0.5u ng=1
MM35 net5 net5 net5 VSS sg13_hv_nmos w=0.5u l=0.5u ng=1
MM36 VSS VSS VSS VSS sg13_hv_nmos w=0.5u l=0.5u ng=1
MM37 vout vout vout VSS sg13_hv_nmos w=1.0u l=0.5u ng=1
MM38 net6 net6 net6 VSS sg13_hv_nmos w=1.0u l=0.5u ng=1
MM39 net6 net6 net6 VSS sg13_hv_nmos w=1.0u l=0.5u ng=1
MM40 VSS VSS VSS VSS sg13_hv_nmos w=1.0u l=0.5u ng=1
MM41 net1 net1 net1 VSS sg13_hv_nmos w=1.00u l=0.5u ng=1
MM42 VSS VSS VSS VSS sg13_hv_nmos w=1.00u l=0.5u ng=1
.ends

.subckt dac VGND VPWR clk_fb clk_ref dac_out rst_ni vctrl_b_in vctrl_b_out vctrl_in
+ vctrl_out
XFILLER_7_7 VPWR VGND sg13cmos5l_fill_2
XFILLER_5_332 VPWR VGND sg13cmos5l_fill_2
X_0985_ _0985_/Y _0920_/A _0983_/Y _0984_/Y _1021_/A _0866_/Y VPWR VGND sg13cmos5l_a221oi_1
XFILLER_12_21 VPWR VGND sg13cmos5l_fill_1
X_0770_ _0770_/Y _0770_/A _0770_/B VPWR VGND sg13cmos5l_nand2_1
X_0968_ _1121_/D _0965_/Y _0967_/Y _0957_/Y VPWR VGND sg13cmos5l_o21ai_1
XFILLER_15_239 VPWR VGND sg13cmos5l_fill_1
XFILLER_15_228 VPWR VGND sg13cmos5l_decap_8
X_0899_ _1012_/B _0999_/A _0900_/C _0983_/A VPWR VGND sg13cmos5l_nor3_1
X_0822_ _1035_/C _0820_/X _0821_/Y _0818_/Y VPWR VGND sg13cmos5l_a21oi_1
XFILLER_14_283 VPWR VGND sg13cmos5l_fill_1
X_0753_ _0805_/C _0753_/A _0753_/B VPWR VGND sg13cmos5l_and2_1
X_0684_ _0684_/Y _0684_/A _0684_/B VPWR VGND sg13cmos5l_nor2_1
Xclkbuf_1_0__f_u_fb_div.g_stage\[1\].q_regs clkload1/A clkbuf_0_u_fb_div.g_stage\[1\].q_regs/X
+ VPWR VGND sg13cmos5l_buf_8
X_1098_ _1098_/Q clk_fb _1098_/D fanout52/X VPWR VGND sg13cmos5l_dfrbpq_1
XFILLER_18_42 VPWR VGND sg13cmos5l_fill_2
Xfanout7 fanout7/X _1035_/C VPWR VGND sg13cmos5l_buf_1
X_1021_ _1022_/C _1021_/A _1021_/B VPWR VGND sg13cmos5l_nor2_1
X_0598_ _0598_/Y _1076_/Q _1001_/A VPWR VGND sg13cmos5l_nand2_1
X_0736_ _0736_/Y _0544_/Y _0733_/Y _0735_/Y VPWR VGND sg13cmos5l_a21oi_1
X_0667_ _0786_/B _0697_/C _0675_/A VPWR VGND sg13cmos5l_and2_1
X_0805_ _0805_/X _0805_/A _0805_/B _0805_/C VPWR VGND sg13cmos5l_and3_1
XFILLER_16_378 VPWR VGND sg13cmos5l_fill_1
Xhold85 hold85/X hold85/A VPWR VGND sg13cmos5l_dlygate4sd3_1
Xhold96 hold96/X hold96/A VPWR VGND sg13cmos5l_dlygate4sd3_1
Xhold74 hold74/X hold74/A VPWR VGND sg13cmos5l_dlygate4sd3_1
Xhold63 hold63/X hold63/A VPWR VGND sg13cmos5l_dlygate4sd3_1
X_1004_ _1124_/D _0998_/Y _1003_/Y _0994_/Y VPWR VGND sg13cmos5l_o21ai_1
XFILLER_6_67 VPWR VGND sg13cmos5l_fill_1
X_0719_ _0767_/A hold97/A _0718_/B VPWR VGND sg13cmos5l_nor2b_1
XFILLER_9_319 VPWR VGND sg13cmos5l_fill_1
XFILLER_0_230 VPWR VGND sg13cmos5l_fill_1
XFILLER_11_0 VPWR VGND sg13cmos5l_decap_8
XFILLER_10_329 VPWR VGND sg13cmos5l_decap_8
XFILLER_10_307 VPWR VGND sg13cmos5l_fill_1
XFILLER_13_145 VPWR VGND sg13cmos5l_fill_2
XFILLER_13_123 VPWR VGND sg13cmos5l_decap_8
XFILLER_13_101 VPWR VGND sg13cmos5l_fill_1
XFILLER_9_138 VPWR VGND sg13cmos5l_fill_2
XFILLER_5_377 VPWR VGND sg13cmos5l_fill_2
X_0984_ _0984_/Y _0984_/A _0984_/B VPWR VGND sg13cmos5l_xnor2_1
Xclkbuf_0_u_fb_div.g_stage\[1\].q clkbuf_0_u_fb_div.g_stage\[1\].q/X _1107_/Q VPWR
+ VGND sg13cmos5l_buf_8
XFILLER_5_130 VPWR VGND sg13cmos5l_fill_2
X_0898_ _0983_/A _0982_/A _0982_/C _0984_/B VPWR VGND sg13cmos5l_a21oi_1
X_0967_ _0967_/Y _0866_/Y _0966_/X _1016_/B VPWR VGND sg13cmos5l_o21ai_1
X_0752_ _0753_/B _0779_/A _0774_/B VPWR VGND sg13cmos5l_nor2_1
X_0821_ _0821_/Y hold68/A _0821_/B _1035_/B VPWR VGND sg13cmos5l_nand3_1
XFILLER_9_45 VPWR VGND sg13cmos5l_fill_2
XFILLER_2_188 VPWR VGND sg13cmos5l_fill_1
X_0683_ _0758_/B _0706_/S _0804_/B _0684_/B _1065_/A VPWR VGND sg13cmos5l_a22oi_1
X_1097_ _1097_/Q _1114_/CLK hold62/X fanout55/X VPWR VGND sg13cmos5l_dfrbpq_1
Xfanout8 _1016_/B _1033_/A VPWR VGND sg13cmos5l_buf_1
X_1020_ _1021_/B _0886_/C _0885_/Y _1019_/X VPWR VGND sg13cmos5l_a21oi_1
XFILLER_15_7 VPWR VGND sg13cmos5l_decap_4
X_0597_ _0599_/A _1076_/Q _1001_/A VPWR VGND sg13cmos5l_nor2_1
X_0735_ _0735_/Y _0763_/A _0735_/B _0878_/B VPWR VGND sg13cmos5l_nor3_1
X_0666_ _0742_/A _0790_/S _0697_/C _0751_/D VPWR VGND sg13cmos5l_or3_1
X_0804_ _0804_/Y _0839_/A _0804_/B _0805_/C VPWR VGND sg13cmos5l_nor3_1
Xhold97 hold97/X hold97/A VPWR VGND sg13cmos5l_dlygate4sd3_1
Xhold86 hold86/X hold86/A VPWR VGND sg13cmos5l_dlygate4sd3_1
Xhold75 hold75/X hold75/A VPWR VGND sg13cmos5l_dlygate4sd3_1
Xhold64 hold64/X hold64/A VPWR VGND sg13cmos5l_dlygate4sd3_1
XFILLER_4_228 VPWR VGND sg13cmos5l_fill_2
XFILLER_16_324 VPWR VGND sg13cmos5l_fill_2
X_1003_ _1003_/Y _1027_/A _1002_/Y _1016_/B VPWR VGND sg13cmos5l_o21ai_1
Xclkbuf_1_0__f_u_fb_div.stage_q0_regs clkload0/A clkbuf_0_u_fb_div.stage_q0_regs/X
+ VPWR VGND sg13cmos5l_buf_8
X_0649_ hold77/A hold76/X _0650_/B VPWR VGND sg13cmos5l_nor2_1
X_0718_ _0777_/C _0718_/A _0718_/B VPWR VGND sg13cmos5l_nand2_1
XFILLER_16_132 VPWR VGND sg13cmos5l_fill_1
XFILLER_5_334 VPWR VGND sg13cmos5l_fill_1
XFILLER_12_190 VPWR VGND sg13cmos5l_fill_2
X_0983_ _0983_/Y _0983_/A _0982_/Y VPWR VGND sg13cmos5l_nor2b_1
XFILLER_12_56 VPWR VGND sg13cmos5l_fill_2
XFILLER_5_175 VPWR VGND sg13cmos5l_fill_2
X_0897_ _0982_/C _0970_/A _0970_/C _0972_/B VPWR VGND sg13cmos5l_a21o_1
X_0966_ _0966_/X _0920_/A _0958_/Y _0960_/Y VPWR VGND sg13cmos5l_a21o_1
XFILLER_14_263 VPWR VGND sg13cmos5l_fill_2
XFILLER_0_26 VPWR VGND sg13cmos5l_fill_2
XFILLER_2_123 VPWR VGND sg13cmos5l_decap_8
XFILLER_2_134 VPWR VGND sg13cmos5l_fill_1
X_0820_ _0820_/X _0821_/B _1035_/B _0819_/Y VPWR VGND sg13cmos5l_a21o_1
X_0682_ _0682_/Y _0764_/A _0764_/B VPWR VGND sg13cmos5l_nor2_1
X_0751_ _0774_/B _0805_/A _0798_/A _1065_/A _0751_/D VPWR VGND sg13cmos5l_nor4_1
X_1096_ hold62/A _1114_/CLK hold61/X fanout55/X VPWR VGND sg13cmos5l_dfrbpq_1
Xclkbuf_1_0__f_u_fb_div.g_stage\[2\].q _0788_/B2 clkbuf_0_u_fb_div.g_stage\[2\].q/X
+ VPWR VGND sg13cmos5l_buf_8
XFILLER_18_44 VPWR VGND sg13cmos5l_fill_1
Xclkbuf_3_6__f_clk_ref _1135_/CLK clkbuf_0_clk_ref/X VPWR VGND sg13cmos5l_buf_8
XFILLER_11_288 VPWR VGND sg13cmos5l_fill_2
XFILLER_7_226 VPWR VGND sg13cmos5l_decap_8
X_0949_ _0949_/Y _0949_/A _0949_/B VPWR VGND sg13cmos5l_xnor2_1
Xfanout9 _0994_/B _1023_/A VPWR VGND sg13cmos5l_buf_1
X_0665_ _0684_/B _0790_/S _0697_/C _0807_/A VPWR VGND sg13cmos5l_nor3_1
X_0734_ _0734_/Y _0544_/Y _0733_/Y _0732_/Y VPWR VGND sg13cmos5l_o21ai_1
XFILLER_1_0 VPWR VGND sg13cmos5l_decap_8
X_0803_ _1113_/D _0839_/A _0803_/B VPWR VGND sg13cmos5l_xnor2_1
X_1079_ hold90/A _1125_/CLK _1079_/D fanout47/X VPWR VGND sg13cmos5l_dfrbpq_1
X_0596_ _0596_/Y _0592_/A _0987_/A _0595_/B VPWR VGND sg13cmos5l_a21oi_1
Xhold76 hold76/X hold76/A VPWR VGND sg13cmos5l_dlygate4sd3_1
Xhold98 hold98/X hold98/A VPWR VGND sg13cmos5l_dlygate4sd3_1
Xhold87 hold87/X hold87/A VPWR VGND sg13cmos5l_dlygate4sd3_1
Xhold65 hold65/X hold65/A VPWR VGND sg13cmos5l_dlygate4sd3_1
X_0717_ _0718_/B hold70/A _0769_/A hold76/A VPWR VGND sg13cmos5l_a21oi_1
X_0648_ hold72/A _0809_/B hold71/X _0650_/B VPWR VGND sg13cmos5l_nor3_1
X_1002_ _1002_/Y _0913_/Y _1001_/X _1000_/Y VPWR VGND sg13cmos5l_o21ai_1
X_0579_ _0579_/X hold99/X _0949_/A VPWR VGND sg13cmos5l_xor2_1
XFILLER_13_339 VPWR VGND sg13cmos5l_fill_2
XFILLER_13_317 VPWR VGND sg13cmos5l_fill_1
XFILLER_8_332 VPWR VGND sg13cmos5l_fill_2
XFILLER_8_321 VPWR VGND sg13cmos5l_fill_1
X_0982_ _0982_/Y _0982_/A _0984_/B _0982_/C VPWR VGND sg13cmos5l_nand3_1
XFILLER_3_26 VPWR VGND sg13cmos5l_fill_2
Xhold140 hold140/X _1123_/Q VPWR VGND sg13cmos5l_dlygate4sd3_1
XFILLER_2_338 VPWR VGND sg13cmos5l_fill_2
XFILLER_5_7 VPWR VGND sg13cmos5l_fill_2
XFILLER_18_228 VPWR VGND sg13cmos5l_decap_8
XFILLER_5_132 VPWR VGND sg13cmos5l_fill_1
X_0896_ _0970_/C _0895_/A _0953_/A _0959_/B VPWR VGND sg13cmos5l_o21ai_1
X_0965_ _0965_/Y _0976_/B1 _0963_/X _0964_/X _0912_/X fanout7/X VPWR VGND sg13cmos5l_a221oi_1
X_0681_ _0764_/B _0777_/A _0775_/A _0681_/C VPWR VGND sg13cmos5l_nand3b_1
X_0750_ _0753_/A _0750_/A _0750_/B _0750_/C VPWR VGND sg13cmos5l_nand3_1
X_1095_ hold61/A _1114_/CLK _1095_/D fanout54/X VPWR VGND sg13cmos5l_dfrbpq_1
X_0879_ _0881_/D _0892_/S _0879_/B VPWR VGND sg13cmos5l_xor2_1
X_0948_ _0948_/Y _0873_/Y _0947_/X _0976_/B1 VPWR VGND sg13cmos5l_o21ai_1
X_0802_ _0803_/B _1065_/B _0802_/B VPWR VGND sg13cmos5l_nand2_1
X_1078_ _1078_/Q _1125_/CLK _1078_/D fanout47/X VPWR VGND sg13cmos5l_dfrbpq_1
X_0664_ _0712_/A _0677_/B _0804_/B _1090_/Q VPWR VGND sg13cmos5l_o21ai_1
X_0733_ _0733_/Y _0804_/B _0769_/A _0805_/B _0751_/D VPWR VGND sg13cmos5l_a22oi_1
X_0595_ _1075_/D _0595_/A _0595_/B VPWR VGND sg13cmos5l_nor2_1
Xhold77 hold77/X hold77/A VPWR VGND sg13cmos5l_dlygate4sd3_1
Xhold66 hold66/X hold66/A VPWR VGND sg13cmos5l_dlygate4sd3_1
Xhold99 hold99/X hold99/A VPWR VGND sg13cmos5l_dlygate4sd3_1
Xhold88 hold88/X hold88/A VPWR VGND sg13cmos5l_dlygate4sd3_1
XFILLER_6_26 VPWR VGND sg13cmos5l_decap_4
X_0647_ _0650_/B hold70/X _1090_/Q _0647_/C VPWR VGND sg13cmos5l_and3_1
X_0716_ _0718_/A hold70/A _0769_/A VPWR VGND sg13cmos5l_or2_1
X_1001_ _1001_/X _1001_/A _1001_/B VPWR VGND sg13cmos5l_xor2_1
X_0578_ _0584_/A hold99/X _0949_/A VPWR VGND sg13cmos5l_nor2_1
XFILLER_16_123 VPWR VGND sg13cmos5l_decap_8
XFILLER_12_351 VPWR VGND sg13cmos5l_fill_1
X_0981_ _0981_/Y _0987_/A _0994_/B VPWR VGND sg13cmos5l_nand2_1
Xclkbuf_0_u_fb_div.g_stage\[2\].q_regs clkbuf_0_u_fb_div.g_stage\[2\].q_regs/X clkbuf_regs_2_fb_stage2/X
+ VPWR VGND sg13cmos5l_buf_8
XFILLER_12_192 VPWR VGND sg13cmos5l_fill_1
XFILLER_8_130 VPWR VGND sg13cmos5l_decap_4
Xhold141 _1013_/A _1125_/Q VPWR VGND sg13cmos5l_dlygate4sd3_1
Xhold130 _0582_/A _1073_/Q VPWR VGND sg13cmos5l_dlygate4sd3_1
X_0895_ _0958_/B _0895_/A _0953_/A VPWR VGND sg13cmos5l_nor2_1
XFILLER_1_350 VPWR VGND sg13cmos5l_fill_1
X_0964_ _0964_/X _0964_/A _0964_/B VPWR VGND sg13cmos5l_xor2_1
X_0680_ _0775_/A hold93/A _0680_/B VPWR VGND sg13cmos5l_or2_1
XFILLER_14_265 VPWR VGND sg13cmos5l_fill_1
XFILLER_9_26 VPWR VGND sg13cmos5l_fill_2
XFILLER_0_28 VPWR VGND sg13cmos5l_fill_1
X_1094_ _1094_/Q _1135_/CLK _1094_/D fanout52/X VPWR VGND sg13cmos5l_dfrbpq_1
X_0947_ _0947_/X _0949_/A _0961_/C VPWR VGND sg13cmos5l_xor2_1
X_0878_ _0879_/B _0941_/A _0878_/B VPWR VGND sg13cmos5l_xnor2_1
Xclkload0 clkload0/X clkload0/A VPWR VGND sg13cmos5l_buf_1
XFILLER_11_235 VPWR VGND sg13cmos5l_fill_2
XFILLER_11_213 VPWR VGND sg13cmos5l_fill_2
XFILLER_11_202 VPWR VGND sg13cmos5l_fill_2
X_0663_ _0663_/X _1090_/Q _0707_/B VPWR VGND sg13cmos5l_and2_1
X_1077_ _1077_/Q _1125_/CLK _1077_/D fanout47/X VPWR VGND sg13cmos5l_dfrbpq_1
X_0732_ _0732_/Y _0757_/A _0739_/A _0770_/B VPWR VGND sg13cmos5l_nand3_1
X_0594_ _0595_/B _0593_/A _0593_/B _0593_/C VPWR VGND sg13cmos5l_a21oi_1
X_0801_ _0802_/B _0804_/B _0805_/C _0800_/Y VPWR VGND sg13cmos5l_o21ai_1
Xhold67 hold67/X hold67/A VPWR VGND sg13cmos5l_dlygate4sd3_1
XFILLER_16_338 VPWR VGND sg13cmos5l_fill_2
Xhold78 hold78/X hold78/A VPWR VGND sg13cmos5l_dlygate4sd3_1
Xhold89 hold89/X hold89/A VPWR VGND sg13cmos5l_dlygate4sd3_1
X_0715_ _0720_/C _0747_/B _0720_/B _0715_/C VPWR VGND sg13cmos5l_nor3_1
XFILLER_13_7 VPWR VGND sg13cmos5l_decap_4
X_1000_ _1000_/Y _0873_/Y _0999_/X _1021_/A VPWR VGND sg13cmos5l_o21ai_1
X_0646_ hold71/A _1090_/Q _0647_/C hold70/X VPWR VGND sg13cmos5l_a21oi_1
X_1129_ hold74/A _1130_/CLK hold75/X fanout50/X VPWR VGND sg13cmos5l_dfrbpq_1
X_0577_ _0580_/A _0576_/A _0576_/B _0574_/X VPWR VGND sg13cmos5l_a21oi_1
XFILLER_12_330 VPWR VGND sg13cmos5l_decap_8
XFILLER_8_334 VPWR VGND sg13cmos5l_fill_1
XFILLER_0_234 VPWR VGND sg13cmos5l_fill_2
X_0629_ _0631_/B _0629_/A _0629_/B VPWR VGND sg13cmos5l_and2_1
XFILLER_3_28 VPWR VGND sg13cmos5l_fill_1
XFILLER_8_164 VPWR VGND sg13cmos5l_fill_1
X_0980_ _1122_/D _0973_/Y _0979_/Y _0969_/Y VPWR VGND sg13cmos5l_o21ai_1
XFILLER_12_26 VPWR VGND sg13cmos5l_fill_2
Xhold131 hold131/X _1084_/Q VPWR VGND sg13cmos5l_dlygate4sd3_1
XFILLER_10_108 VPWR VGND sg13cmos5l_fill_1
Xhold120 _0617_/A _1097_/Q VPWR VGND sg13cmos5l_dlygate4sd3_1
Xhold142 hold142/X _1121_/Q VPWR VGND sg13cmos5l_dlygate4sd3_1
X_0894_ _0953_/A _0952_/A _0952_/C _0954_/B VPWR VGND sg13cmos5l_a21oi_1
XFILLER_1_340 VPWR VGND sg13cmos5l_fill_1
X_0963_ _0963_/X _0975_/B _0962_/X _0873_/Y VPWR VGND sg13cmos5l_a21o_1
XFILLER_5_123 VPWR VGND sg13cmos5l_decap_8
XFILLER_4_71 VPWR VGND sg13cmos5l_fill_1
X_1093_ hold97/A _1135_/CLK _1093_/D fanout52/X VPWR VGND sg13cmos5l_dfrbpq_1
X_0946_ _0946_/Y _0961_/A _0994_/B VPWR VGND sg13cmos5l_nand2_1
X_0877_ _0892_/S _1117_/Q _1116_/Q _0877_/C _0877_/D VPWR VGND sg13cmos5l_nor4_1
Xclkload1 clkload1/X clkload1/A VPWR VGND sg13cmos5l_buf_1
X_0662_ _0707_/B _0706_/S _0791_/B VPWR VGND sg13cmos5l_nand2_1
XFILLER_10_291 VPWR VGND sg13cmos5l_fill_2
X_0593_ _0595_/A _0593_/A _0593_/B _0593_/C VPWR VGND sg13cmos5l_and3_1
X_0731_ _0731_/Y _0731_/A _0731_/B _0731_/C VPWR VGND sg13cmos5l_nor3_1
X_0800_ _0800_/Y _0805_/B _0805_/C VPWR VGND sg13cmos5l_nand2_1
Xhold68 hold68/X hold68/A VPWR VGND sg13cmos5l_dlygate4sd3_1
X_1076_ _1076_/Q _1125_/CLK _1076_/D fanout47/X VPWR VGND sg13cmos5l_dfrbpq_1
Xhold79 hold79/X hold79/A VPWR VGND sg13cmos5l_dlygate4sd3_1
X_0929_ _0929_/X _0941_/A _0891_/Y _0929_/S VPWR VGND sg13cmos5l_mux2_1
Xclkbuf_3_5__f_clk_ref _1114_/CLK clkbuf_0_clk_ref/X VPWR VGND sg13cmos5l_buf_8
XFILLER_15_26 VPWR VGND sg13cmos5l_decap_4
X_0645_ _1090_/D _0645_/A VPWR VGND sg13cmos5l_inv_1
X_0714_ _0748_/A _0720_/B _0715_/C VPWR VGND sg13cmos5l_or2_1
X_1059_ hold82/A hold85/A _1055_/B hold81/X VPWR VGND sg13cmos5l_a21oi_1
X_1128_ hold92/A _1128_/CLK _1128_/D fanout49/X VPWR VGND sg13cmos5l_dfrbpq_1
X_0576_ _1071_/D _0576_/A _0576_/B VPWR VGND sg13cmos5l_xor2_1
X_0628_ _0628_/Y _0629_/A _0629_/B VPWR VGND sg13cmos5l_nor2_1
XFILLER_7_71 VPWR VGND sg13cmos5l_fill_2
X_0559_ _1106_/D _1106_/Q VPWR VGND sg13cmos5l_inv_1
XFILLER_5_338 VPWR VGND sg13cmos5l_fill_2
Xhold143 hold143/X _1094_/Q VPWR VGND sg13cmos5l_dlygate4sd3_1
Xhold132 _0627_/B _0625_/Y VPWR VGND sg13cmos5l_dlygate4sd3_1
Xhold110 _0619_/A _1082_/Q VPWR VGND sg13cmos5l_dlygate4sd3_1
Xhold121 _0575_/A _1071_/Q VPWR VGND sg13cmos5l_dlygate4sd3_1
X_0893_ _0952_/C _0941_/A _0941_/C _0943_/B VPWR VGND sg13cmos5l_a21o_1
XFILLER_4_50 VPWR VGND sg13cmos5l_fill_1
X_0962_ _0962_/X _0961_/A _0961_/C _0964_/A VPWR VGND sg13cmos5l_a21o_1
XFILLER_14_256 VPWR VGND sg13cmos5l_fill_1
XFILLER_14_234 VPWR VGND sg13cmos5l_fill_2
XFILLER_9_28 VPWR VGND sg13cmos5l_fill_1
XFILLER_0_19 VPWR VGND sg13cmos5l_fill_2
XFILLER_3_7 VPWR VGND sg13cmos5l_fill_2
X_1092_ hold76/A _1135_/CLK hold78/X fanout53/X VPWR VGND sg13cmos5l_dfrbpq_1
X_0945_ _1119_/D _0940_/Y _0944_/Y _0932_/Y VPWR VGND sg13cmos5l_o21ai_1
X_0876_ _0919_/B _1116_/Q _0877_/C _0877_/D VPWR VGND sg13cmos5l_nor3_1
XFILLER_18_26 VPWR VGND sg13cmos5l_fill_2
Xclkload2 clkload2/X clkload2/A VPWR VGND sg13cmos5l_buf_1
Xclkbuf_regs_2_fb_stage2 clkbuf_regs_2_fb_stage2/X _1101_/Q VPWR VGND sg13cmos5l_buf_8
X_0661_ _0684_/A _0677_/B _0804_/B VPWR VGND sg13cmos5l_nor2_1
X_0592_ _0593_/C _0592_/A _0987_/A VPWR VGND sg13cmos5l_xnor2_1
X_0730_ _0730_/Y _0729_/A _0730_/B VPWR VGND sg13cmos5l_nand2b_1
XFILLER_6_230 VPWR VGND sg13cmos5l_fill_1
Xhold69 hold69/X hold69/A VPWR VGND sg13cmos5l_dlygate4sd3_1
X_0859_ _0997_/B _0984_/A _0858_/Y _0825_/Y VPWR VGND sg13cmos5l_o21ai_1
X_1075_ _1075_/Q _1125_/CLK _1075_/D fanout47/X VPWR VGND sg13cmos5l_dfrbpq_1
X_0928_ _0928_/Y fanout7/X _0927_/Y _1016_/B VPWR VGND sg13cmos5l_o21ai_1
X_1127_ _1127_/Q _1134_/CLK _1127_/D fanout49/X VPWR VGND sg13cmos5l_dfrbpq_1
X_0644_ _0645_/A hold126/X _0647_/C _0643_/Y VPWR VGND sg13cmos5l_o21ai_1
X_0713_ _0715_/C _0707_/B _0739_/A _1090_/Q VPWR VGND sg13cmos5l_a21oi_1
X_1058_ _1058_/Y hold81/X _1063_/B VPWR VGND sg13cmos5l_nand2_1
X_0575_ _0576_/B _0575_/A _0881_/B VPWR VGND sg13cmos5l_xor2_1
XFILLER_0_236 VPWR VGND sg13cmos5l_fill_1
XFILLER_8_369 VPWR VGND sg13cmos5l_fill_1
XFILLER_13_118 VPWR VGND sg13cmos5l_fill_1
X_0627_ _1084_/D _0796_/B _0627_/B _0629_/B VPWR VGND sg13cmos5l_nor3_1
X_0558_ _1104_/D _1104_/Q VPWR VGND sg13cmos5l_inv_1
XFILLER_3_19 VPWR VGND sg13cmos5l_fill_2
XFILLER_4_350 VPWR VGND sg13cmos5l_fill_2
Xhold111 _0602_/A _1077_/Q VPWR VGND sg13cmos5l_dlygate4sd3_1
XFILLER_12_28 VPWR VGND sg13cmos5l_fill_1
Xhold133 hold133/X _1083_/Q VPWR VGND sg13cmos5l_dlygate4sd3_1
Xhold100 _0580_/B _0579_/X VPWR VGND sg13cmos5l_dlygate4sd3_1
Xhold122 _0567_/B _1117_/Q VPWR VGND sg13cmos5l_dlygate4sd3_1
XFILLER_1_331 VPWR VGND sg13cmos5l_decap_4
XFILLER_17_287 VPWR VGND sg13cmos5l_fill_1
X_0961_ _0975_/B _0961_/A _0964_/A _0961_/C VPWR VGND sg13cmos5l_nand3_1
X_0892_ _0941_/C _0891_/Y _0879_/B _0892_/S VPWR VGND sg13cmos5l_mux2_1
XFILLER_4_95 VPWR VGND sg13cmos5l_fill_2
XFILLER_4_180 VPWR VGND sg13cmos5l_fill_1
X_1091_ hold70/A _1135_/CLK hold72/X fanout57/X VPWR VGND sg13cmos5l_dfrbpq_1
X_0944_ _0944_/Y _0920_/A _0942_/X _0943_/Y _0976_/B1 _0866_/Y VPWR VGND sg13cmos5l_a221oi_1
Xfanout50 fanout50/X fanout53/X VPWR VGND sg13cmos5l_buf_1
X_0875_ _0875_/Y _1030_/A _0874_/X _0867_/A VPWR VGND sg13cmos5l_o21ai_1
XFILLER_10_293 VPWR VGND sg13cmos5l_fill_1
X_0591_ _1074_/D _0591_/A _0593_/B VPWR VGND sg13cmos5l_nor2b_1
X_0660_ _0729_/B _0805_/A _0675_/A _0807_/A VPWR VGND sg13cmos5l_nand3_1
X_0858_ _0858_/Y _0984_/B VPWR VGND sg13cmos5l_inv_1
X_0789_ _0794_/A _0784_/Y _0785_/Y _0786_/Y _0788_/Y _0807_/A VPWR VGND sg13cmos5l_a221oi_1
X_1074_ _1074_/Q _1122_/CLK _1074_/D fanout46/X VPWR VGND sg13cmos5l_dfrbpq_1
X_0927_ _0927_/Y _0881_/D _0913_/Y _0926_/Y VPWR VGND sg13cmos5l_o21ai_1
XFILLER_3_234 VPWR VGND sg13cmos5l_fill_2
XFILLER_6_19 VPWR VGND sg13cmos5l_fill_2
X_1126_ _1126_/Q _1134_/CLK _1126_/D fanout48/X VPWR VGND sg13cmos5l_dfrbpq_1
XFILLER_18_0 VPWR VGND sg13cmos5l_decap_8
X_0643_ _0643_/Y hold126/X _0647_/C _0809_/B VPWR VGND sg13cmos5l_a21oi_1
X_0712_ _0720_/B _0712_/A _0878_/B VPWR VGND sg13cmos5l_nor2_1
X_0574_ _0574_/X _0575_/A _0881_/B VPWR VGND sg13cmos5l_and2_1
XFILLER_16_149 VPWR VGND sg13cmos5l_fill_1
X_1057_ hold86/A _1039_/B _1056_/Y _1054_/Y VPWR VGND sg13cmos5l_o21ai_1
XFILLER_11_7 VPWR VGND sg13cmos5l_fill_2
X_0626_ _0629_/B _0757_/A _0729_/A _0626_/C VPWR VGND sg13cmos5l_and3_1
XFILLER_7_73 VPWR VGND sg13cmos5l_fill_1
X_0557_ _1103_/D _1103_/Q VPWR VGND sg13cmos5l_inv_1
X_1109_ _1109_/Q _1108_/Q _1109_/D fanout54/X VPWR VGND sg13cmos5l_dfrbpq_1
XFILLER_8_123 VPWR VGND sg13cmos5l_decap_8
Xhold112 _1077_/D _0604_/X VPWR VGND sg13cmos5l_dlygate4sd3_1
Xhold134 hold134/X _1113_/Q VPWR VGND sg13cmos5l_dlygate4sd3_1
Xhold101 _1072_/D _0580_/Y VPWR VGND sg13cmos5l_dlygate4sd3_1
Xhold123 _0565_/B _1116_/Q VPWR VGND sg13cmos5l_dlygate4sd3_1
X_0609_ _0609_/Y _1019_/A hold90/X VPWR VGND sg13cmos5l_nor2_1
X_0960_ _0960_/Y _1030_/A _0960_/B VPWR VGND sg13cmos5l_nor2_1
X_0891_ _0891_/Y hold84/A _0891_/B VPWR VGND sg13cmos5l_xnor2_1
XFILLER_3_9 VPWR VGND sg13cmos5l_fill_1
X_1090_ _1090_/Q _1090_/CLK _1090_/D fanout57/X VPWR VGND sg13cmos5l_dfrbpq_1
XFILLER_14_236 VPWR VGND sg13cmos5l_fill_1
Xfanout40 _0798_/A hold138/X VPWR VGND sg13cmos5l_buf_1
XFILLER_9_19 VPWR VGND sg13cmos5l_fill_2
Xfanout51 fanout51/X fanout53/X VPWR VGND sg13cmos5l_buf_1
XFILLER_18_28 VPWR VGND sg13cmos5l_fill_1
XFILLER_11_228 VPWR VGND sg13cmos5l_decap_8
XFILLER_9_295 VPWR VGND sg13cmos5l_fill_2
X_0874_ _0874_/X _0874_/A _0874_/B _0986_/A _0874_/D VPWR VGND sg13cmos5l_or4_1
X_0943_ _0943_/Y _0943_/A _0943_/B VPWR VGND sg13cmos5l_xnor2_1
XFILLER_18_372 VPWR VGND sg13cmos5l_fill_2
X_0857_ _0984_/B _1123_/Q _0857_/B VPWR VGND sg13cmos5l_xnor2_1
X_0590_ _0593_/B _0589_/A _0589_/B _0589_/C VPWR VGND sg13cmos5l_o21ai_1
X_0926_ _0926_/Y _0873_/Y _0925_/Y _0976_/B1 VPWR VGND sg13cmos5l_o21ai_1
X_1073_ _1073_/Q _1122_/CLK _1073_/D fanout46/X VPWR VGND sg13cmos5l_dfrbpq_1
X_0788_ _0788_/Y _0788_/A1 _0805_/B _0704_/Y _0788_/B2 _0787_/Y VPWR VGND sg13cmos5l_a221oi_1
X_0642_ _1089_/D _0796_/B _0642_/B _0647_/C VPWR VGND sg13cmos5l_nor3_1
X_0711_ _0747_/B _0878_/B _0746_/C _1089_/Q VPWR VGND sg13cmos5l_o21ai_1
X_0573_ _0576_/A _0572_/A _0572_/B _0570_/Y VPWR VGND sg13cmos5l_o21ai_1
X_1125_ _1125_/Q _1125_/CLK _1125_/D fanout47/X VPWR VGND sg13cmos5l_dfrbpq_1
X_1056_ _1056_/Y hold85/X _1055_/B _1055_/Y VPWR VGND sg13cmos5l_o21ai_1
X_0909_ _0911_/A _0919_/B _0909_/B VPWR VGND sg13cmos5l_nand2b_1
XFILLER_8_338 VPWR VGND sg13cmos5l_fill_2
XFILLER_15_183 VPWR VGND sg13cmos5l_fill_2
XFILLER_15_161 VPWR VGND sg13cmos5l_fill_1
X_0625_ _0625_/Y _0729_/A _0626_/C _0757_/A VPWR VGND sg13cmos5l_a21oi_1
X_1039_ _1039_/Y hold92/X _1039_/B _1052_/A VPWR VGND sg13cmos5l_nor3_1
X_0556_ _1102_/D _1102_/Q VPWR VGND sg13cmos5l_inv_1
X_1108_ _1108_/Q _1106_/Q _1108_/D fanout54/X VPWR VGND sg13cmos5l_dfrbpq_1
XFILLER_16_61 VPWR VGND sg13cmos5l_fill_2
Xclkbuf_3_4__f_clk_ref _1130_/CLK clkbuf_0_clk_ref/X VPWR VGND sg13cmos5l_buf_8
XFILLER_12_19 VPWR VGND sg13cmos5l_fill_2
Xhold135 _0817_/A _1115_/Q VPWR VGND sg13cmos5l_dlygate4sd3_1
Xhold102 _0606_/A _1078_/Q VPWR VGND sg13cmos5l_dlygate4sd3_1
X_0608_ _0608_/Y _1019_/A hold90/X VPWR VGND sg13cmos5l_nand2_1
Xhold113 _0629_/A _1085_/Q VPWR VGND sg13cmos5l_dlygate4sd3_1
X_0539_ _0934_/A _0881_/B VPWR VGND sg13cmos5l_inv_1
Xhold124 _1116_/D _0916_/Y VPWR VGND sg13cmos5l_dlygate4sd3_1
XFILLER_5_138 VPWR VGND sg13cmos5l_fill_1
X_0890_ _0903_/C _0875_/Y _0888_/X _1027_/A VPWR VGND sg13cmos5l_a21o_1
XFILLER_13_40 VPWR VGND sg13cmos5l_fill_1
Xfanout52 fanout52/X fanout53/X VPWR VGND sg13cmos5l_buf_1
Xfanout41 _0675_/A _1065_/A VPWR VGND sg13cmos5l_buf_1
XFILLER_8_0 VPWR VGND sg13cmos5l_decap_8
Xfanout30 _0961_/A hold128/X VPWR VGND sg13cmos5l_buf_1
X_0873_ _0873_/Y _0874_/A _0874_/B _0986_/A _0874_/D VPWR VGND sg13cmos5l_nor4_1
X_0942_ _0942_/X _0952_/C _0942_/B VPWR VGND sg13cmos5l_and2_1
XFILLER_1_7 VPWR VGND sg13cmos5l_decap_4
XFILLER_1_21 VPWR VGND sg13cmos5l_fill_1
X_1072_ hold99/A _1122_/CLK _1072_/D fanout46/X VPWR VGND sg13cmos5l_dfrbpq_1
X_0856_ _0900_/C _0987_/A _0857_/B VPWR VGND sg13cmos5l_and2_1
X_0787_ _0787_/Y _1105_/D _0804_/B _0805_/A VPWR VGND sg13cmos5l_o21ai_1
X_0925_ _0925_/Y _0929_/S _0879_/B _0840_/Y VPWR VGND sg13cmos5l_a21oi_1
X_0641_ _0647_/C _0641_/A _0641_/B VPWR VGND sg13cmos5l_and2_1
XFILLER_15_332 VPWR VGND sg13cmos5l_decap_8
X_0710_ _0750_/A _0703_/Y _0777_/B _0712_/A VPWR VGND sg13cmos5l_o21ai_1
XFILLER_3_236 VPWR VGND sg13cmos5l_fill_1
XFILLER_15_19 VPWR VGND sg13cmos5l_decap_8
X_1124_ _1124_/Q _1134_/CLK _1124_/D fanout47/X VPWR VGND sg13cmos5l_dfrbpq_1
X_1055_ _1055_/Y hold81/X _1055_/B hold85/X VPWR VGND sg13cmos5l_nand3b_1
XFILLER_0_228 VPWR VGND sg13cmos5l_fill_2
X_0572_ _0572_/X _0572_/A _0572_/B VPWR VGND sg13cmos5l_xor2_1
X_0908_ _0909_/B _0877_/C _0877_/D _1116_/Q VPWR VGND sg13cmos5l_o21ai_1
X_0839_ _0929_/S _0839_/A _0839_/B _0839_/C _0839_/D VPWR VGND sg13cmos5l_or4_1
XFILLER_11_9 VPWR VGND sg13cmos5l_fill_1
X_0624_ _1083_/D _0624_/A VPWR VGND sg13cmos5l_inv_1
X_0555_ _1100_/D _1100_/Q VPWR VGND sg13cmos5l_inv_1
X_1038_ _1052_/A hold85/X hold81/X _1055_/B VPWR VGND sg13cmos5l_and3_1
X_1107_ _1107_/Q clkload0/A _1107_/D fanout51/X VPWR VGND sg13cmos5l_dfrbpq_1
XFILLER_12_132 VPWR VGND sg13cmos5l_fill_1
XFILLER_12_121 VPWR VGND sg13cmos5l_decap_8
XFILLER_8_103 VPWR VGND sg13cmos5l_fill_2
Xhold103 _0607_/B _0606_/Y VPWR VGND sg13cmos5l_dlygate4sd3_1
X_0607_ _0607_/Y _0607_/A _0607_/B VPWR VGND sg13cmos5l_xnor2_1
Xhold114 _0630_/B _0628_/Y VPWR VGND sg13cmos5l_dlygate4sd3_1
Xhold136 hold136/X _1114_/Q VPWR VGND sg13cmos5l_dlygate4sd3_1
Xhold125 _0567_/A _1069_/Q VPWR VGND sg13cmos5l_dlygate4sd3_1
X_0538_ _0919_/A _0567_/B VPWR VGND sg13cmos5l_inv_1
XFILLER_17_235 VPWR VGND sg13cmos5l_fill_2
XFILLER_1_345 VPWR VGND sg13cmos5l_fill_1
XFILLER_4_21 VPWR VGND sg13cmos5l_fill_1
XFILLER_4_161 VPWR VGND sg13cmos5l_fill_1
Xfanout42 _1065_/A hold129/X VPWR VGND sg13cmos5l_buf_1
XFILLER_14_227 VPWR VGND sg13cmos5l_decap_8
Xfanout31 _0881_/B hold73/A VPWR VGND sg13cmos5l_buf_1
Xfanout53 fanout53/X fanout57/X VPWR VGND sg13cmos5l_buf_1
Xfanout20 _0809_/B _0617_/Y VPWR VGND sg13cmos5l_buf_1
X_0872_ _0874_/D _1019_/A hold73/A _0886_/C _1006_/A VPWR VGND sg13cmos5l_nand4_1
X_0941_ _0942_/B _0941_/A _0943_/B _0941_/C VPWR VGND sg13cmos5l_nand3_1
XFILLER_18_19 VPWR VGND sg13cmos5l_decap_8
XFILLER_18_374 VPWR VGND sg13cmos5l_fill_1
XFILLER_18_330 VPWR VGND sg13cmos5l_decap_8
XFILLER_6_234 VPWR VGND sg13cmos5l_fill_2
X_1071_ _1071_/Q _1122_/CLK _1071_/D fanout46/X VPWR VGND sg13cmos5l_dfrbpq_1
X_0924_ _0924_/Y hold84/X _0994_/B VPWR VGND sg13cmos5l_nand2_1
X_0855_ _0984_/A _0972_/A _0972_/B _0827_/Y VPWR VGND sg13cmos5l_a21oi_1
X_0786_ _0786_/Y _0786_/A _0786_/B VPWR VGND sg13cmos5l_nand2_1
X_0640_ _0642_/B _0641_/A _0641_/B VPWR VGND sg13cmos5l_nor2_1
X_1054_ _1054_/Y hold85/X _1063_/B VPWR VGND sg13cmos5l_nand2_1
X_1123_ _1123_/Q _1125_/CLK _1123_/D fanout47/X VPWR VGND sg13cmos5l_dfrbpq_1
X_0571_ _0572_/B _0571_/A _0881_/A VPWR VGND sg13cmos5l_xnor2_1
X_0907_ _0907_/Y _0888_/A _0906_/Y _1023_/A VPWR VGND sg13cmos5l_a21oi_1
X_0769_ _0769_/Y _0769_/A _0769_/B VPWR VGND sg13cmos5l_nand2_1
X_0838_ _0839_/D _1117_/Q _1116_/Q VPWR VGND sg13cmos5l_nand2_1
XFILLER_15_130 VPWR VGND sg13cmos5l_decap_4
X_0623_ _0624_/A _0729_/A _0626_/C _0622_/Y VPWR VGND sg13cmos5l_o21ai_1
XFILLER_7_340 VPWR VGND sg13cmos5l_fill_1
XFILLER_7_21 VPWR VGND sg13cmos5l_fill_1
X_0554_ _1099_/D _1099_/Q VPWR VGND sg13cmos5l_inv_1
XFILLER_16_0 VPWR VGND sg13cmos5l_decap_8
X_1037_ _1055_/B hold79/X hold95/A _1046_/B VPWR VGND sg13cmos5l_and3_1
X_1106_ _1106_/Q _1104_/Q _1106_/D fanout55/X VPWR VGND sg13cmos5l_dfrbpq_1
XFILLER_4_332 VPWR VGND sg13cmos5l_decap_8
Xhold126 hold126/X _1090_/Q VPWR VGND sg13cmos5l_dlygate4sd3_1
Xhold104 _1078_/D _0607_/Y VPWR VGND sg13cmos5l_dlygate4sd3_1
X_0606_ _0606_/Y _0606_/A _0886_/C VPWR VGND sg13cmos5l_xnor2_1
Xhold137 hold137/X _1086_/Q VPWR VGND sg13cmos5l_dlygate4sd3_1
X_0537_ _0941_/A _0881_/A VPWR VGND sg13cmos5l_inv_1
Xhold115 _0571_/A _1070_/Q VPWR VGND sg13cmos5l_dlygate4sd3_1
Xfanout10 _1023_/A _0814_/X VPWR VGND sg13cmos5l_buf_1
Xfanout21 _1019_/A _0536_/Y VPWR VGND sg13cmos5l_buf_1
Xfanout43 _0763_/A hold137/X VPWR VGND sg13cmos5l_buf_1
XFILLER_13_97 VPWR VGND sg13cmos5l_decap_4
Xfanout54 fanout54/X fanout56/X VPWR VGND sg13cmos5l_buf_1
Xfanout32 _0881_/A hold84/A VPWR VGND sg13cmos5l_buf_1
XFILLER_13_283 VPWR VGND sg13cmos5l_fill_2
XFILLER_9_276 VPWR VGND sg13cmos5l_fill_2
X_0871_ _0986_/A _0961_/A _1121_/Q _1122_/Q _1123_/Q VPWR VGND sg13cmos5l_nand4_1
X_0940_ _0940_/Y fanout7/X _0939_/Y _1016_/B VPWR VGND sg13cmos5l_o21ai_1
X_0854_ _0972_/B _0969_/A _0854_/B VPWR VGND sg13cmos5l_xnor2_1
X_0785_ _0785_/Y _1102_/Q _0791_/B _0805_/B _1110_/Q _0805_/A VPWR VGND sg13cmos5l_a221oi_1
X_1070_ _1070_/Q _1128_/CLK _1070_/D fanout46/X VPWR VGND sg13cmos5l_dfrbpq_1
XFILLER_1_56 VPWR VGND sg13cmos5l_fill_2
X_0923_ _1117_/D _0919_/A _0814_/X _0918_/Y _0922_/X VPWR VGND sg13cmos5l_a22oi_1
XFILLER_10_21 VPWR VGND sg13cmos5l_fill_1
XFILLER_3_227 VPWR VGND sg13cmos5l_decap_8
X_1053_ hold80/A _1039_/B _1052_/Y _1049_/Y VPWR VGND sg13cmos5l_o21ai_1
X_1122_ _1122_/Q _1122_/CLK _1122_/D fanout46/X VPWR VGND sg13cmos5l_dfrbpq_1
X_0570_ _0570_/Y _0571_/A _0881_/A VPWR VGND sg13cmos5l_nand2_1
XFILLER_12_337 VPWR VGND sg13cmos5l_decap_4
XFILLER_8_319 VPWR VGND sg13cmos5l_fill_2
X_0768_ _0768_/Y _0757_/A _0727_/Y _0730_/Y _0723_/X _0725_/D VPWR VGND sg13cmos5l_a221oi_1
X_0837_ _0917_/B _0837_/A _0839_/B _0877_/D VPWR VGND sg13cmos5l_nor3_1
X_0906_ _0906_/Y _0917_/B _0906_/B VPWR VGND sg13cmos5l_nor2_1
X_0699_ _0699_/X _0839_/A _0839_/C VPWR VGND sg13cmos5l_or2_1
XFILLER_7_330 VPWR VGND sg13cmos5l_decap_4
X_1036_ _1046_/B hold92/X hold74/X VPWR VGND sg13cmos5l_nor2b_1
X_0553_ _1110_/D _1110_/Q VPWR VGND sg13cmos5l_inv_1
X_1105_ _1105_/Q clkload2/A _1105_/D fanout51/X VPWR VGND sg13cmos5l_dfrbpq_1
X_0622_ _0622_/Y _0729_/A _0626_/C _0796_/B VPWR VGND sg13cmos5l_a21oi_1
XFILLER_12_101 VPWR VGND sg13cmos5l_decap_4
Xhold105 _0638_/A _1088_/Q VPWR VGND sg13cmos5l_dlygate4sd3_1
X_0536_ _0536_/Y _0902_/A VPWR VGND sg13cmos5l_inv_1
X_0605_ _0607_/A _0604_/A _0604_/B _0601_/X VPWR VGND sg13cmos5l_a21o_1
Xhold138 hold138/X _1112_/Q VPWR VGND sg13cmos5l_dlygate4sd3_1
Xhold127 _0588_/A _1074_/Q VPWR VGND sg13cmos5l_dlygate4sd3_1
Xhold116 _1070_/D _0572_/X VPWR VGND sg13cmos5l_dlygate4sd3_1
X_1019_ _1019_/X _1019_/A _1019_/B VPWR VGND sg13cmos5l_and2_1
Xclkbuf_3_3__f_clk_ref _1134_/CLK clkbuf_0_clk_ref/X VPWR VGND sg13cmos5l_buf_8
XFILLER_4_130 VPWR VGND sg13cmos5l_fill_2
Xfanout33 _0877_/C _0817_/A VPWR VGND sg13cmos5l_buf_1
Xfanout22 _0886_/C _1126_/Q VPWR VGND sg13cmos5l_buf_1
Xfanout11 _1021_/A _0888_/A VPWR VGND sg13cmos5l_buf_1
Xfanout55 fanout55/X fanout56/X VPWR VGND sg13cmos5l_buf_1
Xfanout44 _0757_/A hold131/X VPWR VGND sg13cmos5l_buf_1
X_0870_ _0874_/B hold84/A _0870_/B VPWR VGND sg13cmos5l_nor2_1
XFILLER_1_122 VPWR VGND sg13cmos5l_decap_8
XFILLER_1_111 VPWR VGND sg13cmos5l_fill_2
X_0999_ _0999_/X _0999_/A _1006_/B VPWR VGND sg13cmos5l_xor2_1
XFILLER_6_236 VPWR VGND sg13cmos5l_fill_1
XFILLER_6_0 VPWR VGND sg13cmos5l_decap_8
X_0853_ _0982_/A _0969_/A _0854_/B VPWR VGND sg13cmos5l_nand2_1
X_0784_ _0784_/Y _1099_/Q _0786_/B _0704_/Y _1100_/Q VPWR VGND sg13cmos5l_a22oi_1
X_0922_ _0922_/X _0867_/B _0920_/Y _0921_/Y VPWR VGND sg13cmos5l_a21o_1
Xinput1 input1/X rst_ni VPWR VGND sg13cmos5l_buf_1
XFILLER_15_346 VPWR VGND sg13cmos5l_fill_1
X_1052_ _1052_/Y _1052_/A _1052_/B VPWR VGND sg13cmos5l_nor2_1
X_1121_ _1121_/Q _1122_/CLK _1121_/D fanout46/X VPWR VGND sg13cmos5l_dfrbpq_1
X_0767_ _0811_/B _0767_/A _0767_/B VPWR VGND sg13cmos5l_and2_1
X_0698_ _0779_/B _0839_/A _0839_/C VPWR VGND sg13cmos5l_nor2_1
X_0836_ _0891_/B _0839_/A _0839_/C _0535_/Y VPWR VGND sg13cmos5l_o21ai_1
X_0905_ _0906_/B _0877_/C _0878_/B _0565_/B VPWR VGND sg13cmos5l_a21oi_1
XFILLER_12_349 VPWR VGND sg13cmos5l_fill_2
X_1035_ _1039_/B hold143/X _1035_/B _1035_/C VPWR VGND sg13cmos5l_nand3b_1
X_0621_ _1082_/D _0796_/B _0687_/A _0626_/C VPWR VGND sg13cmos5l_nor3_1
X_1104_ _1104_/Q _1103_/Q _1104_/D fanout54/X VPWR VGND sg13cmos5l_dfrbpq_1
X_0552_ _1105_/D _1105_/Q VPWR VGND sg13cmos5l_inv_1
XFILLER_16_21 VPWR VGND sg13cmos5l_fill_1
X_0819_ _0819_/Y hold68/A hold66/A VPWR VGND sg13cmos5l_nand2b_1
XFILLER_12_146 VPWR VGND sg13cmos5l_fill_1
Xhold106 _0641_/A _1089_/Q VPWR VGND sg13cmos5l_dlygate4sd3_1
X_0604_ _0604_/X _0604_/A _0604_/B VPWR VGND sg13cmos5l_xor2_1
Xhold139 hold139/X _1122_/Q VPWR VGND sg13cmos5l_dlygate4sd3_1
Xhold117 _0592_/A _1075_/Q VPWR VGND sg13cmos5l_dlygate4sd3_1
Xhold128 hold128/X _1120_/Q VPWR VGND sg13cmos5l_dlygate4sd3_1
X_1018_ _1022_/B _0874_/X _1017_/Y _1030_/A VPWR VGND sg13cmos5l_a21oi_1
X_0535_ _0535_/Y hold92/A VPWR VGND sg13cmos5l_inv_1
Xfanout23 _1009_/A _1013_/A VPWR VGND sg13cmos5l_buf_1
Xfanout12 _0976_/B1 _0888_/A VPWR VGND sg13cmos5l_buf_1
Xfanout56 fanout56/X fanout57/X VPWR VGND sg13cmos5l_buf_1
Xfanout34 _0807_/A hold136/X VPWR VGND sg13cmos5l_buf_1
Xfanout45 _0729_/A hold133/X VPWR VGND sg13cmos5l_buf_1
XFILLER_13_285 VPWR VGND sg13cmos5l_fill_1
XFILLER_9_278 VPWR VGND sg13cmos5l_fill_1
Xclkbuf_1_0__f_u_fb_div.g_stage\[1\].q _0786_/A clkbuf_0_u_fb_div.g_stage\[1\].q/X
+ VPWR VGND sg13cmos5l_buf_8
X_0551__60 _1101_/D _0551__60/A VPWR VGND sg13cmos5l_inv_1
X_0998_ _0998_/Y _0910_/Y _0996_/Y _0997_/X _1021_/A _0866_/Y VPWR VGND sg13cmos5l_a221oi_1
X_0783_ _1094_/D _0782_/A _0779_/A _1065_/B VPWR VGND sg13cmos5l_a21o_1
X_0852_ _0972_/A _0959_/A _0959_/B _0829_/Y VPWR VGND sg13cmos5l_o21ai_1
X_0921_ _0921_/Y _0813_/Y _0873_/Y _0912_/X _0920_/B fanout7/X VPWR VGND sg13cmos5l_a221oi_1
X_0904_ _1115_/D _0902_/X _0903_/Y _0816_/Y VPWR VGND sg13cmos5l_o21ai_1
X_0766_ _0767_/B _0663_/X _0720_/C _0718_/A VPWR VGND sg13cmos5l_o21ai_1
X_1051_ _1052_/B _1055_/B _1051_/B VPWR VGND sg13cmos5l_nor2_1
X_0835_ _0934_/B _0881_/A _0870_/B VPWR VGND sg13cmos5l_nand2_1
X_0697_ _0839_/C _0675_/A _0751_/D _0697_/C VPWR VGND sg13cmos5l_nand3b_1
X_1120_ _1120_/Q _1128_/CLK _1120_/D fanout48/X VPWR VGND sg13cmos5l_dfrbpq_1
X_1034_ _1034_/Y _1033_/A _1031_/X _1033_/Y _0536_/Y VPWR VGND sg13cmos5l_a22oi_1
XFILLER_15_155 VPWR VGND sg13cmos5l_fill_1
X_1103_ _1103_/Q _1102_/Q _1103_/D fanout54/X VPWR VGND sg13cmos5l_dfrbpq_1
X_0620_ _0626_/C _0620_/A _0620_/B VPWR VGND sg13cmos5l_nor2_1
X_0818_ _0818_/Y _1035_/B _0813_/B _0548_/Y VPWR VGND sg13cmos5l_a21oi_1
X_0749_ _0750_/C _0741_/Y _0744_/Y _0748_/Y VPWR VGND sg13cmos5l_o21ai_1
Xhold107 _0902_/A _1127_/Q VPWR VGND sg13cmos5l_dlygate4sd3_1
X_1017_ _1017_/Y _1126_/Q _1017_/B VPWR VGND sg13cmos5l_xnor2_1
XFILLER_14_0 VPWR VGND sg13cmos5l_decap_8
Xhold129 hold129/X _1111_/Q VPWR VGND sg13cmos5l_dlygate4sd3_1
X_0603_ _0604_/B _0596_/Y _0599_/A _0598_/Y VPWR VGND sg13cmos5l_o21ai_1
Xhold118 _0600_/A _0596_/Y VPWR VGND sg13cmos5l_dlygate4sd3_1
XFILLER_7_195 VPWR VGND sg13cmos5l_fill_1
XFILLER_17_228 VPWR VGND sg13cmos5l_decap_8
XFILLER_1_338 VPWR VGND sg13cmos5l_fill_2
XFILLER_4_132 VPWR VGND sg13cmos5l_fill_1
Xclkbuf_regs_1_fb_stage1 clkbuf_regs_1_fb_stage1/X _1107_/Q VPWR VGND sg13cmos5l_buf_8
Xfanout13 _0888_/A _0813_/Y VPWR VGND sg13cmos5l_buf_1
Xfanout24 _0999_/A _1001_/A VPWR VGND sg13cmos5l_buf_1
XFILLER_13_78 VPWR VGND sg13cmos5l_fill_2
Xfanout35 _0751_/D hold136/X VPWR VGND sg13cmos5l_buf_1
XFILLER_1_168 VPWR VGND sg13cmos5l_fill_2
Xfanout57 fanout57/X input1/X VPWR VGND sg13cmos5l_buf_1
Xfanout46 fanout46/X fanout48/X VPWR VGND sg13cmos5l_buf_1
XFILLER_9_235 VPWR VGND sg13cmos5l_fill_2
X_0997_ _0997_/X _0999_/A _0997_/B VPWR VGND sg13cmos5l_xor2_1
XFILLER_5_90 VPWR VGND sg13cmos5l_fill_1
XFILLER_1_26 VPWR VGND sg13cmos5l_fill_2
Xclkbuf_1_0__f_u_fb_div.stage_q0 _0788_/A1 clkbuf_0_u_fb_div.stage_q0/X VPWR VGND
+ sg13cmos5l_buf_8
X_0920_ _0920_/Y _0920_/A _0920_/B VPWR VGND sg13cmos5l_nand2_1
X_0782_ _1065_/B _0782_/A _0782_/B VPWR VGND sg13cmos5l_nor2_1
X_0851_ _0959_/B _1121_/Q _0851_/B VPWR VGND sg13cmos5l_xor2_1
XFILLER_18_120 VPWR VGND sg13cmos5l_decap_8
XFILLER_18_7 VPWR VGND sg13cmos5l_decap_4
X_0903_ _0903_/Y _1016_/B _0903_/B _0903_/C VPWR VGND sg13cmos5l_nand3_1
X_0765_ _0811_/A _0674_/Y _0764_/Y _0754_/Y VPWR VGND sg13cmos5l_o21ai_1
X_0696_ _0761_/A _0763_/A _0696_/B VPWR VGND sg13cmos5l_nand2_1
X_1050_ _1051_/B hold95/A _1046_/B hold79/X VPWR VGND sg13cmos5l_a21oi_1
XFILLER_2_230 VPWR VGND sg13cmos5l_fill_1
Xclkbuf_0_u_fb_div.g_stage\[1\].q_regs clkbuf_0_u_fb_div.g_stage\[1\].q_regs/X clkbuf_regs_1_fb_stage1/X
+ VPWR VGND sg13cmos5l_buf_8
X_0834_ _0834_/X _0934_/A _0845_/B VPWR VGND sg13cmos5l_or2_1
XFILLER_15_145 VPWR VGND sg13cmos5l_fill_1
XFILLER_15_134 VPWR VGND sg13cmos5l_fill_2
XFILLER_15_123 VPWR VGND sg13cmos5l_decap_8
XFILLER_11_362 VPWR VGND sg13cmos5l_fill_2
XFILLER_11_351 VPWR VGND sg13cmos5l_fill_1
XFILLER_11_340 VPWR VGND sg13cmos5l_fill_1
X_1102_ _1102_/Q _1100_/Q _1102_/D fanout54/X VPWR VGND sg13cmos5l_dfrbpq_1
X_1033_ _1033_/Y _1033_/A _1033_/B VPWR VGND sg13cmos5l_nand2_1
X_0817_ _0867_/A _0817_/A _0878_/B VPWR VGND sg13cmos5l_xnor2_1
X_0748_ _0748_/Y _0748_/A _0777_/C _0748_/C _0748_/D VPWR VGND sg13cmos5l_nor4_1
X_0679_ _0764_/A _0763_/A _0696_/B VPWR VGND sg13cmos5l_nor2_1
XFILLER_4_303 VPWR VGND sg13cmos5l_fill_2
X_1016_ _1016_/Y _1016_/A _1016_/B VPWR VGND sg13cmos5l_nor2_1
Xhold108 _0782_/A _1094_/Q VPWR VGND sg13cmos5l_dlygate4sd3_1
X_0602_ _0604_/A _0602_/A _1009_/A VPWR VGND sg13cmos5l_xor2_1
Xhold119 _1076_/D _0600_/Y VPWR VGND sg13cmos5l_dlygate4sd3_1
XFILLER_7_130 VPWR VGND sg13cmos5l_fill_2
XFILLER_4_26 VPWR VGND sg13cmos5l_decap_4
XFILLER_4_48 VPWR VGND sg13cmos5l_fill_2
Xfanout25 _1001_/A _1124_/Q VPWR VGND sg13cmos5l_buf_1
Xfanout36 _0805_/A _1113_/Q VPWR VGND sg13cmos5l_buf_1
Xfanout47 fanout47/X fanout48/X VPWR VGND sg13cmos5l_buf_1
Xfanout14 _0870_/B _0877_/D VPWR VGND sg13cmos5l_buf_1
X_0996_ _0996_/Y _1012_/B _0996_/B VPWR VGND sg13cmos5l_nand2b_1
Xclkbuf_3_2__f_clk_ref _1125_/CLK clkbuf_0_clk_ref/X VPWR VGND sg13cmos5l_buf_8
XFILLER_10_235 VPWR VGND sg13cmos5l_fill_2
XFILLER_6_228 VPWR VGND sg13cmos5l_fill_2
X_0781_ _0782_/B _0779_/Y _0780_/Y _0805_/C VPWR VGND sg13cmos5l_a21oi_1
X_0850_ _0970_/A _1121_/Q _0851_/B VPWR VGND sg13cmos5l_nand2_1
XFILLER_5_250 VPWR VGND sg13cmos5l_fill_2
X_0979_ _0979_/Y fanout7/X _0978_/Y _1016_/B VPWR VGND sg13cmos5l_o21ai_1
XFILLER_10_69 VPWR VGND sg13cmos5l_fill_2
X_0902_ _0902_/X _0902_/A _1027_/A _0902_/C VPWR VGND sg13cmos5l_and3_1
X_0833_ _0845_/B _0839_/A _0839_/C hold74/A VPWR VGND sg13cmos5l_o21ai_1
XFILLER_4_0 VPWR VGND sg13cmos5l_decap_4
X_0764_ _0764_/Y _0764_/A _0764_/B _0764_/C _0764_/D VPWR VGND sg13cmos5l_nor4_1
XFILLER_12_308 VPWR VGND sg13cmos5l_fill_2
X_0695_ _0695_/Y _0770_/A _0758_/B _0684_/Y _0544_/Y VPWR VGND sg13cmos5l_a22oi_1
XFILLER_7_334 VPWR VGND sg13cmos5l_fill_1
XFILLER_7_26 VPWR VGND sg13cmos5l_fill_2
X_0816_ _0816_/Y _0877_/C _1023_/A VPWR VGND sg13cmos5l_nand2_1
X_1032_ _1033_/B _1019_/B _0902_/C _1035_/C VPWR VGND sg13cmos5l_mux2_1
X_0747_ _0748_/D _0746_/Y _0747_/B VPWR VGND sg13cmos5l_nand2b_1
X_0678_ _0696_/B _0675_/A _0684_/B _0769_/B _0706_/S VPWR VGND sg13cmos5l_a22oi_1
X_1101_ _1101_/Q clkload1/A _1101_/D fanout50/X VPWR VGND sg13cmos5l_dfrbpq_1
XFILLER_12_105 VPWR VGND sg13cmos5l_fill_2
Xhold109 _1127_/D _1034_/Y VPWR VGND sg13cmos5l_dlygate4sd3_1
X_0601_ _0601_/X _1077_/Q _1009_/A VPWR VGND sg13cmos5l_and2_1
X_1015_ _1125_/D _1011_/X _1014_/Y _1005_/Y VPWR VGND sg13cmos5l_o21ai_1
XFILLER_0_340 VPWR VGND sg13cmos5l_fill_1
XFILLER_4_123 VPWR VGND sg13cmos5l_decap_8
Xfanout26 _0987_/A hold140/X VPWR VGND sg13cmos5l_buf_1
Xfanout37 _0790_/S _0839_/A VPWR VGND sg13cmos5l_buf_1
Xfanout15 _0877_/D _0739_/A VPWR VGND sg13cmos5l_buf_1
Xfanout48 fanout48/X fanout49/X VPWR VGND sg13cmos5l_buf_1
XFILLER_8_7 VPWR VGND sg13cmos5l_fill_2
X_0995_ _0996_/B _0900_/C _0983_/A _1001_/A VPWR VGND sg13cmos5l_o21ai_1
XFILLER_1_28 VPWR VGND sg13cmos5l_fill_1
X_0780_ _0780_/Y _0811_/A _0821_/B VPWR VGND sg13cmos5l_nor2_1
XFILLER_15_339 VPWR VGND sg13cmos5l_fill_2
XFILLER_15_317 VPWR VGND sg13cmos5l_fill_2
XFILLER_10_26 VPWR VGND sg13cmos5l_fill_2
X_0978_ _0978_/Y _0913_/Y _0977_/Y _0976_/Y VPWR VGND sg13cmos5l_o21ai_1
X_0901_ _0902_/C _1016_/A _1030_/A _0901_/C VPWR VGND sg13cmos5l_and3_1
X_0763_ _0764_/D _0763_/A _0763_/B _0774_/B VPWR VGND sg13cmos5l_nor3_1
X_0694_ _0694_/Y _0685_/Y _0692_/Y _0693_/Y VPWR VGND sg13cmos5l_o21ai_1
X_0832_ _0832_/Y _0832_/A VPWR VGND sg13cmos5l_inv_1
XFILLER_15_114 VPWR VGND sg13cmos5l_fill_1
X_1031_ _1031_/X _1030_/Y _0864_/B _1035_/C VPWR VGND sg13cmos5l_mux2_1
X_0746_ _0746_/Y _1089_/Q _0779_/B _0746_/C VPWR VGND sg13cmos5l_nor3_1
X_0815_ _1033_/A _0810_/Y _0888_/A _0782_/A VPWR VGND sg13cmos5l_a21oi_1
Xclkbuf_0_u_fb_div.stage_q0_regs clkbuf_0_u_fb_div.stage_q0_regs/X clkbuf_regs_0_fb_stage0/X
+ VPWR VGND sg13cmos5l_buf_8
XFILLER_11_91 VPWR VGND sg13cmos5l_fill_1
X_1100_ _1100_/Q _1099_/Q _1100_/D fanout50/X VPWR VGND sg13cmos5l_dfrbpq_1
XFILLER_16_14 VPWR VGND sg13cmos5l_fill_1
XFILLER_12_128 VPWR VGND sg13cmos5l_decap_4
X_0677_ _0685_/B _0697_/C _0677_/B VPWR VGND sg13cmos5l_nor2_1
X_0600_ _0600_/Y _0600_/A _0600_/B VPWR VGND sg13cmos5l_xnor2_1
XFILLER_7_132 VPWR VGND sg13cmos5l_fill_1
X_0549__58 _1098_/D _0549__58/A VPWR VGND sg13cmos5l_inv_1
X_1014_ _1014_/Y _0910_/Y _1012_/X _1013_/Y _1021_/A _0866_/Y VPWR VGND sg13cmos5l_a221oi_1
X_0729_ _0731_/C _0729_/A _0729_/B VPWR VGND sg13cmos5l_nor2_1
XFILLER_0_330 VPWR VGND sg13cmos5l_decap_4
XFILLER_4_39 VPWR VGND sg13cmos5l_fill_1
XFILLER_4_146 VPWR VGND sg13cmos5l_fill_2
Xfanout38 _0839_/A hold134/X VPWR VGND sg13cmos5l_buf_1
XFILLER_12_0 VPWR VGND sg13cmos5l_decap_8
Xfanout27 _0969_/A hold139/X VPWR VGND sg13cmos5l_buf_1
Xfanout16 _0739_/A _0699_/X VPWR VGND sg13cmos5l_buf_1
Xfanout49 fanout49/X input1/X VPWR VGND sg13cmos5l_buf_1
XFILLER_13_26 VPWR VGND sg13cmos5l_fill_2
Xclkbuf_1_1__f_u_fb_div.g_stage\[2\].q_regs clkload2/A clkbuf_0_u_fb_div.g_stage\[2\].q_regs/X
+ VPWR VGND sg13cmos5l_buf_8
X_0994_ _0994_/Y _0999_/A _0994_/B VPWR VGND sg13cmos5l_nand2_1
XFILLER_18_337 VPWR VGND sg13cmos5l_decap_4
XFILLER_5_230 VPWR VGND sg13cmos5l_fill_1
X_0977_ _0977_/Y _0977_/A _0977_/B VPWR VGND sg13cmos5l_xnor2_1
XFILLER_18_134 VPWR VGND sg13cmos5l_fill_1
XFILLER_14_351 VPWR VGND sg13cmos5l_fill_1
X_0900_ _0901_/C _0999_/A _1009_/A _0900_/C _0983_/A VPWR VGND sg13cmos5l_nor4_1
X_0762_ _0764_/C _1085_/Q _0761_/B _0759_/Y _0760_/Y _0761_/Y VPWR VGND sg13cmos5l_a221oi_1
X_0693_ _0693_/Y _0758_/B _0757_/A VPWR VGND sg13cmos5l_nand2b_1
X_0831_ _0832_/A _0949_/A hold95/A _0870_/B VPWR VGND sg13cmos5l_nand3_1
XFILLER_11_321 VPWR VGND sg13cmos5l_fill_2
XFILLER_16_7 VPWR VGND sg13cmos5l_decap_8
X_1030_ _1030_/Y _1030_/A _1030_/B VPWR VGND sg13cmos5l_nor2_1
X_0814_ _0814_/X _0810_/Y _0888_/A _0782_/A VPWR VGND sg13cmos5l_a21o_1
XFILLER_7_28 VPWR VGND sg13cmos5l_fill_1
XFILLER_16_26 VPWR VGND sg13cmos5l_fill_2
X_0745_ _0748_/C _1088_/Q _0745_/B VPWR VGND sg13cmos5l_nor2_1
X_0676_ _0769_/B _0675_/A _0697_/C VPWR VGND sg13cmos5l_nand2b_1
XFILLER_4_339 VPWR VGND sg13cmos5l_fill_2
X_1013_ _1013_/Y _1013_/A _1013_/B VPWR VGND sg13cmos5l_xnor2_1
X_0728_ _0731_/B _0739_/A _0770_/B _0757_/A VPWR VGND sg13cmos5l_a21oi_1
X_0659_ _0730_/B _0805_/A _0675_/A _0807_/A VPWR VGND sg13cmos5l_and3_1
XFILLER_0_375 VPWR VGND sg13cmos5l_decap_4
XFILLER_13_38 VPWR VGND sg13cmos5l_fill_2
Xfanout39 _0697_/C _0798_/A VPWR VGND sg13cmos5l_buf_1
Xfanout17 _0878_/B _0779_/B VPWR VGND sg13cmos5l_buf_1
Xfanout28 _0964_/A hold142/X VPWR VGND sg13cmos5l_buf_1
XFILLER_13_235 VPWR VGND sg13cmos5l_fill_2
X_0993_ _1123_/D _0985_/Y _0992_/X _0981_/Y VPWR VGND sg13cmos5l_o21ai_1
XFILLER_9_228 VPWR VGND sg13cmos5l_decap_8
XFILLER_9_217 VPWR VGND sg13cmos5l_fill_2
XFILLER_8_272 VPWR VGND sg13cmos5l_fill_2
XFILLER_1_19 VPWR VGND sg13cmos5l_fill_2
XFILLER_10_28 VPWR VGND sg13cmos5l_fill_1
X_0976_ _0976_/Y _0873_/Y _0975_/Y _0976_/B1 VPWR VGND sg13cmos5l_o21ai_1
XFILLER_2_234 VPWR VGND sg13cmos5l_fill_2
XFILLER_14_330 VPWR VGND sg13cmos5l_decap_8
X_0761_ _0761_/Y _0761_/A _0761_/B VPWR VGND sg13cmos5l_nor2_1
X_0692_ _0692_/Y _1083_/Q _0685_/B _0687_/Y _0690_/X _0725_/A VPWR VGND sg13cmos5l_a221oi_1
X_0830_ _0848_/B hold95/A _0870_/B VPWR VGND sg13cmos5l_nand2_1
X_0959_ _0960_/B _0959_/A _0959_/B VPWR VGND sg13cmos5l_xnor2_1
Xclkbuf_3_1__f_clk_ref _1128_/CLK clkbuf_0_clk_ref/X VPWR VGND sg13cmos5l_buf_8
XFILLER_11_377 VPWR VGND sg13cmos5l_fill_2
XFILLER_11_311 VPWR VGND sg13cmos5l_fill_1
XFILLER_11_60 VPWR VGND sg13cmos5l_fill_2
XFILLER_2_0 VPWR VGND sg13cmos5l_decap_8
X_1089_ _1089_/Q _1090_/CLK _1089_/D fanout56/X VPWR VGND sg13cmos5l_dfrbpq_1
X_0813_ _0813_/Y _1035_/B _0813_/B VPWR VGND sg13cmos5l_nand2_1
X_0744_ _0744_/Y _0744_/A VPWR VGND sg13cmos5l_inv_1
X_0675_ _0805_/B _0675_/A _0798_/A VPWR VGND sg13cmos5l_nor2b_1
XFILLER_11_174 VPWR VGND sg13cmos5l_fill_2
XFILLER_11_130 VPWR VGND sg13cmos5l_fill_2
XFILLER_7_123 VPWR VGND sg13cmos5l_decap_8
X_1012_ _1012_/X _1013_/A _1012_/B VPWR VGND sg13cmos5l_xor2_1
X_0727_ _0727_/Y _0770_/B VPWR VGND sg13cmos5l_inv_1
XFILLER_3_340 VPWR VGND sg13cmos5l_fill_1
X_0658_ _0804_/B _0798_/A _1065_/A VPWR VGND sg13cmos5l_nand2b_1
X_0589_ _0591_/A _0589_/A _0589_/B _0589_/C VPWR VGND sg13cmos5l_nor3_1
XFILLER_4_19 VPWR VGND sg13cmos5l_fill_2
XFILLER_13_28 VPWR VGND sg13cmos5l_fill_1
Xfanout18 _0706_/S _0763_/B VPWR VGND sg13cmos5l_buf_1
Xfanout29 _0949_/A _1120_/Q VPWR VGND sg13cmos5l_buf_1
XFILLER_1_129 VPWR VGND sg13cmos5l_decap_4
XFILLER_13_258 VPWR VGND sg13cmos5l_fill_2
X_0992_ _0992_/X _0994_/B _0992_/B VPWR VGND sg13cmos5l_or2_1
XFILLER_10_228 VPWR VGND sg13cmos5l_decap_8
XFILLER_6_7 VPWR VGND sg13cmos5l_decap_4
X_0975_ _0975_/Y _1122_/Q _0975_/B VPWR VGND sg13cmos5l_xnor2_1
X_0760_ _0760_/Y _0760_/A _0760_/B VPWR VGND sg13cmos5l_nor2_1
X_0691_ _0725_/A _0620_/B _0687_/B _0620_/A VPWR VGND sg13cmos5l_a21oi_1
XFILLER_4_4 VPWR VGND sg13cmos5l_fill_2
X_0889_ _0889_/Y _1019_/A _1126_/Q VPWR VGND sg13cmos5l_nor2_1
X_0958_ _0958_/Y _0959_/B _0958_/B VPWR VGND sg13cmos5l_xnor2_1
XFILLER_11_323 VPWR VGND sg13cmos5l_fill_1
XFILLER_7_338 VPWR VGND sg13cmos5l_fill_2
XFILLER_7_316 VPWR VGND sg13cmos5l_fill_2
XFILLER_7_19 VPWR VGND sg13cmos5l_fill_2
XFILLER_16_28 VPWR VGND sg13cmos5l_fill_1
X_0674_ _0674_/Y _0681_/C _0777_/A VPWR VGND sg13cmos5l_nor2_1
X_0812_ _1030_/A _1035_/B _0813_/B VPWR VGND sg13cmos5l_and2_1
X_0743_ _0744_/A hold93/A _0740_/B _0745_/B _1088_/Q VPWR VGND sg13cmos5l_a22oi_1
X_1088_ _1088_/Q _1090_/CLK _1088_/D fanout56/X VPWR VGND sg13cmos5l_dfrbpq_1
X_1011_ _1011_/X _1023_/A _1011_/B VPWR VGND sg13cmos5l_or2_1
XFILLER_11_120 VPWR VGND sg13cmos5l_decap_8
XFILLER_7_102 VPWR VGND sg13cmos5l_fill_1
XFILLER_3_330 VPWR VGND sg13cmos5l_decap_4
X_0657_ _0791_/B _0697_/C _0675_/A VPWR VGND sg13cmos5l_nor2b_1
X_0726_ _0770_/B _0677_/B _0742_/A _0797_/A VPWR VGND sg13cmos5l_a21o_1
X_0588_ _0589_/C _0588_/A _0969_/A VPWR VGND sg13cmos5l_xor2_1
X_0709_ _0777_/B _1089_/Q _0746_/C _0708_/Y VPWR VGND sg13cmos5l_o21ai_1
Xfanout19 _0796_/B _0809_/B VPWR VGND sg13cmos5l_buf_1
XFILLER_0_130 VPWR VGND sg13cmos5l_fill_2
X_0991_ _0992_/B _1021_/A _0988_/Y _0990_/Y _0912_/X _1027_/A VPWR VGND sg13cmos5l_a221oi_1
XFILLER_10_0 VPWR VGND sg13cmos5l_decap_4
XFILLER_8_296 VPWR VGND sg13cmos5l_fill_2
XFILLER_8_263 VPWR VGND sg13cmos5l_fill_1
X_0974_ _0987_/B _0977_/A _0975_/B VPWR VGND sg13cmos5l_nor2_1
XFILLER_10_19 VPWR VGND sg13cmos5l_fill_2
X_0690_ _0690_/X _0742_/A _0797_/A _0706_/S VPWR VGND sg13cmos5l_mux2_1
XFILLER_2_236 VPWR VGND sg13cmos5l_fill_1
X_0888_ _0888_/X _0888_/A _0913_/B VPWR VGND sg13cmos5l_or2_1
X_0957_ _0957_/Y _0964_/A _0994_/B VPWR VGND sg13cmos5l_nand2_1
XFILLER_2_86 VPWR VGND sg13cmos5l_fill_1
XFILLER_11_84 VPWR VGND sg13cmos5l_decap_8
X_0673_ _0777_/A _1088_/Q _0673_/B VPWR VGND sg13cmos5l_nor2_1
X_0811_ _0813_/B _0811_/A _0811_/B VPWR VGND sg13cmos5l_and2_1
X_0742_ _0745_/B _0742_/A _0839_/C VPWR VGND sg13cmos5l_nand2_1
X_1087_ hold93/A _1090_/CLK _1087_/D fanout56/X VPWR VGND sg13cmos5l_dfrbpq_1
X_1010_ _1011_/B _1021_/A _1008_/Y _1009_/X _0912_/X _1027_/A VPWR VGND sg13cmos5l_a221oi_1
XFILLER_11_176 VPWR VGND sg13cmos5l_fill_1
XFILLER_11_132 VPWR VGND sg13cmos5l_fill_1
XFILLER_8_30 VPWR VGND sg13cmos5l_fill_2
X_0725_ _0731_/A _0725_/A _0878_/B _0725_/C _0725_/D VPWR VGND sg13cmos5l_nor4_1
X_0656_ _0677_/B _0805_/A _0807_/A VPWR VGND sg13cmos5l_nand2_1
X_0587_ _0593_/A _0588_/A _0969_/A VPWR VGND sg13cmos5l_nand2_1
XFILLER_16_235 VPWR VGND sg13cmos5l_fill_2
XFILLER_0_334 VPWR VGND sg13cmos5l_fill_1
XFILLER_13_19 VPWR VGND sg13cmos5l_decap_8
X_0708_ _0708_/Y _1089_/Q _0746_/C _0707_/Y VPWR VGND sg13cmos5l_a21oi_1
X_0639_ _1088_/D _0796_/B _0639_/B _0641_/B VPWR VGND sg13cmos5l_nor3_1
XFILLER_12_293 VPWR VGND sg13cmos5l_fill_2
X_0990_ _0990_/Y _1001_/B _0990_/B VPWR VGND sg13cmos5l_nand2_1
XFILLER_5_234 VPWR VGND sg13cmos5l_fill_2
X_0973_ _0973_/Y _0920_/A _0971_/X _0972_/X _0888_/A _0866_/Y VPWR VGND sg13cmos5l_a221oi_1
XFILLER_18_127 VPWR VGND sg13cmos5l_decap_8
XFILLER_2_21 VPWR VGND sg13cmos5l_fill_1
XFILLER_2_43 VPWR VGND sg13cmos5l_fill_2
XFILLER_2_54 VPWR VGND sg13cmos5l_fill_2
X_0956_ _1120_/D _0951_/Y _0955_/Y _0946_/Y VPWR VGND sg13cmos5l_o21ai_1
X_0887_ _0913_/B _1127_/Q _1019_/B VPWR VGND sg13cmos5l_nand2_1
XFILLER_11_336 VPWR VGND sg13cmos5l_decap_4
X_0810_ _0810_/Y _0821_/B _1035_/B VPWR VGND sg13cmos5l_nand2_1
X_0672_ _0672_/Y _0681_/C VPWR VGND sg13cmos5l_inv_1
XFILLER_14_130 VPWR VGND sg13cmos5l_decap_4
X_0741_ _0741_/Y _0721_/Y _0737_/Y _0740_/Y VPWR VGND sg13cmos5l_a21oi_1
XFILLER_6_340 VPWR VGND sg13cmos5l_fill_1
XFILLER_16_19 VPWR VGND sg13cmos5l_fill_2
X_1086_ _1086_/Q _1090_/CLK _1086_/D fanout56/X VPWR VGND sg13cmos5l_dfrbpq_1
Xclkbuf_regs_0_fb_stage0 clkbuf_regs_0_fb_stage0/X _1098_/Q VPWR VGND sg13cmos5l_buf_8
X_0939_ _0939_/Y _0913_/Y _0938_/Y _0936_/Y VPWR VGND sg13cmos5l_o21ai_1
XFILLER_0_0 VPWR VGND sg13cmos5l_decap_8
Xclkbuf_3_0__f_clk_ref _1122_/CLK clkbuf_0_clk_ref/X VPWR VGND sg13cmos5l_buf_8
X_0655_ _0763_/B _0805_/A _0807_/A VPWR VGND sg13cmos5l_and2_1
X_0724_ _0725_/D _0729_/A _0729_/B VPWR VGND sg13cmos5l_and2_1
X_0586_ _1073_/D _0589_/B _0585_/Y VPWR VGND sg13cmos5l_nor2b_1
XFILLER_17_95 VPWR VGND sg13cmos5l_fill_1
X_1069_ _1069_/Q _1128_/CLK _1069_/D fanout49/X VPWR VGND sg13cmos5l_dfrbpq_1
XFILLER_0_368 VPWR VGND sg13cmos5l_decap_8
X_0638_ _0641_/B _0638_/A _0638_/B VPWR VGND sg13cmos5l_and2_1
X_0707_ _0707_/Y _1090_/Q _0707_/B VPWR VGND sg13cmos5l_xnor2_1
XFILLER_13_228 VPWR VGND sg13cmos5l_decap_8
X_0569_ _0572_/A _1066_/A _0568_/B _0562_/X VPWR VGND sg13cmos5l_a21oi_1
XFILLER_8_298 VPWR VGND sg13cmos5l_fill_1
XFILLER_0_132 VPWR VGND sg13cmos5l_fill_1
XFILLER_5_21 VPWR VGND sg13cmos5l_fill_1
XFILLER_5_279 VPWR VGND sg13cmos5l_fill_1
X_0972_ _0972_/X _0972_/A _0972_/B VPWR VGND sg13cmos5l_xor2_1
X_0886_ _1019_/B _1001_/A _1009_/A _0886_/C _1001_/B VPWR VGND sg13cmos5l_nor4_1
X_0955_ _0955_/Y _0920_/A _0953_/Y _0954_/X _0976_/B1 _0866_/Y VPWR VGND sg13cmos5l_a221oi_1
X_0740_ _0740_/Y hold93/A _0740_/B VPWR VGND sg13cmos5l_nor2_1
XFILLER_7_308 VPWR VGND sg13cmos5l_fill_2
X_0671_ _0681_/C hold93/A _0680_/B _0673_/B _1088_/Q VPWR VGND sg13cmos5l_a22oi_1
X_1085_ _1085_/Q _1090_/CLK _1085_/D fanout56/X VPWR VGND sg13cmos5l_dfrbpq_1
X_0938_ _0938_/Y _0949_/B _0937_/Y VPWR VGND sg13cmos5l_nor2b_1
X_0869_ _0874_/A _0881_/A _0870_/B _0868_/Y VPWR VGND sg13cmos5l_a21oi_1
X_0654_ _1093_/D hold98/X VPWR VGND sg13cmos5l_inv_1
XFILLER_8_21 VPWR VGND sg13cmos5l_fill_1
Xclkbuf_0_u_fb_div.stage_q0 clkbuf_0_u_fb_div.stage_q0/X _1098_/Q VPWR VGND sg13cmos5l_buf_8
X_0723_ _0723_/X _0725_/A _0725_/C VPWR VGND sg13cmos5l_or2_1
X_0585_ _0585_/Y _0584_/A _0584_/C _0584_/B VPWR VGND sg13cmos5l_o21ai_1
X_1068_ hold87/A _1130_/CLK hold89/X fanout50/X VPWR VGND sg13cmos5l_dfrbpq_1
X_1137_ _1137_/X vctrl_in VPWR VGND sg13cmos5l_buf_1
XFILLER_3_130 VPWR VGND sg13cmos5l_fill_2
XFILLER_3_174 VPWR VGND sg13cmos5l_fill_2
X_0637_ _0639_/B _0638_/A _0638_/B VPWR VGND sg13cmos5l_nor2_1
X_0706_ _0746_/C _0684_/B _0705_/X _0706_/S VPWR VGND sg13cmos5l_mux2_1
X_0568_ _1066_/B _0562_/X _0568_/B VPWR VGND sg13cmos5l_nand2b_1
XFILLER_5_77 VPWR VGND sg13cmos5l_fill_1
XFILLER_5_236 VPWR VGND sg13cmos5l_fill_1
XFILLER_17_376 VPWR VGND sg13cmos5l_fill_2
XFILLER_17_332 VPWR VGND sg13cmos5l_decap_8
X_0971_ _0971_/X _0982_/C _0971_/B VPWR VGND sg13cmos5l_and2_1
XFILLER_2_228 VPWR VGND sg13cmos5l_fill_2
X_0885_ _0885_/Y _1009_/A _1009_/B VPWR VGND sg13cmos5l_nand2b_1
X_0954_ _0954_/X _0954_/A _0954_/B VPWR VGND sg13cmos5l_xor2_1
XFILLER_11_349 VPWR VGND sg13cmos5l_fill_2
XFILLER_11_21 VPWR VGND sg13cmos5l_fill_1
X_1084_ _1084_/Q _1090_/CLK _1084_/D fanout56/X VPWR VGND sg13cmos5l_dfrbpq_1
X_0670_ _0673_/B _0677_/B _0742_/A _0730_/B VPWR VGND sg13cmos5l_a21oi_1
X_0799_ _1112_/D _1065_/B _0797_/X _0798_/Y VPWR VGND sg13cmos5l_a21oi_1
X_0937_ _0937_/Y _0881_/A _0881_/D _0881_/B VPWR VGND sg13cmos5l_o21ai_1
X_0868_ _0868_/Y _0839_/B _0877_/D _0839_/D VPWR VGND sg13cmos5l_a21oi_1
X_0653_ hold98/A hold97/X _0651_/C _0652_/Y VPWR VGND sg13cmos5l_o21ai_1
XFILLER_8_77 VPWR VGND sg13cmos5l_fill_2
XFILLER_3_334 VPWR VGND sg13cmos5l_fill_1
X_0722_ _0725_/C _0687_/A _0687_/B _0797_/A _0763_/B VPWR VGND sg13cmos5l_a22oi_1
X_0584_ _0589_/B _0584_/A _0584_/B _0584_/C VPWR VGND sg13cmos5l_nor3_1
X_1067_ hold64/A _1130_/CLK hold65/X fanout50/X VPWR VGND sg13cmos5l_dfrbpq_1
X_1136_ _1136_/X vctrl_b_in VPWR VGND sg13cmos5l_buf_1
X_0636_ _1087_/D _0796_/B hold94/X _0638_/B VPWR VGND sg13cmos5l_nor3_1
X_0705_ _0705_/X _0798_/A _1065_/A VPWR VGND sg13cmos5l_or2_1
XFILLER_12_7 VPWR VGND sg13cmos5l_fill_2
X_0567_ _0568_/B _0567_/A _0567_/B VPWR VGND sg13cmos5l_or2_1
XFILLER_0_123 VPWR VGND sg13cmos5l_decap_8
X_1119_ hold73/A _1128_/CLK _1119_/D fanout49/X VPWR VGND sg13cmos5l_dfrbpq_1
XFILLER_10_4 VPWR VGND sg13cmos5l_fill_2
XFILLER_5_56 VPWR VGND sg13cmos5l_fill_1
XFILLER_14_65 VPWR VGND sg13cmos5l_fill_1
X_0619_ _0687_/A _0619_/A hold63/X VPWR VGND sg13cmos5l_nor2_1
XFILLER_17_322 VPWR VGND sg13cmos5l_fill_1
X_0970_ _0971_/B _0970_/A _0972_/B _0970_/C VPWR VGND sg13cmos5l_nand3_1
XFILLER_17_130 VPWR VGND sg13cmos5l_fill_2
X_0884_ _1009_/B _1001_/A _1001_/B VPWR VGND sg13cmos5l_nor2_1
XFILLER_9_340 VPWR VGND sg13cmos5l_fill_1
X_0953_ _0953_/Y _0953_/A _0952_/Y VPWR VGND sg13cmos5l_nor2b_1
X_1083_ _1083_/Q _1114_/CLK _1083_/D fanout55/X VPWR VGND sg13cmos5l_dfrbpq_1
XFILLER_6_332 VPWR VGND sg13cmos5l_fill_2
X_0867_ _0903_/B _0867_/A _0867_/B VPWR VGND sg13cmos5l_nand2_1
XFILLER_11_103 VPWR VGND sg13cmos5l_decap_4
X_0798_ _0798_/Y _0798_/A _1065_/B VPWR VGND sg13cmos5l_nor2_1
X_0936_ _0936_/Y _0873_/Y _0935_/Y _0976_/B1 VPWR VGND sg13cmos5l_o21ai_1
XFILLER_3_368 VPWR VGND sg13cmos5l_fill_2
X_0652_ _0652_/Y hold97/X _0651_/C _0809_/B VPWR VGND sg13cmos5l_a21oi_1
X_1135_ hold68/A _1135_/CLK hold69/X fanout52/X VPWR VGND sg13cmos5l_dfrbpq_1
X_0721_ _0721_/Y _0735_/B _0878_/B _0763_/A VPWR VGND sg13cmos5l_o21ai_1
X_1066_ _1069_/D _1066_/A _1066_/B VPWR VGND sg13cmos5l_xnor2_1
X_0583_ _0584_/C hold99/X _0949_/A _0576_/A _0576_/B _0574_/X VPWR VGND sg13cmos5l_a221oi_1
X_0919_ _0920_/B _0919_/A _0919_/B VPWR VGND sg13cmos5l_xnor2_1
XFILLER_17_21 VPWR VGND sg13cmos5l_fill_1
XFILLER_16_228 VPWR VGND sg13cmos5l_decap_8
XFILLER_0_338 VPWR VGND sg13cmos5l_fill_2
XFILLER_3_132 VPWR VGND sg13cmos5l_fill_1
X_0635_ _0638_/B hold93/X _0635_/B VPWR VGND sg13cmos5l_and2_1
X_0704_ _0704_/Y _0798_/A _1065_/A VPWR VGND sg13cmos5l_nor2_1
X_0566_ _1066_/A _0614_/A hold88/A _0563_/Y VPWR VGND sg13cmos5l_o21ai_1
X_1049_ _1049_/Y hold79/X _1063_/B VPWR VGND sg13cmos5l_nand2_1
X_1118_ hold84/A _1128_/CLK _1118_/D fanout49/X VPWR VGND sg13cmos5l_dfrbpq_1
XFILLER_8_235 VPWR VGND sg13cmos5l_fill_2
Xclkbuf_1_0__f_u_fb_div.g_stage\[2\].q_regs _0551__60/A clkbuf_0_u_fb_div.g_stage\[2\].q_regs/X
+ VPWR VGND sg13cmos5l_buf_8
X_0618_ _0779_/A _0617_/A hold62/X VPWR VGND sg13cmos5l_nand2b_1
XFILLER_17_378 VPWR VGND sg13cmos5l_fill_1
XFILLER_17_312 VPWR VGND sg13cmos5l_fill_1
XFILLER_14_337 VPWR VGND sg13cmos5l_decap_4
X_0883_ _1001_/B _0969_/A _0987_/A _0977_/B VPWR VGND sg13cmos5l_or3_1
XFILLER_9_0 VPWR VGND sg13cmos5l_decap_8
XFILLER_1_230 VPWR VGND sg13cmos5l_fill_1
X_0952_ _0952_/Y _0952_/A _0954_/B _0952_/C VPWR VGND sg13cmos5l_nand3_1
XFILLER_11_329 VPWR VGND sg13cmos5l_decap_8
XFILLER_2_7 VPWR VGND sg13cmos5l_decap_4
XFILLER_14_178 VPWR VGND sg13cmos5l_fill_1
XFILLER_14_123 VPWR VGND sg13cmos5l_decap_8
XFILLER_10_351 VPWR VGND sg13cmos5l_fill_1
XFILLER_10_340 VPWR VGND sg13cmos5l_fill_1
X_0866_ _0866_/Y _1027_/A _0866_/B VPWR VGND sg13cmos5l_nand2_1
X_1082_ _1082_/Q _1114_/CLK _1082_/D fanout54/X VPWR VGND sg13cmos5l_dfrbpq_1
Xclkbuf_0_u_fb_div.g_stage\[2\].q clkbuf_0_u_fb_div.g_stage\[2\].q/X _1101_/Q VPWR
+ VGND sg13cmos5l_buf_8
X_0935_ _0935_/Y _0961_/C _0934_/Y VPWR VGND sg13cmos5l_nor2b_1
X_0797_ _0797_/X _0797_/A _0805_/C VPWR VGND sg13cmos5l_xor2_1
X_1134_ hold66/A _1134_/CLK hold67/X fanout52/X VPWR VGND sg13cmos5l_dfrbpq_1
X_0651_ hold78/A _0809_/B hold77/X _0651_/C VPWR VGND sg13cmos5l_nor3_1
X_0720_ _0750_/B hold97/A _0720_/B _0720_/C _0777_/C VPWR VGND sg13cmos5l_nor4_1
X_1065_ _1111_/D _1065_/A _1065_/B VPWR VGND sg13cmos5l_xor2_1
XFILLER_8_68 VPWR VGND sg13cmos5l_fill_1
X_0582_ _0584_/B _0582_/A _0964_/A VPWR VGND sg13cmos5l_xnor2_1
XFILLER_6_130 VPWR VGND sg13cmos5l_fill_2
X_0849_ _0959_/A _0954_/A _0954_/B _0832_/Y VPWR VGND sg13cmos5l_a21oi_1
X_0918_ _0918_/Y _0813_/Y _0917_/Y _1023_/A VPWR VGND sg13cmos5l_a21oi_1
XFILLER_15_295 VPWR VGND sg13cmos5l_fill_2
X_0703_ _0703_/Y _0682_/Y _0702_/X _0674_/Y VPWR VGND sg13cmos5l_a21oi_1
X_0634_ hold94/A hold93/X _0635_/B VPWR VGND sg13cmos5l_nor2_1
X_1048_ hold96/A _1039_/B _1047_/Y _1045_/Y VPWR VGND sg13cmos5l_o21ai_1
X_1117_ _1117_/Q _1128_/CLK _1117_/D fanout49/X VPWR VGND sg13cmos5l_dfrbpq_1
X_0565_ hold88/A hold87/X _0565_/B VPWR VGND sg13cmos5l_xnor2_1
X_0548_ _0548_/Y hold66/A VPWR VGND sg13cmos5l_inv_1
X_0617_ _0617_/Y _0617_/A hold62/X VPWR VGND sg13cmos5l_nor2b_1
XFILLER_5_228 VPWR VGND sg13cmos5l_fill_2
XFILLER_14_316 VPWR VGND sg13cmos5l_fill_2
XFILLER_17_132 VPWR VGND sg13cmos5l_fill_1
XFILLER_13_360 VPWR VGND sg13cmos5l_fill_1
X_0882_ _0977_/B _0964_/A _0964_/B VPWR VGND sg13cmos5l_nand2b_1
XFILLER_2_26 VPWR VGND sg13cmos5l_fill_2
X_0951_ _0951_/Y fanout7/X _0950_/Y _1016_/B VPWR VGND sg13cmos5l_o21ai_1
XFILLER_6_334 VPWR VGND sg13cmos5l_fill_1
X_0865_ _0867_/B _0820_/X _0821_/Y _0864_/B _1019_/A _0818_/Y VPWR VGND sg13cmos5l_a221oi_1
X_0796_ _1081_/D hold63/X _0796_/B VPWR VGND sg13cmos5l_nor2_1
X_0934_ _0934_/Y _0934_/A _0934_/B _0934_/C VPWR VGND sg13cmos5l_nand3_1
X_1081_ hold63/A _1114_/CLK _1081_/D fanout54/X VPWR VGND sg13cmos5l_dfrbpq_1
Xclkbuf_1_1__f_u_fb_div.stage_q0_regs _0549__58/A clkbuf_0_u_fb_div.stage_q0_regs/X
+ VPWR VGND sg13cmos5l_buf_8
X_1064_ hold69/A _1094_/Q _0810_/Y _1063_/Y VPWR VGND sg13cmos5l_o21ai_1
X_0650_ _0651_/C hold76/X _0650_/B VPWR VGND sg13cmos5l_and2_1
X_1133_ hold81/A _1134_/CLK hold83/X input1/X VPWR VGND sg13cmos5l_dfrbpq_1
X_0581_ _0589_/A _0582_/A _0964_/A VPWR VGND sg13cmos5l_and2_1
X_0779_ _0779_/Y _0779_/A _0779_/B VPWR VGND sg13cmos5l_nor2_1
X_0848_ _0954_/B _0961_/A _0848_/B VPWR VGND sg13cmos5l_xnor2_1
X_0917_ _0917_/Y _0919_/A _0917_/B VPWR VGND sg13cmos5l_xnor2_1
XFILLER_3_123 VPWR VGND sg13cmos5l_decap_4
XFILLER_3_156 VPWR VGND sg13cmos5l_fill_2
X_0633_ _1086_/D _0635_/B _0633_/B VPWR VGND sg13cmos5l_nor2_1
XFILLER_17_0 VPWR VGND sg13cmos5l_decap_8
X_0702_ _0702_/X _0694_/Y _0695_/Y _0701_/Y VPWR VGND sg13cmos5l_a21o_1
X_1047_ _1047_/Y _1052_/A _1047_/B VPWR VGND sg13cmos5l_nor2_1
X_0564_ _0614_/A hold64/X _0877_/C VPWR VGND sg13cmos5l_nand2_1
X_1116_ _1116_/Q _1130_/CLK _1116_/D fanout50/X VPWR VGND sg13cmos5l_dfrbpq_1
XFILLER_5_26 VPWR VGND sg13cmos5l_fill_2
X_0616_ hold91/A _0609_/Y _0613_/B _0608_/Y VPWR VGND sg13cmos5l_o21ai_1
X_0547_ _0620_/B hold63/X VPWR VGND sg13cmos5l_inv_1
XFILLER_17_166 VPWR VGND sg13cmos5l_fill_2
XFILLER_11_309 VPWR VGND sg13cmos5l_fill_2
X_0950_ _0950_/Y _0913_/Y _0949_/Y _0948_/Y VPWR VGND sg13cmos5l_o21ai_1
X_0881_ _0964_/B _0881_/A _0881_/B _0949_/A _0881_/D VPWR VGND sg13cmos5l_nor4_1
XFILLER_14_169 VPWR VGND sg13cmos5l_fill_1
XFILLER_14_158 VPWR VGND sg13cmos5l_fill_2
XFILLER_14_147 VPWR VGND sg13cmos5l_fill_1
XFILLER_11_69 VPWR VGND sg13cmos5l_fill_1
Xclkbuf_0_clk_ref clkbuf_0_clk_ref/X clk_ref VPWR VGND sg13cmos5l_buf_8
X_0864_ _0866_/B _1019_/A _0864_/B VPWR VGND sg13cmos5l_nand2_1
XFILLER_6_346 VPWR VGND sg13cmos5l_fill_1
X_1080_ _1080_/Q _1122_/CLK hold91/X fanout46/X VPWR VGND sg13cmos5l_dfrbpq_1
X_0795_ _1095_/D _0839_/C _0790_/X _0794_/Y VPWR VGND sg13cmos5l_o21ai_1
X_0933_ _0961_/C _0934_/B _0934_/C _0934_/A VPWR VGND sg13cmos5l_a21oi_1
XFILLER_3_338 VPWR VGND sg13cmos5l_fill_2
Xclkbuf_1_1__f_u_fb_div.g_stage\[1\].q_regs _0550__59/A clkbuf_0_u_fb_div.g_stage\[1\].q_regs/X
+ VPWR VGND sg13cmos5l_buf_8
XFILLER_8_26 VPWR VGND sg13cmos5l_decap_4
X_0580_ _0580_/Y _0580_/A _0580_/B VPWR VGND sg13cmos5l_xnor2_1
XFILLER_6_132 VPWR VGND sg13cmos5l_fill_1
XFILLER_6_143 VPWR VGND sg13cmos5l_fill_1
X_1063_ _1063_/Y hold68/X _1063_/B VPWR VGND sg13cmos5l_nand2_1
X_0778_ _0821_/B _0776_/Y _0777_/X _0811_/B VPWR VGND sg13cmos5l_o21ai_1
X_1132_ hold85/A _1135_/CLK hold86/X fanout52/X VPWR VGND sg13cmos5l_dfrbpq_1
X_0847_ _0895_/A _0949_/A _0848_/B VPWR VGND sg13cmos5l_and2_1
X_0916_ _0916_/Y _0837_/A _1023_/A _0907_/Y _0915_/X VPWR VGND sg13cmos5l_a22oi_1
X_1115_ _1115_/Q _1134_/CLK _1115_/D fanout49/X VPWR VGND sg13cmos5l_dfrbpq_1
X_0632_ _0633_/B _0763_/A _0631_/B _0779_/A VPWR VGND sg13cmos5l_o21ai_1
X_0701_ _0701_/Y _0761_/A _0739_/A _0701_/C VPWR VGND sg13cmos5l_nand3_1
X_1046_ _1047_/B hold95/X _1046_/B VPWR VGND sg13cmos5l_xor2_1
X_0563_ _0563_/Y hold87/X _0565_/B VPWR VGND sg13cmos5l_nand2_1
X_1029_ _1030_/B _1126_/Q _1017_/B _0536_/Y VPWR VGND sg13cmos5l_a21oi_1
X_0546_ _0620_/A _0619_/A VPWR VGND sg13cmos5l_inv_1
X_0615_ hold65/A hold64/X _0877_/C VPWR VGND sg13cmos5l_xor2_1
XFILLER_4_230 VPWR VGND sg13cmos5l_fill_1
XFILLER_2_28 VPWR VGND sg13cmos5l_fill_1
XFILLER_17_123 VPWR VGND sg13cmos5l_decap_8
XFILLER_9_355 VPWR VGND sg13cmos5l_fill_1
X_0880_ _0949_/B _0881_/A _0881_/B _0881_/D VPWR VGND sg13cmos5l_nor3_1
XFILLER_11_26 VPWR VGND sg13cmos5l_fill_2
XFILLER_10_321 VPWR VGND sg13cmos5l_fill_2
XFILLER_9_130 VPWR VGND sg13cmos5l_fill_2
X_0932_ _0932_/Y hold73/X _0994_/B VPWR VGND sg13cmos5l_nand2_1
XFILLER_7_0 VPWR VGND sg13cmos5l_decap_8
X_0863_ _0864_/B _1035_/B _0813_/B _0862_/Y VPWR VGND sg13cmos5l_a21oi_1
X_0794_ _0794_/Y _0794_/A _0794_/B VPWR VGND sg13cmos5l_nor2_1
XFILLER_0_7 VPWR VGND sg13cmos5l_fill_2
XFILLER_3_317 VPWR VGND sg13cmos5l_fill_2
X_1062_ hold67/A _1094_/Q _0813_/Y _1061_/Y VPWR VGND sg13cmos5l_o21ai_1
X_0777_ _0777_/X _0777_/A _0777_/B _0777_/C VPWR VGND sg13cmos5l_or3_1
X_1131_ hold79/A _1134_/CLK hold80/X fanout52/X VPWR VGND sg13cmos5l_dfrbpq_1
X_0915_ _0915_/X _0867_/B _0911_/Y _0914_/Y VPWR VGND sg13cmos5l_a21o_1
X_0846_ _0954_/A _0943_/A _0844_/X _0834_/X VPWR VGND sg13cmos5l_o21ai_1
X_0631_ _0635_/B _0763_/A _0631_/B VPWR VGND sg13cmos5l_and2_1
X_0700_ _0701_/C _0684_/A _0684_/B _1085_/Q VPWR VGND sg13cmos5l_o21ai_1
X_1114_ _1114_/Q _1114_/CLK _1114_/D fanout51/X VPWR VGND sg13cmos5l_dfrbpq_1
X_0562_ _0562_/X _0567_/A _0567_/B VPWR VGND sg13cmos5l_and2_1
X_0829_ _0829_/Y _0964_/A hold79/A _0877_/D VPWR VGND sg13cmos5l_nand3_1
XFILLER_9_70 VPWR VGND sg13cmos5l_fill_2
X_1045_ _1045_/Y hold95/X _1063_/B VPWR VGND sg13cmos5l_nand2_1
XFILLER_12_235 VPWR VGND sg13cmos5l_fill_2
XFILLER_8_228 VPWR VGND sg13cmos5l_decap_8
XFILLER_5_28 VPWR VGND sg13cmos5l_fill_1
X_1028_ _1126_/D _1023_/Y _1027_/Y _1016_/Y VPWR VGND sg13cmos5l_a21o_1
XFILLER_14_26 VPWR VGND sg13cmos5l_fill_2
XFILLER_11_290 VPWR VGND sg13cmos5l_fill_1
X_0545_ _0770_/A _0757_/A VPWR VGND sg13cmos5l_inv_1
X_0614_ hold89/A _0614_/A hold88/X VPWR VGND sg13cmos5l_xor2_1
XFILLER_1_234 VPWR VGND sg13cmos5l_fill_2
XFILLER_15_91 VPWR VGND sg13cmos5l_fill_2
X_0862_ _0862_/Y _0886_/C _1006_/A _0997_/B VPWR VGND sg13cmos5l_nand3_1
XFILLER_13_193 VPWR VGND sg13cmos5l_fill_2
XFILLER_9_197 VPWR VGND sg13cmos5l_fill_2
X_0931_ _1118_/D _0928_/Y _0930_/Y _0924_/Y VPWR VGND sg13cmos5l_o21ai_1
XFILLER_3_83 VPWR VGND sg13cmos5l_fill_2
X_0793_ _0794_/B _0791_/Y _0792_/Y _0677_/B VPWR VGND sg13cmos5l_a21oi_1
XFILLER_10_130 VPWR VGND sg13cmos5l_fill_2
X_1061_ _1061_/Y hold66/X _1063_/B VPWR VGND sg13cmos5l_nand2_1
X_1130_ hold95/A _1130_/CLK hold96/X fanout52/X VPWR VGND sg13cmos5l_dfrbpq_1
X_0914_ _0914_/Y _0888_/A _0873_/Y _0911_/A _0912_/X fanout7/X VPWR VGND sg13cmos5l_a221oi_1
XFILLER_2_340 VPWR VGND sg13cmos5l_fill_1
X_0845_ _0943_/B _0881_/B _0845_/B VPWR VGND sg13cmos5l_xnor2_1
XFILLER_6_123 VPWR VGND sg13cmos5l_decap_8
XFILLER_17_26 VPWR VGND sg13cmos5l_decap_4
X_0776_ _0776_/Y _0773_/Y _0775_/X _0672_/Y VPWR VGND sg13cmos5l_a21oi_1
XFILLER_15_255 VPWR VGND sg13cmos5l_fill_2
X_0630_ _1085_/D _0796_/B _0630_/B _0631_/B VPWR VGND sg13cmos5l_nor3_1
X_0561_ _1109_/D _1109_/Q VPWR VGND sg13cmos5l_inv_1
X_0828_ _0851_/B hold79/A _0877_/D VPWR VGND sg13cmos5l_nand2_1
XFILLER_9_82 VPWR VGND sg13cmos5l_fill_1
X_0759_ _0759_/Y _0685_/Y _0692_/Y _0757_/Y VPWR VGND sg13cmos5l_o21ai_1
X_1113_ _1113_/Q _1130_/CLK _1113_/D fanout50/X VPWR VGND sg13cmos5l_dfrbpq_1
X_1044_ hold75/A _1039_/B _1043_/Y _1041_/Y VPWR VGND sg13cmos5l_o21ai_1
X_1027_ _1027_/Y _1027_/A _1027_/B VPWR VGND sg13cmos5l_nand2_1
X_0613_ _1079_/D _0613_/A _0613_/B VPWR VGND sg13cmos5l_xnor2_1
XFILLER_15_0 VPWR VGND sg13cmos5l_decap_8
X_0544_ _0544_/Y _1085_/Q VPWR VGND sg13cmos5l_inv_1
XFILLER_17_339 VPWR VGND sg13cmos5l_fill_2
Xhold90 hold90/X hold90/A VPWR VGND sg13cmos5l_dlygate4sd3_1
XFILLER_2_19 VPWR VGND sg13cmos5l_fill_2
XFILLER_11_28 VPWR VGND sg13cmos5l_fill_1
XFILLER_6_338 VPWR VGND sg13cmos5l_fill_2
X_0861_ _0861_/Y _1006_/A _0997_/B VPWR VGND sg13cmos5l_nand2_1
XFILLER_9_154 VPWR VGND sg13cmos5l_fill_1
XFILLER_9_132 VPWR VGND sg13cmos5l_fill_1
X_0792_ _0792_/Y _1104_/Q _0786_/B _0704_/Y _1106_/Q VPWR VGND sg13cmos5l_a22oi_1
X_0930_ _0930_/Y _0941_/C _0920_/A _0929_/X _0976_/B1 _0866_/Y VPWR VGND sg13cmos5l_a221oi_1
XFILLER_0_9 VPWR VGND sg13cmos5l_fill_1
XFILLER_3_319 VPWR VGND sg13cmos5l_fill_1
XFILLER_18_264 VPWR VGND sg13cmos5l_fill_1
XFILLER_18_220 VPWR VGND sg13cmos5l_fill_2
XFILLER_12_71 VPWR VGND sg13cmos5l_fill_1
X_1060_ hold83/A _1039_/B _1058_/Y hold82/X VPWR VGND sg13cmos5l_a21oi_1
X_0775_ _0775_/X _0775_/A _0775_/B VPWR VGND sg13cmos5l_and2_1
X_0913_ _0913_/Y _1030_/A _0913_/B VPWR VGND sg13cmos5l_nand2_1
X_0844_ _0844_/X _0934_/A _0845_/B VPWR VGND sg13cmos5l_and2_1
X_0758_ _0760_/B _1084_/Q _0758_/B VPWR VGND sg13cmos5l_nor2_1
X_1112_ _1112_/Q _1130_/CLK _1112_/D fanout53/X VPWR VGND sg13cmos5l_dfrbpq_1
X_0827_ _0827_/Y _0977_/A _0854_/B VPWR VGND sg13cmos5l_nor2_1
X_1043_ _1043_/Y _1052_/A _1043_/B VPWR VGND sg13cmos5l_nor2_1
X_0560_ _1108_/D _1108_/Q VPWR VGND sg13cmos5l_inv_1
XFILLER_12_259 VPWR VGND sg13cmos5l_fill_2
X_0689_ _0735_/B _0706_/S _0797_/A VPWR VGND sg13cmos5l_and2_1
XFILLER_5_19 VPWR VGND sg13cmos5l_fill_2
XFILLER_18_81 VPWR VGND sg13cmos5l_fill_2
X_0612_ _0613_/B _0606_/A _0886_/C _0611_/X VPWR VGND sg13cmos5l_o21ai_1
XFILLER_7_263 VPWR VGND sg13cmos5l_fill_2
X_0543_ _0839_/B _0877_/C VPWR VGND sg13cmos5l_inv_1
X_1026_ _1027_/B _1019_/A _0902_/C _1024_/Y _1025_/Y VPWR VGND sg13cmos5l_a22oi_1
XFILLER_14_28 VPWR VGND sg13cmos5l_fill_1
XFILLER_16_340 VPWR VGND sg13cmos5l_fill_1
Xhold80 hold80/X hold80/A VPWR VGND sg13cmos5l_dlygate4sd3_1
Xhold91 hold91/X hold91/A VPWR VGND sg13cmos5l_dlygate4sd3_1
X_1009_ _1009_/X _1009_/A _1009_/B VPWR VGND sg13cmos5l_xor2_1
XFILLER_13_332 VPWR VGND sg13cmos5l_decap_8
XFILLER_9_336 VPWR VGND sg13cmos5l_decap_4
XFILLER_1_236 VPWR VGND sg13cmos5l_fill_1
XFILLER_16_170 VPWR VGND sg13cmos5l_fill_1
Xoutput2 dac_out _1080_/Q VPWR VGND sg13cmos5l_buf_1
X_0860_ _1013_/B _0999_/A _0997_/B VPWR VGND sg13cmos5l_nand2_1
XFILLER_13_195 VPWR VGND sg13cmos5l_fill_1
X_0791_ _0791_/Y _1108_/Q _0791_/B VPWR VGND sg13cmos5l_nand2_1
X_0989_ _0990_/B _0969_/A _0977_/B _0987_/A VPWR VGND sg13cmos5l_o21ai_1
XFILLER_10_154 VPWR VGND sg13cmos5l_fill_2
XFILLER_10_132 VPWR VGND sg13cmos5l_fill_1
XFILLER_8_19 VPWR VGND sg13cmos5l_fill_2
XFILLER_2_331 VPWR VGND sg13cmos5l_decap_4
XFILLER_5_0 VPWR VGND sg13cmos5l_decap_8
X_0774_ _0775_/B _1086_/Q _0774_/B VPWR VGND sg13cmos5l_or2_1
X_0912_ _0912_/X _1030_/A _0913_/B VPWR VGND sg13cmos5l_and2_1
X_0843_ _0952_/A _0881_/B _0845_/B VPWR VGND sg13cmos5l_nand2_1
XFILLER_15_235 VPWR VGND sg13cmos5l_decap_4
X_1111_ _1111_/Q _1135_/CLK _1111_/D fanout53/X VPWR VGND sg13cmos5l_dfrbpq_1
X_1042_ _1043_/B hold92/A hold74/X VPWR VGND sg13cmos5l_xnor2_1
XFILLER_0_64 VPWR VGND sg13cmos5l_fill_1
X_0688_ _0797_/A _0798_/A _1065_/A VPWR VGND sg13cmos5l_xnor2_1
X_0826_ _0854_/B hold85/A _0870_/B VPWR VGND sg13cmos5l_nand2_1
X_0757_ _0757_/Y _0757_/A _0758_/B VPWR VGND sg13cmos5l_nand2_1
X_0611_ _0611_/X _0606_/A _0886_/C _0607_/A VPWR VGND sg13cmos5l_a21o_1
X_0542_ _0837_/A _0565_/B VPWR VGND sg13cmos5l_inv_1
X_1025_ _1025_/Y _1016_/A _0861_/Y _0864_/B _0902_/A VPWR VGND sg13cmos5l_a22oi_1
X_0809_ _1063_/B _1094_/Q _0809_/B VPWR VGND sg13cmos5l_nand2b_1
Xhold70 hold70/X hold70/A VPWR VGND sg13cmos5l_dlygate4sd3_1
Xhold81 hold81/X hold81/A VPWR VGND sg13cmos5l_dlygate4sd3_1
Xhold92 hold92/X hold92/A VPWR VGND sg13cmos5l_dlygate4sd3_1
XFILLER_4_234 VPWR VGND sg13cmos5l_fill_2
XFILLER_6_30 VPWR VGND sg13cmos5l_fill_1
X_1008_ _1008_/Y _1017_/B _1007_/Y _0874_/X VPWR VGND sg13cmos5l_o21ai_1
Xoutput3 vctrl_b_out _1136_/X VPWR VGND sg13cmos5l_buf_1
XFILLER_11_19 VPWR VGND sg13cmos5l_fill_2
XFILLER_10_336 VPWR VGND sg13cmos5l_decap_4
XFILLER_13_130 VPWR VGND sg13cmos5l_decap_4
XFILLER_9_123 VPWR VGND sg13cmos5l_decap_8
X_0790_ _0790_/X _1109_/D _1103_/D _0790_/S VPWR VGND sg13cmos5l_mux2_1
XFILLER_5_340 VPWR VGND sg13cmos5l_fill_1
XFILLER_5_351 VPWR VGND sg13cmos5l_fill_2
X_0988_ _0988_/Y _1006_/B _0987_/Y _0874_/X VPWR VGND sg13cmos5l_o21ai_1
XFILLER_2_376 VPWR VGND sg13cmos5l_fill_2
XFILLER_18_222 VPWR VGND sg13cmos5l_fill_1
X_0773_ _0773_/Y _0768_/Y _0771_/Y _0772_/Y VPWR VGND sg13cmos5l_o21ai_1
X_0911_ _0911_/Y _0911_/A _0920_/A VPWR VGND sg13cmos5l_nand2_1
X_0842_ _0943_/A _0891_/B _0929_/S _0941_/A VPWR VGND sg13cmos5l_a21o_1
X_1041_ _1041_/Y hold74/X _1063_/B VPWR VGND sg13cmos5l_nand2_1
X_1110_ _1110_/Q _1105_/Q _1110_/D fanout51/X VPWR VGND sg13cmos5l_dfrbpq_1
XFILLER_0_21 VPWR VGND sg13cmos5l_fill_1
XFILLER_12_228 VPWR VGND sg13cmos5l_decap_8
X_0825_ _0825_/Y _0987_/A hold81/A _0870_/B VPWR VGND sg13cmos5l_nand3_1
X_0756_ _0760_/A _1085_/Q _0761_/B VPWR VGND sg13cmos5l_nor2_1
X_0687_ _0687_/Y _0687_/A _0687_/B VPWR VGND sg13cmos5l_nand2_1
XFILLER_18_83 VPWR VGND sg13cmos5l_fill_1
X_1024_ _1024_/Y _1016_/A _0901_/C _1030_/A VPWR VGND sg13cmos5l_o21ai_1
X_0541_ _1016_/A _0886_/C VPWR VGND sg13cmos5l_inv_1
X_0610_ _0613_/A _0902_/A hold90/X VPWR VGND sg13cmos5l_xnor2_1
XFILLER_14_19 VPWR VGND sg13cmos5l_decap_8
X_0808_ _1035_/B _0753_/A _0753_/B _0779_/Y _0780_/Y _0779_/A VPWR VGND sg13cmos5l_a221oi_1
X_0739_ _0740_/B _0739_/A _0739_/B VPWR VGND sg13cmos5l_nand2_1
Xhold71 hold71/X hold71/A VPWR VGND sg13cmos5l_dlygate4sd3_1
Xhold93 hold93/X hold93/A VPWR VGND sg13cmos5l_dlygate4sd3_1
XFILLER_16_331 VPWR VGND sg13cmos5l_decap_4
Xhold82 hold82/X hold82/A VPWR VGND sg13cmos5l_dlygate4sd3_1
XFILLER_6_97 VPWR VGND sg13cmos5l_fill_2
X_1007_ _1007_/Y _0999_/A _1006_/B _1125_/Q VPWR VGND sg13cmos5l_a21oi_1
XFILLER_13_0 VPWR VGND sg13cmos5l_decap_8
XFILLER_0_282 VPWR VGND sg13cmos5l_fill_1
Xoutput4 vctrl_out _1137_/X VPWR VGND sg13cmos5l_buf_1
XFILLER_13_175 VPWR VGND sg13cmos5l_fill_2
XFILLER_9_113 VPWR VGND sg13cmos5l_fill_2
X_0987_ _0987_/Y _0987_/A _0987_/B VPWR VGND sg13cmos5l_nor2_1
XFILLER_3_21 VPWR VGND sg13cmos5l_fill_1
XFILLER_10_145 VPWR VGND sg13cmos5l_fill_1
XFILLER_10_123 VPWR VGND sg13cmos5l_decap_8
X_0910_ _0910_/Y _0889_/Y _0901_/C _1021_/A VPWR VGND sg13cmos5l_a21oi_1
X_0772_ _0772_/Y _0763_/A _0774_/B _0769_/Y _1085_/Q VPWR VGND sg13cmos5l_a22oi_1
X_0841_ _0934_/C _0941_/A _0929_/S VPWR VGND sg13cmos5l_or2_1
XFILLER_17_19 VPWR VGND sg13cmos5l_fill_2
XFILLER_17_7 VPWR VGND sg13cmos5l_decap_4
X_1040_ _1128_/D hold92/X _1063_/B _1039_/Y VPWR VGND sg13cmos5l_a21o_1
XFILLER_2_130 VPWR VGND sg13cmos5l_decap_4
XFILLER_2_163 VPWR VGND sg13cmos5l_fill_2
XFILLER_14_281 VPWR VGND sg13cmos5l_fill_2
X_0755_ _0761_/B _0763_/B _0774_/B VPWR VGND sg13cmos5l_nor2_1
X_0824_ _0857_/B hold81/A _0870_/B VPWR VGND sg13cmos5l_nand2_1
X_0686_ _0687_/B _0790_/S _0697_/C _0807_/A VPWR VGND sg13cmos5l_nand3_1
X_0550__59 _1107_/D _0550__59/A VPWR VGND sg13cmos5l_inv_1
X_1023_ _1023_/Y _1023_/A _1023_/B VPWR VGND sg13cmos5l_nor2_1
X_0540_ _0977_/A _0969_/A VPWR VGND sg13cmos5l_inv_1
XFILLER_7_233 VPWR VGND sg13cmos5l_decap_4
X_0738_ _0739_/B _0706_/S _0704_/Y _0684_/B VPWR VGND sg13cmos5l_a21oi_1
Xfanout5 _0920_/A _0910_/Y VPWR VGND sg13cmos5l_buf_1
X_0669_ _0769_/A _0677_/B _0742_/A VPWR VGND sg13cmos5l_nand2_1
X_0807_ _1114_/D _0807_/A _0807_/B VPWR VGND sg13cmos5l_xnor2_1
Xhold94 hold94/X hold94/A VPWR VGND sg13cmos5l_dlygate4sd3_1
Xhold72 hold72/X hold72/A VPWR VGND sg13cmos5l_dlygate4sd3_1
Xhold83 hold83/X hold83/A VPWR VGND sg13cmos5l_dlygate4sd3_1
XFILLER_4_236 VPWR VGND sg13cmos5l_fill_1
Xhold61 hold61/X hold61/A VPWR VGND sg13cmos5l_dlygate4sd3_1
XFILLER_6_21 VPWR VGND sg13cmos5l_fill_1
X_1006_ _1017_/B _1006_/A _1006_/B VPWR VGND sg13cmos5l_and2_1
XFILLER_1_228 VPWR VGND sg13cmos5l_fill_2
XFILLER_13_346 VPWR VGND sg13cmos5l_fill_2
XFILLER_8_350 VPWR VGND sg13cmos5l_fill_2
XFILLER_10_349 VPWR VGND sg13cmos5l_fill_2
XFILLER_13_165 VPWR VGND sg13cmos5l_fill_1
XFILLER_9_103 VPWR VGND sg13cmos5l_fill_1
XFILLER_5_353 VPWR VGND sg13cmos5l_fill_1
X_0986_ _1006_/B _0986_/A _0961_/C VPWR VGND sg13cmos5l_nor2b_1
XFILLER_18_235 VPWR VGND sg13cmos5l_fill_2
XFILLER_18_202 VPWR VGND sg13cmos5l_fill_1
Xclkbuf_3_7__f_clk_ref _1090_/CLK clkbuf_0_clk_ref/X VPWR VGND sg13cmos5l_buf_8
X_0771_ _0771_/Y _1085_/Q _0769_/Y _0770_/Y VPWR VGND sg13cmos5l_o21ai_1
XFILLER_2_378 VPWR VGND sg13cmos5l_fill_1
X_0840_ _0840_/Y _0941_/A _0929_/S VPWR VGND sg13cmos5l_nor2_1
X_0969_ _0969_/Y _0969_/A _0994_/B VPWR VGND sg13cmos5l_nand2_1
XFILLER_3_0 VPWR VGND sg13cmos5l_decap_8
X_0823_ _1006_/A _0999_/A _1009_/A VPWR VGND sg13cmos5l_and2_1
X_0754_ _0754_/Y _0777_/B _0777_/C VPWR VGND sg13cmos5l_nor2_1
XFILLER_9_21 VPWR VGND sg13cmos5l_fill_1
X_0685_ _0685_/Y _0729_/A _0685_/B VPWR VGND sg13cmos5l_nor2_1
X_1099_ _1099_/Q _1110_/Q _1099_/D fanout50/X VPWR VGND sg13cmos5l_dfrbpq_1
X_1022_ _1023_/B _1027_/A _1022_/B _1022_/C VPWR VGND sg13cmos5l_nor3_1
Xfanout6 _1027_/A fanout7/X VPWR VGND sg13cmos5l_buf_1
X_0599_ _0600_/B _0599_/A _0598_/Y VPWR VGND sg13cmos5l_nor2b_1
X_0668_ _0680_/B _0706_/S _0786_/B _0684_/B VPWR VGND sg13cmos5l_a21o_1
X_0737_ _0737_/Y _0731_/Y _0734_/Y _0736_/Y VPWR VGND sg13cmos5l_o21ai_1
X_0806_ _0807_/B _0804_/Y _0805_/X _1065_/B VPWR VGND sg13cmos5l_o21ai_1
Xhold95 hold95/X hold95/A VPWR VGND sg13cmos5l_dlygate4sd3_1
Xhold73 hold73/X hold73/A VPWR VGND sg13cmos5l_dlygate4sd3_1
Xhold84 hold84/X hold84/A VPWR VGND sg13cmos5l_dlygate4sd3_1
Xhold62 hold62/X hold62/A VPWR VGND sg13cmos5l_dlygate4sd3_1
X_1005_ _1005_/Y _1009_/A _1023_/A VPWR VGND sg13cmos5l_nand2_1
XFILLER_13_358 VPWR VGND sg13cmos5l_fill_2
XFILLER_9_329 VPWR VGND sg13cmos5l_decap_8
XFILLER_16_130 VPWR VGND sg13cmos5l_fill_2
XFILLER_8_340 VPWR VGND sg13cmos5l_fill_1
.ends

************************************************************************
*
* Copyright 2023 IHP PDK Authors
*
* Licensed under the Apache License, Version 2.0 (the "License");
* you may not use this file except in compliance with the License.
* You may obtain a copy of the License at
*
*    https://www.apache.org/licenses/LICENSE-2.0
*
* Unless required by applicable law or agreed to in writing, software
* distributed under the License is distributed on an "AS IS" BASIS,
* WITHOUT WARRANTIES OR CONDITIONS OF ANY KIND, either express or implied.
* See the License for the specific language governing permissions and
* limitations under the License.
*
************************************************************************

************************************************************************
* Library Name: sg13cmos5l_stdcell
* Cell Name:    sg13cmos5l_a21o_1
* View Name:    schematic
************************************************************************

.SUBCKT sg13cmos5l_a21o_1 X A1 A2 B1 VDD VSS
*.PININFO A1:I A2:I B1:I X:O VDD:B VSS:B
MN0 net1 A1 net2 VSS sg13_lv_nmos m=1 w=640.00n l=130.00n ng=1
MN1 net2 A2 VSS VSS sg13_lv_nmos m=1 w=640.00n l=130.00n ng=1
MN2 net1 B1 VSS VSS sg13_lv_nmos m=1 w=640.00n l=130.00n ng=1
MN3 X net1 VSS VSS sg13_lv_nmos m=1 w=740.00n l=130.00n ng=1
MP2 net1 B1 net3 VDD sg13_lv_pmos m=1 w=1.000u l=130.00n ng=1
MP0 net3 A1 VDD VDD sg13_lv_pmos m=1 w=1.000u l=130.00n ng=1
MP1 net3 A2 VDD VDD sg13_lv_pmos m=1 w=1.000u l=130.00n ng=1
MP3 X net1 VDD VDD sg13_lv_pmos m=1 w=1.12u l=130.00n ng=1
.ENDS

************************************************************************
* Library Name: sg13cmos5l_stdcell
* Cell Name:    sg13cmos5l_a21o_2
* View Name:    schematic
************************************************************************

.SUBCKT sg13cmos5l_a21o_2 X A1 A2 B1 VDD VSS
*.PININFO A1:I A2:I B1:I X:O VDD:B VSS:B
MN0 net1 A1 net2 VSS sg13_lv_nmos m=1 w=740.00n l=130.00n ng=1
MN1 net2 A2 VSS VSS sg13_lv_nmos m=1 w=740.00n l=130.00n ng=1
MN2 net1 B1 VSS VSS sg13_lv_nmos m=1 w=740.00n l=130.00n ng=1
MN3 X net1 VSS VSS sg13_lv_nmos m=1 w=1.48u l=130.00n ng=2
MP2 net1 B1 net3 VDD sg13_lv_pmos m=1 w=1.000u l=130.00n ng=1
MP0 net3 A1 VDD VDD sg13_lv_pmos m=1 w=1.000u l=130.00n ng=1
MP1 net3 A2 VDD VDD sg13_lv_pmos m=1 w=1.000u l=130.00n ng=1
MP3 X net1 VDD VDD sg13_lv_pmos m=1 w=2.24u l=130.00n ng=2
.ENDS

************************************************************************
* Library Name: sg13cmos5l_stdcell
* Cell Name:    sg13cmos5l_a21oi_1
* View Name:    schematic
************************************************************************

.SUBCKT sg13cmos5l_a21oi_1 Y A1 A2 B1 VDD VSS
*.PININFO A1:I A2:I B1:I Y:O VDD:B VSS:B
MN0 Y B1 VSS VSS sg13_lv_nmos m=1 w=740.00n l=130.00n ng=1
MN2 net1 A2 VSS VSS sg13_lv_nmos m=1 w=740.00n l=130.00n ng=1
MN1 Y A1 net1 VSS sg13_lv_nmos m=1 w=740.00n l=130.00n ng=1
MP2 Y B1 net2 VDD sg13_lv_pmos m=1 w=1.12u l=130.00n ng=1
MP1 net2 A2 VDD VDD sg13_lv_pmos m=1 w=1.12u l=130.00n ng=1
MP0 net2 A1 VDD VDD sg13_lv_pmos m=1 w=1.12u l=130.00n ng=1
.ENDS

************************************************************************
* Library Name: sg13cmos5l_stdcell
* Cell Name:    sg13cmos5l_a21oi_2
* View Name:    schematic
************************************************************************

.SUBCKT sg13cmos5l_a21oi_2 Y A1 A2 B1 VDD VSS
*.PININFO A1:I A2:I B1:I Y:O VDD:B VSS:B
MN0 Y B1 VSS VSS sg13_lv_nmos m=1 w=1.48u l=130.00n ng=2
MN2 net2 A2 VSS VSS sg13_lv_nmos m=1 w=1.48u l=130.00n ng=2
MN1 Y A1 net2 VSS sg13_lv_nmos m=1 w=1.48u l=130.00n ng=2
MP2 Y B1 net1 VDD sg13_lv_pmos m=1 w=2.24u l=130.00n ng=2
MP1 net1 A2 VDD VDD sg13_lv_pmos m=1 w=2.24u l=130.00n ng=2
MP0 net1 A1 VDD VDD sg13_lv_pmos m=1 w=2.24u l=130.00n ng=2
.ENDS

************************************************************************
* Library Name: sg13cmos5l_stdcell
* Cell Name:    sg13cmos5l_a221oi_1
* View Name:    schematic
************************************************************************

.SUBCKT sg13cmos5l_a221oi_1 Y A1 A2 B1 B2 C1 VDD VSS
*.PININFO A1:I A2:I B1:I B2:I C1:I Y:O VDD:B VSS:B
MP2 Y C1 net3 VDD sg13_lv_pmos m=1 w=1.12u l=130.00n ng=1
MP4 net3 B2 net1 VDD sg13_lv_pmos m=1 w=1.12u l=130.00n ng=1
MP1 net3 B1 net1 VDD sg13_lv_pmos m=1 w=1.12u l=130.00n ng=1
MP3 net1 A2 VDD VDD sg13_lv_pmos m=1 w=1.12u l=130.00n ng=1
MP0 net1 A1 VDD VDD sg13_lv_pmos m=1 w=1.12u l=130.00n ng=1
MN4 Y C1 VSS VSS sg13_lv_nmos m=1 w=740.00n l=130.00n ng=1
MN3 net4 B2 VSS VSS sg13_lv_nmos m=1 w=740.00n l=130.00n ng=1
MN2 Y B1 net4 VSS sg13_lv_nmos m=1 w=740.00n l=130.00n ng=1
MN1 net2 A2 VSS VSS sg13_lv_nmos m=1 w=740.00n l=130.00n ng=1
MN0 Y A1 net2 VSS sg13_lv_nmos m=1 w=740.00n l=130.00n ng=1
.ENDS

************************************************************************
* Library Name: sg13cmos5l_stdcell
* Cell Name:    sg13cmos5l_and2_1
* View Name:    schematic
************************************************************************

.SUBCKT sg13cmos5l_and2_1 X A B VDD VSS
*.PININFO A:I B:I X:O VDD:B VSS:B
MN0 net4 A net2 VSS sg13_lv_nmos m=1 w=640.00n l=130.00n ng=1
MN2 X net4 VSS VSS sg13_lv_nmos m=1 w=740.00n l=130.00n ng=1
MN1 net2 B VSS VSS sg13_lv_nmos m=1 w=640.00n l=130.00n ng=1
MP0 net4 B VDD VDD sg13_lv_pmos m=1 w=840.00n l=130.00n ng=1
MP2 X net4 VDD VDD sg13_lv_pmos m=1 w=1.12u l=130.00n ng=1
MP1 net4 A VDD VDD sg13_lv_pmos m=1 w=840.00n l=130.00n ng=1
.ENDS

************************************************************************
* Library Name: sg13cmos5l_stdcell
* Cell Name:    sg13cmos5l_and2_2
* View Name:    schematic
************************************************************************

.SUBCKT sg13cmos5l_and2_2 X A B VDD VSS
*.PININFO A:I B:I X:O VDD:B VSS:B
MN0 net1 A net2 VSS sg13_lv_nmos m=1 w=640.00n l=130.00n ng=1
MN2 X net1 VSS VSS sg13_lv_nmos m=1 w=1.48u l=130.00n ng=2
MN1 net2 B VSS VSS sg13_lv_nmos m=1 w=640.00n l=130.00n ng=1
MP0 net1 B VDD VDD sg13_lv_pmos m=1 w=840.00n l=130.00n ng=1
MP2 X net1 VDD VDD sg13_lv_pmos m=1 w=2.24u l=130.00n ng=2
MP1 net1 A VDD VDD sg13_lv_pmos m=1 w=840.00n l=130.00n ng=1
.ENDS

************************************************************************
* Library Name: sg13cmos5l_stdcell
* Cell Name:    sg13cmos5l_and3_1
* View Name:    schematic
************************************************************************

.SUBCKT sg13cmos5l_and3_1 X A B C VDD VSS
*.PININFO A:I B:I C:I X:O VDD:B VSS:B
MN2 net3 C VSS VSS sg13_lv_nmos m=1 w=640.00n l=130.00n ng=1
MN3 X net2 VSS VSS sg13_lv_nmos m=1 w=740.00n l=130.00n ng=1
MN0 net2 A net1 VSS sg13_lv_nmos m=1 w=640.00n l=130.00n ng=1
MN1 net1 B net3 VSS sg13_lv_nmos m=1 w=640.00n l=130.00n ng=1
MP3 X net2 VDD VDD sg13_lv_pmos m=1 w=1.12u l=130.00n ng=1
MP1 net2 B VDD VDD sg13_lv_pmos m=1 w=840.00n l=130.00n ng=1
MP2 net2 A VDD VDD sg13_lv_pmos m=1 w=840.00n l=130.00n ng=1
MP0 net2 C VDD VDD sg13_lv_pmos m=1 w=840.00n l=130.00n ng=1
.ENDS

************************************************************************
* Library Name: sg13cmos5l_stdcell
* Cell Name:    sg13cmos5l_and3_2
* View Name:    schematic
************************************************************************

.SUBCKT sg13cmos5l_and3_2 X A B C VDD VSS
*.PININFO A:I B:I C:I X:O VDD:B VSS:B
MN2 net3 C VSS VSS sg13_lv_nmos m=1 w=640.00n l=130.00n ng=1
MN3 X net2 VSS VSS sg13_lv_nmos m=1 w=1.48u l=130.00n ng=2
MN0 net2 A net1 VSS sg13_lv_nmos m=1 w=640.00n l=130.00n ng=1
MN1 net1 B net3 VSS sg13_lv_nmos m=1 w=640.00n l=130.00n ng=1
MP3 X net2 VDD VDD sg13_lv_pmos m=1 w=2.24u l=130.00n ng=2
MP1 net2 B VDD VDD sg13_lv_pmos m=1 w=840.00n l=130.00n ng=1
MP2 net2 A VDD VDD sg13_lv_pmos m=1 w=840.00n l=130.00n ng=1
MP0 net2 C VDD VDD sg13_lv_pmos m=1 w=840.00n l=130.00n ng=1
.ENDS

************************************************************************
* Library Name: sg13cmos5l_stdcell
* Cell Name:    sg13cmos5l_and4_1
* View Name:    schematic
************************************************************************

.SUBCKT sg13cmos5l_and4_1 X A B C D VDD VSS
*.PININFO A:I B:I C:I D:I X:O VDD:B VSS:B
MN3 net17 D VSS VSS sg13_lv_nmos m=1 w=640.00n l=130.00n ng=1
MN2 net16 C net17 VSS sg13_lv_nmos m=1 w=640.00n l=130.00n ng=1
MN1 net15 B net16 VSS sg13_lv_nmos m=1 w=640.00n l=130.00n ng=1
MN0 net1 A net15 VSS sg13_lv_nmos m=1 w=640.00n l=130.00n ng=1
MN4 X net1 VSS VSS sg13_lv_nmos m=1 w=740.00n l=130.00n ng=1
MP3 net1 A VDD VDD sg13_lv_pmos m=1 w=840.00n l=130.00n ng=1
MP4 X net1 VDD VDD sg13_lv_pmos m=1 w=1.12u l=130.00n ng=1
MP0 net1 D VDD VDD sg13_lv_pmos m=1 w=840.00n l=130.00n ng=1
MP1 net1 C VDD VDD sg13_lv_pmos m=1 w=840.00n l=130.00n ng=1
MP2 net1 B VDD VDD sg13_lv_pmos m=1 w=840.00n l=130.00n ng=1
.ENDS

************************************************************************
* Library Name: sg13cmos5l_stdcell
* Cell Name:    sg13cmos5l_and4_2
* View Name:    schematic
************************************************************************

.SUBCKT sg13cmos5l_and4_2 X A B C D VDD VSS
*.PININFO A:I B:I C:I D:I X:O VDD:B VSS:B
MN3 net17 D VSS VSS sg13_lv_nmos m=1 w=640.00n l=130.00n ng=1
MN2 net16 C net17 VSS sg13_lv_nmos m=1 w=640.00n l=130.00n ng=1
MN1 net15 B net16 VSS sg13_lv_nmos m=1 w=640.00n l=130.00n ng=1
MN0 net1 A net15 VSS sg13_lv_nmos m=1 w=640.00n l=130.00n ng=1
MN4 X net1 VSS VSS sg13_lv_nmos m=1 w=1.48u l=130.00n ng=2
MP3 net1 A VDD VDD sg13_lv_pmos m=1 w=840.00n l=130.00n ng=1
MP4 X net1 VDD VDD sg13_lv_pmos m=1 w=2.24u l=130.00n ng=2
MP0 net1 D VDD VDD sg13_lv_pmos m=1 w=840.00n l=130.00n ng=1
MP1 net1 C VDD VDD sg13_lv_pmos m=1 w=840.00n l=130.00n ng=1
MP2 net1 B VDD VDD sg13_lv_pmos m=1 w=840.00n l=130.00n ng=1
.ENDS

************************************************************************
* Library Name: sg13cmos5l_stdcell
* Cell Name:    sg13cmos5l_antennanp
* View Name:    schematic
************************************************************************

.SUBCKT sg13cmos5l_antennanp A VDD VSS
*.PININFO A:I VDD:B VSS:B
DD1 VSS A dantenna m=1 w=780n l=780n a=608.4f p=3.12u
DD0 A VDD dpantenna m=1 w=1.05u l=1.34u a=1.407p p=4.78u
.ENDS

************************************************************************
* Library Name: sg13cmos5l_stdcell
* Cell Name:    sg13cmos5l_buf_1
* View Name:    schematic
************************************************************************

.SUBCKT sg13cmos5l_buf_1 X A VDD VSS
*.PININFO A:I X:O VDD:B VSS:B
MN0 net1 A VSS VSS sg13_lv_nmos m=1 w=550.00n l=130.00n ng=1
MN1 X net1 VSS VSS sg13_lv_nmos m=1 w=740.00n l=130.00n ng=1
MP1 X net1 VDD VDD sg13_lv_pmos m=1 w=1.12u l=130.00n ng=1
MP0 net1 A VDD VDD sg13_lv_pmos m=1 w=840.00n l=130.00n ng=1
.ENDS

************************************************************************
* Library Name: sg13cmos5l_stdcell
* Cell Name:    sg13cmos5l_buf_16
* View Name:    schematic
************************************************************************

.SUBCKT sg13cmos5l_buf_16 X A VDD VSS
*.PININFO A:I X:O VDD:B VSS:B
MN0 net1 A VSS VSS sg13_lv_nmos m=1 w=4.44u l=130.00n ng=6
MN1 X net1 VSS VSS sg13_lv_nmos m=1 w=11.84u l=130.00n ng=16
MP1 X net1 VDD VDD sg13_lv_pmos m=1 w=17.92u l=130.00n ng=16
MP0 net1 A VDD VDD sg13_lv_pmos m=1 w=6.72u l=130.00n ng=6
.ENDS

************************************************************************
* Library Name: sg13cmos5l_stdcell
* Cell Name:    sg13cmos5l_buf_2
* View Name:    schematic
************************************************************************

.SUBCKT sg13cmos5l_buf_2 X A VDD VSS
*.PININFO A:I X:O VDD:B VSS:B
MN0 net1 A VSS VSS sg13_lv_nmos m=1 w=640.00n l=130.00n ng=1
MN1 X net1 VSS VSS sg13_lv_nmos m=1 w=1.48u l=130.00n ng=2
MP1 X net1 VDD VDD sg13_lv_pmos m=1 w=2.24u l=130.00n ng=2
MP0 net1 A VDD VDD sg13_lv_pmos m=1 w=1.000u l=130.00n ng=1
.ENDS

************************************************************************
* Library Name: sg13cmos5l_stdcell
* Cell Name:    sg13cmos5l_buf_4
* View Name:    schematic
************************************************************************

.SUBCKT sg13cmos5l_buf_4 X A VDD VSS
*.PININFO A:I X:O VDD:B VSS:B
MN0 net1 A VSS VSS sg13_lv_nmos m=1 w=740.00n l=130.00n ng=1
MN1 X net1 VSS VSS sg13_lv_nmos m=1 w=2.96u l=130.00n ng=4
MP1 X net1 VDD VDD sg13_lv_pmos m=1 w=4.48u l=130.00n ng=4
MP0 net1 A VDD VDD sg13_lv_pmos m=1 w=1.68u l=130.00n ng=2
.ENDS

************************************************************************
* Library Name: sg13cmos5l_stdcell
* Cell Name:    sg13cmos5l_buf_8
* View Name:    schematic
************************************************************************

.SUBCKT sg13cmos5l_buf_8 X A VDD VSS
*.PININFO A:I X:O VDD:B VSS:B
MN0 net1 A VSS VSS sg13_lv_nmos m=1 w=2.22u l=130.00n ng=3
MN1 X net1 VSS VSS sg13_lv_nmos m=1 w=5.92u l=130.00n ng=8
MP1 X net1 VDD VDD sg13_lv_pmos m=1 w=8.96u l=130.00n ng=8
MP0 net1 A VDD VDD sg13_lv_pmos m=1 w=3.36u l=130.00n ng=3
.ENDS

************************************************************************
* Library Name: sg13cmos5l_stdcell
* Cell Name:    sg13cmos5l_decap_4
* View Name:    schematic
************************************************************************

.SUBCKT sg13cmos5l_decap_4 VDD VSS
*.PININFO VDD:B VSS:B
MN0 VSS VDD VSS VSS sg13_lv_nmos m=1 w=420.00n l=1.000u ng=1
MP0 VDD VSS VDD VDD sg13_lv_pmos m=1 w=1.000u l=1.000u ng=1
.ENDS

************************************************************************
* Library Name: sg13cmos5l_stdcell
* Cell Name:    sg13cmos5l_decap_8
* View Name:    schematic
************************************************************************

.SUBCKT sg13cmos5l_decap_8 VDD VSS
*.PININFO VDD:B VSS:B
MN0 VSS VDD VSS VSS sg13_lv_nmos m=1 w=840.00n l=1.000u ng=2
MP0 VDD VSS VDD VDD sg13_lv_pmos m=1 w=2.000u l=1.000u ng=2
.ENDS

************************************************************************
* Library Name: sg13cmos5l_stdcell
* Cell Name:    sg13cmos5l_dfrbp_1
* View Name:    schematic
************************************************************************

.SUBCKT sg13cmos5l_dfrbp_1 Q Q_N CLK D RESET_B VDD VSS
*.PININFO CLK:I D:I RESET_B:I Q:O Q_N:O VDD:B VSS:B
MN11 net12 net2 VSS VSS sg13_lv_nmos m=1 w=420.00n l=130.00n ng=1
MN10 net5 clkneg net12 VSS sg13_lv_nmos m=1 w=420.00n l=130.00n ng=1
MN12 net2 net5 net11 VSS sg13_lv_nmos m=1 w=420.00n l=130.00n ng=1
MN13 net11 RESET_B VSS VSS sg13_lv_nmos m=1 w=420.00n l=130.00n ng=1
MN14 Q_N net5 VSS VSS sg13_lv_nmos m=1 w=740.00n l=130.00n ng=1
MN0 Db D net10 VSS sg13_lv_nmos m=1 w=420.00n l=130.00n ng=1
MN1 net10 RESET_B VSS VSS sg13_lv_nmos m=1 w=420.00n l=130.00n ng=1
MN4 Db clkneg net6 VSS sg13_lv_nmos m=1 w=420.00n l=130.00n ng=1
MN5 net6 clkpos net9 VSS sg13_lv_nmos m=1 w=420.00n l=130.00n ng=1
MN6 net9 net4 net8 VSS sg13_lv_nmos m=1 w=420.00n l=130.00n ng=1
MN7 net8 RESET_B VSS VSS sg13_lv_nmos m=1 w=420.00n l=130.00n ng=1
MN8 net4 net6 VSS VSS sg13_lv_nmos m=1 w=740.00n l=130.00n ng=1
MN2 clkneg CLK VSS VSS sg13_lv_nmos m=1 w=740.00n l=130.00n ng=1
MN9 net4 clkpos net5 VSS sg13_lv_nmos m=1 w=740.00n l=130.00n ng=1
MN3 clkpos clkneg VSS VSS sg13_lv_nmos m=1 w=740.00n l=130.00n ng=1
MN16 Q net1 VSS VSS sg13_lv_nmos m=1 w=740.00n l=130.00n ng=1
MN15 net1 net5 VSS VSS sg13_lv_nmos m=1 w=740.00n l=130.00n ng=1
MP11 net5 clkpos net3 VDD sg13_lv_pmos m=1 w=420.00n l=130.00n ng=1
MP12 net2 net5 VDD VDD sg13_lv_pmos m=1 w=420.00n l=130.00n ng=1
MP13 net2 RESET_B VDD VDD sg13_lv_pmos m=1 w=420.00n l=130.00n ng=1
MP14 Q_N net5 VDD VDD sg13_lv_pmos m=1 w=1.12u l=130.00n ng=1
MP4 Db clkpos net6 VDD sg13_lv_pmos m=1 w=420.00n l=130.00n ng=1
MP0 Db RESET_B VDD VDD sg13_lv_pmos m=1 w=420.00n l=130.00n ng=1
MP1 Db D VDD VDD sg13_lv_pmos m=1 w=420.00n l=130.00n ng=1
MP5 net7 net4 VDD VDD sg13_lv_pmos m=1 w=420.00n l=130.00n ng=1
MP6 net6 clkneg net7 VDD sg13_lv_pmos m=1 w=420.00n l=130.00n ng=1
MP7 net6 RESET_B VDD VDD sg13_lv_pmos m=1 w=420.00n l=130.00n ng=1
MP2 clkneg CLK VDD VDD sg13_lv_pmos m=1 w=1.12u l=130.00n ng=1
MP3 clkpos clkneg VDD VDD sg13_lv_pmos m=1 w=1.12u l=130.00n ng=1
MP8 net4 net6 VDD VDD sg13_lv_pmos m=1 w=1.000u l=130.00n ng=1
MP9 net4 clkneg net5 VDD sg13_lv_pmos m=1 w=1.000u l=130.00n ng=1
MP16 Q net1 VDD VDD sg13_lv_pmos m=1 w=1.12u l=130.00n ng=1
MP10 net3 net2 VDD VDD sg13_lv_pmos m=1 w=420.00n l=130.00n ng=1
MP15 net1 net5 VDD VDD sg13_lv_pmos m=1 w=1.12u l=130.00n ng=1
.ENDS

************************************************************************
* Library Name: sg13cmos5l_stdcell
* Cell Name:    sg13cmos5l_dfrbp_2
* View Name:    schematic
************************************************************************

.SUBCKT sg13cmos5l_dfrbp_2 Q Q_N CLK D RESET_B VDD VSS
*.PININFO CLK:I D:I RESET_B:I Q:O Q_N:O VDD:B VSS:B
MN11 net12 net2 VSS VSS sg13_lv_nmos m=1 w=420.00n l=130.00n ng=1
MN10 net5 clkneg net12 VSS sg13_lv_nmos m=1 w=420.00n l=130.00n ng=1
MN12 net2 net5 net11 VSS sg13_lv_nmos m=1 w=420.00n l=130.00n ng=1
MN13 net11 RESET_B VSS VSS sg13_lv_nmos m=1 w=420.00n l=130.00n ng=1
MN14 Q_N net5 VSS VSS sg13_lv_nmos m=1 w=1.48u l=130.00n ng=2
MN0 Db D net10 VSS sg13_lv_nmos m=1 w=420.00n l=130.00n ng=1
MN1 net10 RESET_B VSS VSS sg13_lv_nmos m=1 w=420.00n l=130.00n ng=1
MN4 Db clkneg net6 VSS sg13_lv_nmos m=1 w=420.00n l=130.00n ng=1
MN5 net6 clkpos net9 VSS sg13_lv_nmos m=1 w=420.00n l=130.00n ng=1
MN6 net9 net4 net8 VSS sg13_lv_nmos m=1 w=420.00n l=130.00n ng=1
MN7 net8 RESET_B VSS VSS sg13_lv_nmos m=1 w=420.00n l=130.00n ng=1
MN8 net4 net6 VSS VSS sg13_lv_nmos m=1 w=740.00n l=130.00n ng=1
MN2 clkneg CLK VSS VSS sg13_lv_nmos m=1 w=740.00n l=130.00n ng=1
MN9 net4 clkpos net5 VSS sg13_lv_nmos m=1 w=740.00n l=130.00n ng=1
MN3 clkpos clkneg VSS VSS sg13_lv_nmos m=1 w=740.00n l=130.00n ng=1
MN16 Q net1 VSS VSS sg13_lv_nmos m=1 w=1.48u l=130.00n ng=2
MN15 net1 net5 VSS VSS sg13_lv_nmos m=1 w=640.00n l=130.00n ng=1
MP11 net5 clkpos net3 VDD sg13_lv_pmos m=1 w=420.00n l=130.00n ng=1
MP12 net2 net5 VDD VDD sg13_lv_pmos m=1 w=420.00n l=130.00n ng=1
MP13 net2 RESET_B VDD VDD sg13_lv_pmos m=1 w=420.00n l=130.00n ng=1
MP14 Q_N net5 VDD VDD sg13_lv_pmos m=1 w=2.24u l=130.00n ng=2
MP4 Db clkpos net6 VDD sg13_lv_pmos m=1 w=420.00n l=130.00n ng=1
MP0 Db RESET_B VDD VDD sg13_lv_pmos m=1 w=420.00n l=130.00n ng=1
MP1 Db D VDD VDD sg13_lv_pmos m=1 w=420.00n l=130.00n ng=1
MP5 net7 net4 VDD VDD sg13_lv_pmos m=1 w=420.00n l=130.00n ng=1
MP6 net6 clkneg net7 VDD sg13_lv_pmos m=1 w=420.00n l=130.00n ng=1
MP7 net6 RESET_B VDD VDD sg13_lv_pmos m=1 w=420.00n l=130.00n ng=1
MP2 clkneg CLK VDD VDD sg13_lv_pmos m=1 w=1.12u l=130.00n ng=1
MP3 clkpos clkneg VDD VDD sg13_lv_pmos m=1 w=1.12u l=130.00n ng=1
MP8 net4 net6 VDD VDD sg13_lv_pmos m=1 w=1.000u l=130.00n ng=1
MP9 net4 clkneg net5 VDD sg13_lv_pmos m=1 w=1.000u l=130.00n ng=1
MP16 Q net1 VDD VDD sg13_lv_pmos m=1 w=2.24u l=130.00n ng=2
MP10 net3 net2 VDD VDD sg13_lv_pmos m=1 w=420.00n l=130.00n ng=1
MP15 net1 net5 VDD VDD sg13_lv_pmos m=1 w=1.000u l=130.00n ng=1
.ENDS

************************************************************************
* Library Name: sg13cmos5l_stdcell
* Cell Name:    sg13cmos5l_dlhq_1
* View Name:    schematic
************************************************************************

.SUBCKT sg13cmos5l_dlhq_1 Q D GATE VDD VSS
*.PININFO D:I GATE:I Q:O VDD:B VSS:B
MP8 Q qint_b VDD VDD sg13_lv_pmos m=1 w=1.12u l=130.00n ng=1
MP6 qint GATE_BB net8 VDD sg13_lv_pmos m=1 w=420.00n l=130.00n ng=1
MP7 qint_b qint VDD VDD sg13_lv_pmos m=1 w=1.12u l=130.00n ng=1
MP2 Db D VDD VDD sg13_lv_pmos m=1 w=840.00n l=130.00n ng=1
MP0 GATE_B GATE VDD VDD sg13_lv_pmos m=1 w=840.00n l=130.00n ng=1
MP1 GATE_BB GATE_B VDD VDD sg13_lv_pmos m=1 w=840.00n l=130.00n ng=1
MP5 net8 qint_b VDD VDD sg13_lv_pmos m=1 w=420.00n l=130.00n ng=1
MP4 net4 GATE_B qint VDD sg13_lv_pmos m=1 w=1.000u l=130.00n ng=1
MP3 net4 Db VDD VDD sg13_lv_pmos m=1 w=1.000u l=130.00n ng=1
MN0 GATE_B GATE VSS VSS sg13_lv_nmos m=1 w=740.00n l=130.00n ng=1
MN1 GATE_BB GATE_B VSS VSS sg13_lv_nmos m=1 w=740.00n l=130.00n ng=1
MN5 qint GATE_B net9 VSS sg13_lv_nmos m=1 w=420.00n l=130.00n ng=1
MN8 Q qint_b VSS VSS sg13_lv_nmos m=1 w=740.00n l=130.00n ng=1
MN4 net7 Db VSS VSS sg13_lv_nmos m=1 w=740.00n l=130.00n ng=1
MN6 net9 qint_b VSS VSS sg13_lv_nmos m=1 w=420.00n l=130.00n ng=1
MN7 qint_b qint VSS VSS sg13_lv_nmos m=1 w=740.00n l=130.00n ng=1
MN3 qint GATE_BB net7 VSS sg13_lv_nmos m=1 w=740.00n l=130.00n ng=1
MN2 Db D VSS VSS sg13_lv_nmos m=1 w=550.00n l=130.00n ng=1
.ENDS

************************************************************************
* Library Name: sg13cmos5l_stdcell
* Cell Name:    sg13cmos5l_dlhr_1
* View Name:    schematic
************************************************************************

.SUBCKT sg13cmos5l_dlhr_1 Q Q_N D GATE RESET_B VDD VSS
*.PININFO D:I GATE:I RESET_B:I Q:O Q_N:O VDD:B VSS:B
MP8 qint_b RESET_B VDD VDD sg13_lv_pmos m=1 w=1.12u l=130.00n ng=1
MP9 Q qint_b VDD VDD sg13_lv_pmos m=1 w=1.12u l=130.00n ng=1
MP6 qint GATE_BB net11 VDD sg13_lv_pmos m=1 w=420.00n l=130.00n ng=1
MP5 net11 qint_b VDD VDD sg13_lv_pmos m=1 w=420.00n l=130.00n ng=1
MP4 qint GATE_B net2 VDD sg13_lv_pmos m=1 w=1.000u l=130.00n ng=1
MP3 net2 Db VDD VDD sg13_lv_pmos m=1 w=1.000u l=130.00n ng=1
MP2 Db D VDD VDD sg13_lv_pmos m=1 w=840.00n l=130.00n ng=1
MP0 GATE_B GATE VDD VDD sg13_lv_pmos m=1 w=840.00n l=130.00n ng=1
MP11 Q_N qintn_b VDD VDD sg13_lv_pmos m=1 w=1.12u l=130.00n ng=1
MP7 qint_b qint VDD VDD sg13_lv_pmos m=1 w=1.12u l=130.00n ng=1
MP1 GATE_BB GATE_B VDD VDD sg13_lv_pmos m=1 w=840.00n l=130.00n ng=1
MP10 qintn_b qint_b VDD VDD sg13_lv_pmos m=1 w=840.00n l=130.00n ng=1
MN7 qint_b qint net9 VSS sg13_lv_nmos m=1 w=740.00n l=130.00n ng=1
MN8 net9 RESET_B VSS VSS sg13_lv_nmos m=1 w=740.00n l=130.00n ng=1
MN5 qint GATE_B net7 VSS sg13_lv_nmos m=1 w=420.00n l=130.00n ng=1
MN6 net7 qint_b VSS VSS sg13_lv_nmos m=1 w=420.00n l=130.00n ng=1
MN9 Q qint_b VSS VSS sg13_lv_nmos m=1 w=740.00n l=130.00n ng=1
MN3 qint GATE_BB net1 VSS sg13_lv_nmos m=1 w=640.00n l=130.00n ng=1
MN4 net1 Db VSS VSS sg13_lv_nmos m=1 w=640.00n l=130.00n ng=1
MN2 Db D VSS VSS sg13_lv_nmos m=1 w=550.00n l=130.00n ng=1
MN0 GATE_B GATE VSS VSS sg13_lv_nmos m=1 w=740.00n l=130.00n ng=1
MN11 Q_N qintn_b VSS VSS sg13_lv_nmos m=1 w=740.00n l=130.00n ng=1
MN1 GATE_BB GATE_B VSS VSS sg13_lv_nmos m=1 w=740.00n l=130.00n ng=1
MN10 qintn_b qint_b VSS VSS sg13_lv_nmos m=1 w=550.00n l=130.00n ng=1
.ENDS

************************************************************************
* Library Name: sg13cmos5l_stdcell
* Cell Name:    sg13cmos5l_dlhrq_1
* View Name:    schematic
************************************************************************

.SUBCKT sg13cmos5l_dlhrq_1 Q D GATE RESET_B VDD VSS
*.PININFO D:I GATE:I RESET_B:I Q:O VDD:B VSS:B
MN8 net116 RESET_B VSS VSS sg13_lv_nmos m=1 w=740.00n l=130.00n ng=1
MN9 Q qint_b VSS VSS sg13_lv_nmos m=1 w=740.00n l=130.00n ng=1
MN1 GATE_BB GATE_B VSS VSS sg13_lv_nmos m=1 w=740.00n l=130.00n ng=1
MN5 qint GATE_B net89 VSS sg13_lv_nmos m=1 w=420.00n l=130.00n ng=1
MN7 qint_b qint net116 VSS sg13_lv_nmos m=1 w=740.00n l=130.00n ng=1
MN2 Db D VSS VSS sg13_lv_nmos m=1 w=550.00n l=130.00n ng=1
MN4 net61 Db VSS VSS sg13_lv_nmos m=1 w=640.00n l=130.00n ng=1
MN3 qint GATE_BB net61 VSS sg13_lv_nmos m=1 w=640.00n l=130.00n ng=1
MN6 net89 qint_b VSS VSS sg13_lv_nmos m=1 w=420.00n l=130.00n ng=1
MN0 GATE_B GATE VSS VSS sg13_lv_nmos m=1 w=740.00n l=130.00n ng=1
MP3 net60 Db VDD VDD sg13_lv_pmos m=1 w=1.000u l=130.00n ng=1
MP8 qint_b RESET_B VDD VDD sg13_lv_pmos m=1 w=1.000u l=130.00n ng=1
MP6 qint GATE_BB net92 VDD sg13_lv_pmos m=1 w=420.00n l=130.00n ng=1
MP9 Q qint_b VDD VDD sg13_lv_pmos m=1 w=1.12u l=130.00n ng=1
MP5 net92 qint_b VDD VDD sg13_lv_pmos m=1 w=420.00n l=130.00n ng=1
MP0 GATE_B GATE VDD VDD sg13_lv_pmos m=1 w=840.00n l=130.00n ng=1
MP2 Db D VDD VDD sg13_lv_pmos m=1 w=840.00n l=130.00n ng=1
MP4 qint GATE_B net60 VDD sg13_lv_pmos m=1 w=1.000u l=130.00n ng=1
MP1 GATE_BB GATE_B VDD VDD sg13_lv_pmos m=1 w=840.00n l=130.00n ng=1
MP7 qint_b qint VDD VDD sg13_lv_pmos m=1 w=1.000u l=130.00n ng=1
.ENDS

************************************************************************
* Library Name: sg13cmos5l_stdcell
* Cell Name:    sg13cmos5l_dllr_1
* View Name:    schematic
************************************************************************

.SUBCKT sg13cmos5l_dllr_1 Q Q_N D GATE_N RESET_B VDD VSS
*.PININFO D:I GATE_N:I RESET_B:I Q:O Q_N:O VDD:B VSS:B
MN2 Db D VSS VSS sg13_lv_nmos m=1 w=550.00n l=130.00n ng=1
MN0 gnb GATE_N VSS VSS sg13_lv_nmos m=1 w=740.00n l=130.00n ng=1
MN1 gnbb gnb VSS VSS sg13_lv_nmos m=1 w=740.00n l=130.00n ng=1
MN6 net89 qint_b VSS VSS sg13_lv_nmos m=1 w=420.00n l=130.00n ng=1
MN7 qint_b qint net116 VSS sg13_lv_nmos m=1 w=740.00n l=130.00n ng=1
MN8 net116 RESET_B VSS VSS sg13_lv_nmos m=1 w=740.00n l=130.00n ng=1
MN5 qint gnbb net89 VSS sg13_lv_nmos m=1 w=420.00n l=130.00n ng=1
MN11 Q_N qintn_b VSS VSS sg13_lv_nmos m=1 w=740.00n l=130.00n ng=1
MN3 qint gnb net61 VSS sg13_lv_nmos m=1 w=640.00n l=130.00n ng=1
MN10 qintn_b qint_b VSS VSS sg13_lv_nmos m=1 w=550.00n l=130.00n ng=1
MN4 net61 Db VSS VSS sg13_lv_nmos m=1 w=640.00n l=130.00n ng=1
MN9 Q qint_b VSS VSS sg13_lv_nmos m=1 w=740.00n l=130.00n ng=1
MP1 gnbb gnb VDD VDD sg13_lv_pmos m=1 w=840.00n l=130.00n ng=1
MP4 qint gnbb net60 VDD sg13_lv_pmos m=1 w=1.000u l=130.00n ng=1
MP10 qintn_b qint_b VDD VDD sg13_lv_pmos m=1 w=840.00n l=130.00n ng=1
MP11 Q_N qintn_b VDD VDD sg13_lv_pmos m=1 w=1.12u l=130.00n ng=1
MP3 net60 Db VDD VDD sg13_lv_pmos m=1 w=1.000u l=130.00n ng=1
MP5 net92 qint_b VDD VDD sg13_lv_pmos m=1 w=420.00n l=130.00n ng=1
MP8 qint_b RESET_B VDD VDD sg13_lv_pmos m=1 w=1.12u l=130.00n ng=1
MP2 Db D VDD VDD sg13_lv_pmos m=1 w=840.00n l=130.00n ng=1
MP0 gnb GATE_N VDD VDD sg13_lv_pmos m=1 w=840.00n l=130.00n ng=1
MP9 Q qint_b VDD VDD sg13_lv_pmos m=1 w=1.12u l=130.00n ng=1
MP6 qint gnb net92 VDD sg13_lv_pmos m=1 w=420.00n l=130.00n ng=1
MP7 qint_b qint VDD VDD sg13_lv_pmos m=1 w=1.12u l=130.00n ng=1
.ENDS

************************************************************************
* Library Name: sg13cmos5l_stdcell
* Cell Name:    sg13cmos5l_dllrq_1
* View Name:    schematic
************************************************************************

.SUBCKT sg13cmos5l_dllrq_1 Q D GATE_N RESET_B VDD VSS
*.PININFO D:I GATE_N:I RESET_B:I Q:O VDD:B VSS:B
MN5 qint gnbb net89 VSS sg13_lv_nmos m=1 w=420.00n l=130.00n ng=1
MN3 qint gnb net61 VSS sg13_lv_nmos m=1 w=640.00n l=130.00n ng=1
MN8 net116 RESET_B VSS VSS sg13_lv_nmos m=1 w=740.00n l=130.00n ng=1
MN9 Q qint_b VSS VSS sg13_lv_nmos m=1 w=740.00n l=130.00n ng=1
MN4 net61 Db VSS VSS sg13_lv_nmos m=1 w=640.00n l=130.00n ng=1
MN6 net89 qint_b VSS VSS sg13_lv_nmos m=1 w=420.00n l=130.00n ng=1
MN7 qint_b qint net116 VSS sg13_lv_nmos m=1 w=740.00n l=130.00n ng=1
MN2 Db D VSS VSS sg13_lv_nmos m=1 w=550.00n l=130.00n ng=1
MN0 gnb GATE_N VSS VSS sg13_lv_nmos m=1 w=740.00n l=130.00n ng=1
MN1 gnbb gnb VSS VSS sg13_lv_nmos m=1 w=740.00n l=130.00n ng=1
MP3 net59 Db VDD VDD sg13_lv_pmos m=1 w=1.000u l=130.00n ng=1
MP8 qint_b RESET_B VDD VDD sg13_lv_pmos m=1 w=1.000u l=130.00n ng=1
MP0 gnb GATE_N VDD VDD sg13_lv_pmos m=1 w=840.00n l=130.00n ng=1
MP5 net92 qint_b VDD VDD sg13_lv_pmos m=1 w=420.00n l=130.00n ng=1
MP7 qint_b qint VDD VDD sg13_lv_pmos m=1 w=1.000u l=130.00n ng=1
MP9 Q qint_b VDD VDD sg13_lv_pmos m=1 w=1.12u l=130.00n ng=1
MP4 qint gnbb net59 VDD sg13_lv_pmos m=1 w=1.000u l=130.00n ng=1
MP2 Db D VDD VDD sg13_lv_pmos m=1 w=840.00n l=130.00n ng=1
MP1 gnbb gnb VDD VDD sg13_lv_pmos m=1 w=840.00n l=130.00n ng=1
MP6 qint gnb net92 VDD sg13_lv_pmos m=1 w=420.00n l=130.00n ng=1
.ENDS

************************************************************************
* Library Name: sg13cmos5l_stdcell
* Cell Name:    sg13cmos5l_dlygate4sd1_1
* View Name:    schematic
************************************************************************

.SUBCKT sg13cmos5l_dlygate4sd1_1 X A VDD VSS
*.PININFO A:I X:O VDD:B VSS:B
MP3 X net3 VDD VDD sg13_lv_pmos m=1 w=1.12u l=130.00n ng=1
MP2 net3 net2 VDD VDD sg13_lv_pmos m=1 w=1.000u l=130.00n ng=1
MP1 net2 net1 VDD VDD sg13_lv_pmos m=1 w=1.000u l=130.00n ng=1
MP0 net1 A VDD VDD sg13_lv_pmos m=1 w=420.00n l=130.00n ng=1
MN3 X net3 VSS VSS sg13_lv_nmos m=1 w=740.00n l=130.00n ng=1
MN2 net3 net2 VSS VSS sg13_lv_nmos m=1 w=420.00n l=130.00n ng=1
MN1 net2 net1 VSS VSS sg13_lv_nmos m=1 w=420.00n l=130.00n ng=1
MN0 net1 A VSS VSS sg13_lv_nmos m=1 w=420.00n l=130.00n ng=1
.ENDS

************************************************************************
* Library Name: sg13cmos5l_stdcell
* Cell Name:    sg13cmos5l_dlygate4sd2_1
* View Name:    schematic
************************************************************************

.SUBCKT sg13cmos5l_dlygate4sd2_1 X A VDD VSS
*.PININFO A:I X:O VDD:B VSS:B
MP3 X net3 VDD VDD sg13_lv_pmos m=1 w=1.12u l=130.00n ng=1
MP2 net3 net2 VDD VDD sg13_lv_pmos m=1 w=1.000u l=250.00n ng=1
MP1 net2 net1 VDD VDD sg13_lv_pmos m=1 w=1.000u l=250.00n ng=1
MP0 net1 A VDD VDD sg13_lv_pmos m=1 w=420.00n l=130.00n ng=1
MN3 X net3 VSS VSS sg13_lv_nmos m=1 w=740.00n l=130.00n ng=1
MN2 net3 net2 VSS VSS sg13_lv_nmos m=1 w=420.00n l=180.00n ng=1
MN1 net2 net1 VSS VSS sg13_lv_nmos m=1 w=420.00n l=180.00n ng=1
MN0 net1 A VSS VSS sg13_lv_nmos m=1 w=420.00n l=130.00n ng=1
.ENDS

************************************************************************
* Library Name: sg13cmos5l_stdcell
* Cell Name:    sg13cmos5l_dlygate4sd3_1
* View Name:    schematic
************************************************************************

.SUBCKT sg13cmos5l_dlygate4sd3_1 X A VDD VSS
*.PININFO A:I X:O VDD:B VSS:B
MP3 X net3 VDD VDD sg13_lv_pmos m=1 w=1.12u l=130.00n ng=1
MP2 net3 net2 VDD VDD sg13_lv_pmos m=1 w=1.000u l=500.0n ng=1
MP1 net2 net1 VDD VDD sg13_lv_pmos m=1 w=1.000u l=500.0n ng=1
MP0 net1 A VDD VDD sg13_lv_pmos m=1 w=420.00n l=130.00n ng=1
MN3 X net3 VSS VSS sg13_lv_nmos m=1 w=740.00n l=130.00n ng=1
MN2 net3 net2 VSS VSS sg13_lv_nmos m=1 w=420.00n l=500.0n ng=1
MN1 net2 net1 VSS VSS sg13_lv_nmos m=1 w=420.00n l=500.0n ng=1
MN0 net1 A VSS VSS sg13_lv_nmos m=1 w=420.00n l=130.00n ng=1
.ENDS

************************************************************************
* Library Name: sg13cmos5l_stdcell
* Cell Name:    sg13cmos5l_ebufn_2
* View Name:    schematic
************************************************************************

.SUBCKT sg13cmos5l_ebufn_2 Z A TE_B VDD VSS
*.PININFO A:I TE_B:I Z:O VDD:B VSS:B
MN3 net4 net3 VSS VSS sg13_lv_nmos m=1 w=1.48u l=130.00n ng=2
MN2 Z net1 net4 VSS sg13_lv_nmos m=1 w=1.48u l=130.00n ng=2
MN1 net3 TE_B VSS VSS sg13_lv_nmos m=1 w=640.00n l=130.00n ng=1
MN0 net1 A VSS VSS sg13_lv_nmos m=1 w=640.00n l=130.00n ng=1
MP2 net2 TE_B VDD VDD sg13_lv_pmos m=1 w=2.24u l=130.00n ng=2
MP3 Z net1 net2 VDD sg13_lv_pmos m=1 w=2.24u l=130.00n ng=2
MP1 net3 TE_B VDD VDD sg13_lv_pmos m=1 w=1.000u l=130.00n ng=1
MP0 net1 A VDD VDD sg13_lv_pmos m=1 w=1.000u l=130.00n ng=1
.ENDS

************************************************************************
* Library Name: sg13cmos5l_stdcell
* Cell Name:    sg13cmos5l_ebufn_4
* View Name:    schematic
************************************************************************

.SUBCKT sg13cmos5l_ebufn_4 Z A TE_B VDD VSS
*.PININFO A:I TE_B:I Z:O VDD:B VSS:B
MN0 net23 A VSS VSS sg13_lv_nmos m=1 w=740.00n l=130.00n ng=1
MN1 net21 TE_B VSS VSS sg13_lv_nmos m=1 w=740.00n l=130.00n ng=1
MN2 Z net23 net22 VSS sg13_lv_nmos m=1 w=2.96u l=130.00n ng=4
MN3 net22 net21 VSS VSS sg13_lv_nmos m=1 w=2.96u l=130.00n ng=4
MP0 net23 A VDD VDD sg13_lv_pmos m=1 w=1.12u l=130.00n ng=1
MP1 net21 TE_B VDD VDD sg13_lv_pmos m=1 w=1.12u l=130.00n ng=1
MP3 Z net23 net24 VDD sg13_lv_pmos m=1 w=4.48u l=130.00n ng=4
MP2 net24 TE_B VDD VDD sg13_lv_pmos m=1 w=4.48u l=130.00n ng=4
.ENDS

************************************************************************
* Library Name: sg13cmos5l_stdcell
* Cell Name:    sg13cmos5l_ebufn_8
* View Name:    schematic
************************************************************************

.SUBCKT sg13cmos5l_ebufn_8 Z A TE_B VDD VSS
*.PININFO A:I TE_B:I Z:O VDD:B VSS:B
MN3 net23 net22 VSS VSS sg13_lv_nmos m=1 w=5.92u l=130.00n ng=8
MN2 Z net21 net23 VSS sg13_lv_nmos m=1 w=5.92u l=130.00n ng=8
MN1 net22 TE_B VSS VSS sg13_lv_nmos m=1 w=740.00n l=130.00n ng=1
MN0 net21 A VSS VSS sg13_lv_nmos m=1 w=1.48u l=130.00n ng=2
MP2 net24 TE_B VDD VDD sg13_lv_pmos m=1 w=8.96u l=130.00n ng=8
MP3 Z net21 net24 VDD sg13_lv_pmos m=1 w=8.96u l=130.00n ng=8
MP1 net22 TE_B VDD VDD sg13_lv_pmos m=1 w=1.12u l=130.00n ng=1
MP0 net21 A VDD VDD sg13_lv_pmos m=1 w=2.24u l=130.00n ng=2
.ENDS

************************************************************************
* Library Name: sg13cmos5l_stdcell
* Cell Name:    sg13cmos5l_einvn_2
* View Name:    schematic
************************************************************************

.SUBCKT sg13cmos5l_einvn_2 Z A TE_B VDD VSS
*.PININFO A:I TE_B:I Z:O VDD:B VSS:B
MN0 TE TE_B VSS VSS sg13_lv_nmos m=1 w=420.00n l=130.00n ng=1
MN2 net1 TE VSS VSS sg13_lv_nmos m=1 w=1.48u l=130.00n ng=2
MN1 Z A net1 VSS sg13_lv_nmos m=1 w=1.48u l=130.00n ng=2
MP0 TE TE_B VDD VDD sg13_lv_pmos m=1 w=640.00n l=130.00n ng=1
MP1 net2 TE_B VDD VDD sg13_lv_pmos m=1 w=2.24u l=130.00n ng=2
MP2 Z A net2 VDD sg13_lv_pmos m=1 w=2.24u l=130.00n ng=2
.ENDS

************************************************************************
* Library Name: sg13cmos5l_stdcell
* Cell Name:    sg13cmos5l_einvn_4
* View Name:    schematic
************************************************************************

.SUBCKT sg13cmos5l_einvn_4 Z A TE_B VDD VSS
*.PININFO A:I TE_B:I Z:O VDD:B VSS:B
MN2 net16 TE VSS VSS sg13_lv_nmos m=1 w=2.96u l=130.00n ng=4
MN0 TE TE_B VSS VSS sg13_lv_nmos m=1 w=740.00n l=130.00n ng=1
MN1 Z A net16 VSS sg13_lv_nmos m=1 w=2.96u l=130.00n ng=4
MP0 TE TE_B VDD VDD sg13_lv_pmos m=1 w=1.12u l=130.00n ng=1
MP1 net17 TE_B VDD VDD sg13_lv_pmos m=1 w=4.48u l=130.00n ng=4
MP2 Z A net17 VDD sg13_lv_pmos m=1 w=4.48u l=130.00n ng=4
.ENDS

************************************************************************
* Library Name: sg13cmos5l_stdcell
* Cell Name:    sg13cmos5l_einvn_8
* View Name:    schematic
************************************************************************

.SUBCKT sg13cmos5l_einvn_8 Z A TE_B VDD VSS
*.PININFO A:I TE_B:I Z:O VDD:B VSS:B
MN1 Z A net29 VSS sg13_lv_nmos m=1 w=5.92u l=130.00n ng=8
MN0 TE TE_B VSS VSS sg13_lv_nmos m=1 w=740.00n l=130.00n ng=1
MN2 net29 TE VSS VSS sg13_lv_nmos m=1 w=5.92u l=130.00n ng=8
MP1 net28 TE_B VDD VDD sg13_lv_pmos m=1 w=8.96u l=130.00n ng=8
MP2 Z A net28 VDD sg13_lv_pmos m=1 w=8.96u l=130.00n ng=8
MP0 TE TE_B VDD VDD sg13_lv_pmos m=1 w=1.12u l=130.00n ng=1
.ENDS

************************************************************************
* Library Name: sg13cmos5l_stdcell
* Cell Name:    sg13cmos5l_inv_1
* View Name:    schematic
************************************************************************

.SUBCKT sg13cmos5l_inv_1 Y A VDD VSS
*.PININFO A:I Y:O VDD:B VSS:B
MN0 Y A VSS VSS sg13_lv_nmos m=1 w=740.00n l=130.00n ng=1
MP0 Y A VDD VDD sg13_lv_pmos m=1 w=1.12u l=130.00n ng=1
.ENDS

************************************************************************
* Library Name: sg13cmos5l_stdcell
* Cell Name:    sg13cmos5l_inv_16
* View Name:    schematic
************************************************************************

.SUBCKT sg13cmos5l_inv_16 Y A VDD VSS
*.PININFO A:I Y:O VDD:B VSS:B
MN0 Y A VSS VSS sg13_lv_nmos m=1 w=11.84u l=130.00n ng=16
MP0 Y A VDD VDD sg13_lv_pmos m=1 w=17.92u l=130.00n ng=16
.ENDS

************************************************************************
* Library Name: sg13cmos5l_stdcell
* Cell Name:    sg13cmos5l_inv_2
* View Name:    schematic
************************************************************************

.SUBCKT sg13cmos5l_inv_2 Y A VDD VSS
*.PININFO A:I Y:O VDD:B VSS:B
MN0 Y A VSS VSS sg13_lv_nmos m=1 w=1.48u l=130.00n ng=2
MP0 Y A VDD VDD sg13_lv_pmos m=1 w=2.24u l=130.00n ng=2
.ENDS

************************************************************************
* Library Name: sg13cmos5l_stdcell
* Cell Name:    sg13cmos5l_inv_4
* View Name:    schematic
************************************************************************

.SUBCKT sg13cmos5l_inv_4 Y A VDD VSS
*.PININFO A:I Y:O VDD:B VSS:B
MP0 Y A VDD VDD sg13_lv_pmos m=1 w=4.48u l=130.00n ng=4
MN0 Y A VSS VSS sg13_lv_nmos m=1 w=2.96u l=130.00n ng=4
.ENDS

************************************************************************
* Library Name: sg13cmos5l_stdcell
* Cell Name:    sg13cmos5l_inv_8
* View Name:    schematic
************************************************************************

.SUBCKT sg13cmos5l_inv_8 Y A VDD VSS
*.PININFO A:I Y:O VDD:B VSS:B
MN0 Y A VSS VSS sg13_lv_nmos m=1 w=5.92u l=130.00n ng=8
MP0 Y A VDD VDD sg13_lv_pmos m=1 w=8.96u l=130.00n ng=8
.ENDS

************************************************************************
* Library Name: sg13cmos5l_stdcell
* Cell Name:    sg13cmos5l_lgcp_1
* View Name:    schematic
************************************************************************

.SUBCKT sg13cmos5l_lgcp_1 GCLK CLK GATE VDD VSS
*.PININFO CLK:I GATE:I GCLK:O VDD:B VSS:B
MP1 CLKBB CLKB VDD VDD sg13_lv_pmos m=1 w=840.00n l=130.00n ng=1
MP3 net1 CLKBB net4 VDD sg13_lv_pmos m=1 w=1.000u l=130.00n ng=1
MP4 int_GATE net1 VDD VDD sg13_lv_pmos m=1 w=1.12u l=130.00n ng=1
MP2 net4 GATE VDD VDD sg13_lv_pmos m=1 w=1.000u l=130.00n ng=1
MP8 net3 int_GATE VDD VDD sg13_lv_pmos m=1 w=840.00n l=130.00n ng=1
MP9 GCLK net3 VDD VDD sg13_lv_pmos m=1 w=1.12u l=130.00n ng=1
MP6 net1 CLKB net6 VDD sg13_lv_pmos m=1 w=420.00n l=130.00n ng=1
MP0 CLKB CLK VDD VDD sg13_lv_pmos m=1 w=840.00n l=130.00n ng=1
MP7 net3 CLK VDD VDD sg13_lv_pmos m=1 w=840.00n l=130.00n ng=1
MP5 net6 int_GATE VDD VDD sg13_lv_pmos m=1 w=420.00n l=130.00n ng=1
MN9 GCLK net3 VSS VSS sg13_lv_nmos m=1 w=740.00n l=130.00n ng=1
MN7 net3 int_GATE net5 VSS sg13_lv_nmos m=1 w=640.00n l=130.00n ng=1
MN4 int_GATE net1 VSS VSS sg13_lv_nmos m=1 w=740.00n l=130.00n ng=1
MN1 CLKBB CLKB VSS VSS sg13_lv_nmos m=1 w=740.00n l=130.00n ng=1
MN6 net7 int_GATE VSS VSS sg13_lv_nmos m=1 w=420.00n l=130.00n ng=1
MN3 net2 GATE VSS VSS sg13_lv_nmos m=1 w=640.00n l=130.00n ng=1
MN5 net1 CLKBB net7 VSS sg13_lv_nmos m=1 w=420.00n l=130.00n ng=1
MN0 CLKB CLK VSS VSS sg13_lv_nmos m=1 w=740.00n l=130.00n ng=1
MN8 net5 CLK VSS VSS sg13_lv_nmos m=1 w=640.00n l=130.00n ng=1
MN2 net1 CLKB net2 VSS sg13_lv_nmos m=1 w=640.00n l=130.00n ng=1
.ENDS

************************************************************************
* Library Name: sg13cmos5l_stdcell
* Cell Name:    sg13cmos5l_mux2_1
* View Name:    schematic
************************************************************************

.SUBCKT sg13cmos5l_mux2_1 X A0 A1 S VDD VSS
*.PININFO A0:I A1:I S:I X:O VDD:B VSS:B
MP1 net4 S VDD VDD sg13_lv_pmos m=1 w=1.000u l=130.00n ng=1
MP5 X net6 VDD VDD sg13_lv_pmos m=1 w=1.12u l=130.00n ng=1
MP4 net6 A1 net5 VDD sg13_lv_pmos m=1 w=1.000u l=130.00n ng=1
MP0 Sb S VDD VDD sg13_lv_pmos m=1 w=840.00n l=130.00n ng=1
MP3 net5 Sb VDD VDD sg13_lv_pmos m=1 w=1.000u l=130.00n ng=1
MP2 net6 A0 net4 VDD sg13_lv_pmos m=1 w=1.000u l=130.00n ng=1
MN4 net3 S VSS VSS sg13_lv_nmos m=1 w=740.00n l=130.00n ng=1
MN2 net1 Sb VSS VSS sg13_lv_nmos m=1 w=740.00n l=130.00n ng=1
MN5 X net6 VSS VSS sg13_lv_nmos m=1 w=740.00n l=130.00n ng=1
MN0 Sb S VSS VSS sg13_lv_nmos m=1 w=550.00n l=130.00n ng=1
MN3 net6 A1 net3 VSS sg13_lv_nmos m=1 w=740.00n l=130.00n ng=1
MN1 net6 A0 net1 VSS sg13_lv_nmos m=1 w=740.00n l=130.00n ng=1
.ENDS

************************************************************************
* Library Name: sg13cmos5l_stdcell
* Cell Name:    sg13cmos5l_mux2_2
* View Name:    schematic
************************************************************************

.SUBCKT sg13cmos5l_mux2_2 X A0 A1 S VDD VSS
*.PININFO A0:I A1:I S:I X:O VDD:B VSS:B
MP1 net4 S VDD VDD sg13_lv_pmos m=1 w=1.000u l=130.00n ng=1
MP5 X net6 VDD VDD sg13_lv_pmos m=1 w=2.24u l=130.00n ng=2
MP4 net6 A1 net5 VDD sg13_lv_pmos m=1 w=1.000u l=130.00n ng=1
MP0 Sb S VDD VDD sg13_lv_pmos m=1 w=840.00n l=130.00n ng=1
MP3 net5 Sb VDD VDD sg13_lv_pmos m=1 w=1.000u l=130.00n ng=1
MP2 net6 A0 net4 VDD sg13_lv_pmos m=1 w=1.000u l=130.00n ng=1
MN4 net3 S VSS VSS sg13_lv_nmos m=1 w=740.00n l=130.00n ng=1
MN2 net1 Sb VSS VSS sg13_lv_nmos m=1 w=740.00n l=130.00n ng=1
MN5 X net6 VSS VSS sg13_lv_nmos m=1 w=1.48u l=130.00n ng=2
MN0 Sb S VSS VSS sg13_lv_nmos m=1 w=550.00n l=130.00n ng=1
MN3 net6 A1 net3 VSS sg13_lv_nmos m=1 w=740.00n l=130.00n ng=1
MN1 net6 A0 net1 VSS sg13_lv_nmos m=1 w=740.00n l=130.00n ng=1
.ENDS

************************************************************************
* Library Name: sg13cmos5l_stdcell
* Cell Name:    sg13cmos5l_mux4_1
* View Name:    schematic
************************************************************************

.SUBCKT sg13cmos5l_mux4_1 X A0 A1 A2 A3 S0 S1 VDD VSS
*.PININFO A0:I A1:I A2:I A3:I S0:I S1:I X:O VDD:B VSS:B
MN12 X Xb VSS VSS sg13_lv_nmos m=1 w=740.00n l=130.00n ng=1
MN2 low S0b net7 VSS sg13_lv_nmos m=1 w=640.00n l=130.00n ng=1
MN3 net7 A0 VSS VSS sg13_lv_nmos m=1 w=640.00n l=130.00n ng=1
MN6 low S1b Xb VSS sg13_lv_nmos m=1 w=640.00n l=130.00n ng=1
MN11 high S1 Xb VSS sg13_lv_nmos m=1 w=640.00n l=130.00n ng=1
MN10 net4 A3 VSS VSS sg13_lv_nmos m=1 w=640.00n l=130.00n ng=1
MN9 high S0 net4 VSS sg13_lv_nmos m=1 w=640.00n l=130.00n ng=1
MN8 net6 A2 VSS VSS sg13_lv_nmos m=1 w=640.00n l=130.00n ng=1
MN7 high S0b net6 VSS sg13_lv_nmos m=1 w=640.00n l=130.00n ng=1
MN5 net2 A1 VSS VSS sg13_lv_nmos m=1 w=640.00n l=130.00n ng=1
MN4 low S0 net2 VSS sg13_lv_nmos m=1 w=640.00n l=130.00n ng=1
MN1 S1b S1 VSS VSS sg13_lv_nmos m=1 w=640.00n l=130.00n ng=1
MN0 S0b S0 VSS VSS sg13_lv_nmos m=1 w=640.00n l=130.00n ng=1
MP6 low S1 Xb VDD sg13_lv_pmos m=1 w=1.000u l=130.00n ng=1
MP11 high S1b Xb VDD sg13_lv_pmos m=1 w=1.000u l=130.00n ng=1
MP12 X Xb VDD VDD sg13_lv_pmos m=1 w=1.12u l=130.00n ng=1
MP10 high S0b net3 VDD sg13_lv_pmos m=1 w=1.000u l=130.00n ng=1
MP9 net3 A3 VDD VDD sg13_lv_pmos m=1 w=1.000u l=130.00n ng=1
MP8 high S0 net5 VDD sg13_lv_pmos m=1 w=1.000u l=130.00n ng=1
MP7 net5 A2 VDD VDD sg13_lv_pmos m=1 w=1.000u l=130.00n ng=1
MP2 net8 A0 VDD VDD sg13_lv_pmos m=1 w=1.000u l=130.00n ng=1
MP3 low S0 net8 VDD sg13_lv_pmos m=1 w=1.000u l=130.00n ng=1
MP1 S1b S1 VDD VDD sg13_lv_pmos m=1 w=1.000u l=130.00n ng=1
MP0 S0b S0 VDD VDD sg13_lv_pmos m=1 w=1.000u l=130.00n ng=1
MP5 low S0b net1 VDD sg13_lv_pmos m=1 w=1.000u l=130.00n ng=1
MP4 net1 A1 VDD VDD sg13_lv_pmos m=1 w=1.000u l=130.00n ng=1
.ENDS

************************************************************************
* Library Name: sg13cmos5l_stdcell
* Cell Name:    sg13cmos5l_nand2_1
* View Name:    schematic
************************************************************************

.SUBCKT sg13cmos5l_nand2_1 Y A B VDD VSS
*.PININFO A:I B:I Y:O VDD:B VSS:B
MP1 Y B VDD VDD sg13_lv_pmos m=1 w=1.12u l=130.00n ng=1
MP0 Y A VDD VDD sg13_lv_pmos m=1 w=1.12u l=130.00n ng=1
MN1 net1 B VSS VSS sg13_lv_nmos m=1 w=740.00n l=130.00n ng=1
MN0 Y A net1 VSS sg13_lv_nmos m=1 w=740.00n l=130.00n ng=1
.ENDS

************************************************************************
* Library Name: sg13cmos5l_stdcell
* Cell Name:    sg13cmos5l_nand2_2
* View Name:    schematic
************************************************************************

.SUBCKT sg13cmos5l_nand2_2 Y A B VDD VSS
*.PININFO A:I B:I Y:O VDD:B VSS:B
MP1 Y B VDD VDD sg13_lv_pmos m=1 w=2.24u l=130.00n ng=2
MP0 Y A VDD VDD sg13_lv_pmos m=1 w=2.24u l=130.00n ng=2
MN1 net1 B VSS VSS sg13_lv_nmos m=1 w=1.44u l=130.00n ng=2
MN0 Y A net1 VSS sg13_lv_nmos m=1 w=1.44u l=130.00n ng=2
.ENDS

************************************************************************
* Library Name: sg13cmos5l_stdcell
* Cell Name:    sg13cmos5l_nand2b_1
* View Name:    schematic
************************************************************************

.SUBCKT sg13cmos5l_nand2b_1 Y A_N B VDD VSS
*.PININFO A_N:I B:I Y:O VDD:B VSS:B
MP2 Y net2 VDD VDD sg13_lv_pmos m=1 w=1.12u l=130.00n ng=1
MP1 net2 A_N VDD VDD sg13_lv_pmos m=1 w=840.00n l=130.00n ng=1
MP0 Y B VDD VDD sg13_lv_pmos m=1 w=1.12u l=130.00n ng=1
MN1 Y net2 net1 VSS sg13_lv_nmos m=1 w=740.00n l=130.00n ng=1
MN0 net2 A_N VSS VSS sg13_lv_nmos m=1 w=550.00n l=130.00n ng=1
MN2 net1 B VSS VSS sg13_lv_nmos m=1 w=740.00n l=130.00n ng=1
.ENDS

************************************************************************
* Library Name: sg13cmos5l_stdcell
* Cell Name:    sg13cmos5l_nand2b_2
* View Name:    schematic
************************************************************************

.SUBCKT sg13cmos5l_nand2b_2 Y A_N B VDD VSS
*.PININFO A_N:I B:I Y:O VDD:B VSS:B
MP2 Y A VDD VDD sg13_lv_pmos m=1 w=2.24u l=130.00n ng=2
MP0 A A_N VDD VDD sg13_lv_pmos m=1 w=840.00n l=130.00n ng=1
MP1 Y B VDD VDD sg13_lv_pmos m=1 w=2.24u l=130.00n ng=2
MN1 Y B net1 VSS sg13_lv_nmos m=1 w=1.44u l=130.00n ng=2
MN0 A A_N VSS VSS sg13_lv_nmos m=1 w=550.00n l=130.00n ng=1
MN2 net1 A VSS VSS sg13_lv_nmos m=1 w=1.44u l=130.00n ng=2
.ENDS

************************************************************************
* Library Name: sg13cmos5l_stdcell
* Cell Name:    sg13cmos5l_nand3_1
* View Name:    schematic
************************************************************************

.SUBCKT sg13cmos5l_nand3_1 Y A B C VDD VSS
*.PININFO A:I B:I C:I Y:O VDD:B VSS:B
MP0 Y A VDD VDD sg13_lv_pmos m=1 w=1.12u l=130.00n ng=1
MP1 Y B VDD VDD sg13_lv_pmos m=1 w=1.12u l=130.00n ng=1
MP2 Y C VDD VDD sg13_lv_pmos m=1 w=1.12u l=130.00n ng=1
MN1 net2 B net3 VSS sg13_lv_nmos m=1 w=740.00n l=130.00n ng=1
MN2 net3 C VSS VSS sg13_lv_nmos m=1 w=740.00n l=130.00n ng=1
MN0 Y A net2 VSS sg13_lv_nmos m=1 w=740.00n l=130.00n ng=1
.ENDS

************************************************************************
* Library Name: sg13cmos5l_stdcell
* Cell Name:    sg13cmos5l_nand3b_1
* View Name:    schematic
************************************************************************

.SUBCKT sg13cmos5l_nand3b_1 Y A_N B C VDD VSS
*.PININFO A_N:I B:I C:I Y:O VDD:B VSS:B
MP0 net1 A_N VDD VDD sg13_lv_pmos m=1 w=840.00n l=130.00n ng=1
MP1 Y net1 VDD VDD sg13_lv_pmos m=1 w=1.12u l=130.00n ng=1
MP2 Y B VDD VDD sg13_lv_pmos m=1 w=1.12u l=130.00n ng=1
MP3 Y C VDD VDD sg13_lv_pmos m=1 w=1.12u l=130.00n ng=1
MN2 net2 B net3 VSS sg13_lv_nmos m=1 w=740.00n l=130.00n ng=1
MN3 net3 C VSS VSS sg13_lv_nmos m=1 w=740.00n l=130.00n ng=1
MN0 net1 A_N VSS VSS sg13_lv_nmos m=1 w=550.00n l=130.00n ng=1
MN1 Y net1 net2 VSS sg13_lv_nmos m=1 w=740.00n l=130.00n ng=1
.ENDS

************************************************************************
* Library Name: sg13cmos5l_stdcell
* Cell Name:    sg13cmos5l_nand4_1
* View Name:    schematic
************************************************************************

.SUBCKT sg13cmos5l_nand4_1 Y A B C D VDD VSS
*.PININFO A:I B:I C:I D:I Y:O VDD:B VSS:B
MP3 Y D VDD VDD sg13_lv_pmos m=1 w=1.12u l=130.00n ng=1
MP0 Y A VDD VDD sg13_lv_pmos m=1 w=1.12u l=130.00n ng=1
MP1 Y B VDD VDD sg13_lv_pmos m=1 w=1.12u l=130.00n ng=1
MP2 Y C VDD VDD sg13_lv_pmos m=1 w=1.12u l=130.00n ng=1
MN1 net2 B net3 VSS sg13_lv_nmos m=1 w=740.00n l=130.00n ng=1
MN2 net3 C net5 VSS sg13_lv_nmos m=1 w=740.00n l=130.00n ng=1
MN0 Y A net2 VSS sg13_lv_nmos m=1 w=740.00n l=130.00n ng=1
MN3 net5 D VSS VSS sg13_lv_nmos m=1 w=740.00n l=130.00n ng=1
.ENDS

************************************************************************
* Library Name: sg13cmos5l_stdcell
* Cell Name:    sg13cmos5l_nor2_1
* View Name:    schematic
************************************************************************

.SUBCKT sg13cmos5l_nor2_1 Y A B VDD VSS
*.PININFO A:I B:I Y:O VDD:B VSS:B
MN0 Y A VSS VSS sg13_lv_nmos m=1 w=740.00n l=130.00n ng=1
MN1 Y B VSS VSS sg13_lv_nmos m=1 w=740.00n l=130.00n ng=1
MP0 net1 A VDD VDD sg13_lv_pmos m=1 w=1.12u l=130.00n ng=1
MP1 Y B net1 VDD sg13_lv_pmos m=1 w=1.12u l=130.00n ng=1
.ENDS

************************************************************************
* Library Name: sg13cmos5l_stdcell
* Cell Name:    sg13cmos5l_nor2_2
* View Name:    schematic
************************************************************************

.SUBCKT sg13cmos5l_nor2_2 Y A B VDD VSS
*.PININFO A:I B:I Y:O VDD:B VSS:B
MN0 Y A VSS VSS sg13_lv_nmos m=1 w=1.48u l=130.00n ng=2
MN1 Y B VSS VSS sg13_lv_nmos m=1 w=1.48u l=130.00n ng=2
MP0 net1 A VDD VDD sg13_lv_pmos m=1 w=2.24u l=130.00n ng=2
MP1 Y B net1 VDD sg13_lv_pmos m=1 w=2.24u l=130.00n ng=2
.ENDS

************************************************************************
* Library Name: sg13cmos5l_stdcell
* Cell Name:    sg13cmos5l_nor2b_1
* View Name:    schematic
************************************************************************

.SUBCKT sg13cmos5l_nor2b_1 Y A B_N VDD VSS
*.PININFO A:I B_N:I Y:O VDD:B VSS:B
MN0 B B_N VSS VSS sg13_lv_nmos m=1 w=550.00n l=130.00n ng=1
MN1 Y A VSS VSS sg13_lv_nmos m=1 w=740.00n l=130.00n ng=1
MN2 Y B VSS VSS sg13_lv_nmos m=1 w=740.00n l=130.00n ng=1
MP0 B B_N VDD VDD sg13_lv_pmos m=1 w=840.00n l=130.00n ng=1
MP1 net1 B VDD VDD sg13_lv_pmos m=1 w=1.12u l=130.00n ng=1
MP2 Y A net1 VDD sg13_lv_pmos m=1 w=1.12u l=130.00n ng=1
.ENDS

************************************************************************
* Library Name: sg13cmos5l_stdcell
* Cell Name:    sg13cmos5l_nor2b_2
* View Name:    schematic
************************************************************************

.SUBCKT sg13cmos5l_nor2b_2 Y A B_N VDD VSS
*.PININFO A:I B_N:I Y:O VDD:B VSS:B
MN0 B B_N VSS VSS sg13_lv_nmos m=1 w=640.00n l=130.00n ng=1
MN1 Y A VSS VSS sg13_lv_nmos m=1 w=1.44u l=130.00n ng=2
MN2 Y B VSS VSS sg13_lv_nmos m=1 w=1.44u l=130.00n ng=2
MP0 B B_N VDD VDD sg13_lv_pmos m=1 w=1.000u l=130.00n ng=1
MP1 net1 B VDD VDD sg13_lv_pmos m=1 w=2.24u l=130.00n ng=2
MP2 Y A net1 VDD sg13_lv_pmos m=1 w=2.24u l=130.00n ng=2
.ENDS

************************************************************************
* Library Name: sg13cmos5l_stdcell
* Cell Name:    sg13cmos5l_nor3_1
* View Name:    schematic
************************************************************************

.SUBCKT sg13cmos5l_nor3_1 Y A B C VDD VSS
*.PININFO A:I B:I C:I Y:O VDD:B VSS:B
MP2 Y C net2 VDD sg13_lv_pmos m=1 w=1.12u l=130.00n ng=1
MP1 net2 B net3 VDD sg13_lv_pmos m=1 w=1.12u l=130.00n ng=1
MP0 net3 A VDD VDD sg13_lv_pmos m=1 w=1.12u l=130.00n ng=1
MN0 Y A VSS VSS sg13_lv_nmos m=1 w=770.00n l=130.00n ng=1
MN1 Y B VSS VSS sg13_lv_nmos m=1 w=770.00n l=130.00n ng=1
MN2 Y C VSS VSS sg13_lv_nmos m=1 w=770.00n l=130.00n ng=1
.ENDS

************************************************************************
* Library Name: sg13cmos5l_stdcell
* Cell Name:    sg13cmos5l_nor3_2
* View Name:    schematic
************************************************************************

.SUBCKT sg13cmos5l_nor3_2 Y A B C VDD VSS
*.PININFO A:I B:I C:I Y:O VDD:B VSS:B
MP2 Y C net2 VDD sg13_lv_pmos m=1 w=2.24u l=130.00n ng=2
MP1 net2 B net3 VDD sg13_lv_pmos m=1 w=2.24u l=130.00n ng=2
MP0 net3 A VDD VDD sg13_lv_pmos m=1 w=2.24u l=130.00n ng=2
MN0 Y A VSS VSS sg13_lv_nmos m=1 w=1.48u l=130.00n ng=2
MN1 Y B VSS VSS sg13_lv_nmos m=1 w=1.48u l=130.00n ng=2
MN2 Y C VSS VSS sg13_lv_nmos m=1 w=1.48u l=130.00n ng=2
.ENDS

************************************************************************
* Library Name: sg13cmos5l_stdcell
* Cell Name:    sg13cmos5l_nor4_1
* View Name:    schematic
************************************************************************

.SUBCKT sg13cmos5l_nor4_1 Y A B C D VDD VSS
*.PININFO A:I B:I C:I D:I Y:O VDD:B VSS:B
MP0 net3 A VDD VDD sg13_lv_pmos m=1 w=1.12u l=130.00n ng=1
MP1 net2 B net3 VDD sg13_lv_pmos m=1 w=1.12u l=130.00n ng=1
MP2 net1 C net2 VDD sg13_lv_pmos m=1 w=1.12u l=130.00n ng=1
MP3 Y D net1 VDD sg13_lv_pmos m=1 w=1.12u l=130.00n ng=1
MN0 Y A VSS VSS sg13_lv_nmos m=1 w=740.00n l=130.00n ng=1
MN3 Y D VSS VSS sg13_lv_nmos m=1 w=740.00n l=130.00n ng=1
MN1 Y B VSS VSS sg13_lv_nmos m=1 w=740.00n l=130.00n ng=1
MN2 Y C VSS VSS sg13_lv_nmos m=1 w=740.00n l=130.00n ng=1
.ENDS

************************************************************************
* Library Name: sg13cmos5l_stdcell
* Cell Name:    sg13cmos5l_nor4_2
* View Name:    schematic
************************************************************************

.SUBCKT sg13cmos5l_nor4_2 Y A B C D VDD VSS
*.PININFO A:I B:I C:I D:I Y:O VDD:B VSS:B
MP0 net3 A VDD VDD sg13_lv_pmos m=1 w=2.24u l=130.00n ng=2
MP1 net2 B net3 VDD sg13_lv_pmos m=1 w=2.24u l=130.00n ng=2
MP2 net1 C net2 VDD sg13_lv_pmos m=1 w=2.24u l=130.00n ng=2
MP3 Y D net1 VDD sg13_lv_pmos m=1 w=2.24u l=130.00n ng=2
MN0 Y A VSS VSS sg13_lv_nmos m=1 w=1.48u l=130.00n ng=2
MN3 Y D VSS VSS sg13_lv_nmos m=1 w=1.48u l=130.00n ng=2
MN1 Y B VSS VSS sg13_lv_nmos m=1 w=1.48u l=130.00n ng=2
MN2 Y C VSS VSS sg13_lv_nmos m=1 w=1.48u l=130.00n ng=2
.ENDS

************************************************************************
* Library Name: sg13cmos5l_stdcell
* Cell Name:    sg13cmos5l_o21ai_1
* View Name:    schematic
************************************************************************

.SUBCKT sg13cmos5l_o21ai_1 Y A1 A2 B1 VDD VSS
*.PININFO A1:I A2:I B1:I Y:O VDD:B VSS:B
MP0 net14 A1 VDD VDD sg13_lv_pmos m=1 w=1.12u l=150.00n ng=1
MP1 Y A2 net14 VDD sg13_lv_pmos m=1 w=1.12u l=150.00n ng=1
MP2 Y B1 VDD VDD sg13_lv_pmos m=1 w=1.12u l=150.00n ng=1
MN0 net1 A2 VSS VSS sg13_lv_nmos m=1 w=740.00n l=150.00n ng=1
MN2 net1 A1 VSS VSS sg13_lv_nmos m=1 w=740.00n l=150.00n ng=1
MN1 Y B1 net1 VSS sg13_lv_nmos m=1 w=740.00n l=150.00n ng=1
.ENDS

************************************************************************
* Library Name: sg13cmos5l_stdcell
* Cell Name:    sg13cmos5l_or2_1
* View Name:    schematic
************************************************************************

.SUBCKT sg13cmos5l_or2_1 X A B VDD VSS
*.PININFO A:I B:I X:O VDD:B VSS:B
MP1 net2 B net3 VDD sg13_lv_pmos m=1 w=840.00n l=130.00n ng=1
MP0 net3 A VDD VDD sg13_lv_pmos m=1 w=840.00n l=130.00n ng=1
MP2 X net2 VDD VDD sg13_lv_pmos m=1 w=1.12u l=130.00n ng=1
MN1 net2 A VSS VSS sg13_lv_nmos m=1 w=550.00n l=130.00n ng=1
MN0 net2 B VSS VSS sg13_lv_nmos m=1 w=550.00n l=130.00n ng=1
MN2 X net2 VSS VSS sg13_lv_nmos m=1 w=740.00n l=130.00n ng=1
.ENDS

************************************************************************
* Library Name: sg13cmos5l_stdcell
* Cell Name:    sg13cmos5l_or2_2
* View Name:    schematic
************************************************************************

.SUBCKT sg13cmos5l_or2_2 X A B VDD VSS
*.PININFO A:I B:I X:O VDD:B VSS:B
MP1 net2 B net3 VDD sg13_lv_pmos m=1 w=840.00n l=130.00n ng=1
MP0 net3 A VDD VDD sg13_lv_pmos m=1 w=840.00n l=130.00n ng=1
MP2 X net2 VDD VDD sg13_lv_pmos m=1 w=2.24u l=130.00n ng=2
MN1 net2 A VSS VSS sg13_lv_nmos m=1 w=550.00n l=130.00n ng=1
MN0 net2 B VSS VSS sg13_lv_nmos m=1 w=550.00n l=130.00n ng=1
MN2 X net2 VSS VSS sg13_lv_nmos m=1 w=1.48u l=130.00n ng=2
.ENDS

************************************************************************
* Library Name: sg13cmos5l_stdcell
* Cell Name:    sg13cmos5l_or3_1
* View Name:    schematic
************************************************************************

.SUBCKT sg13cmos5l_or3_1 X A B C VDD VSS
*.PININFO A:I B:I C:I X:O VDD:B VSS:B
MN2 net1 C VSS VSS sg13_lv_nmos m=1 w=550.00n l=130.00n ng=1
MN3 X net1 VSS VSS sg13_lv_nmos m=1 w=740.00n l=130.00n ng=1
MN1 net1 B VSS VSS sg13_lv_nmos m=1 w=550.00n l=130.00n ng=1
MN0 net1 A VSS VSS sg13_lv_nmos m=1 w=550.00n l=130.00n ng=1
MP3 X net1 VDD VDD sg13_lv_pmos m=1 w=1.12u l=130.00n ng=1
MP1 net9 B net12 VDD sg13_lv_pmos m=1 w=1.000u l=130.00n ng=1
MP0 net12 A VDD VDD sg13_lv_pmos m=1 w=1.000u l=130.00n ng=1
MP2 net1 C net9 VDD sg13_lv_pmos m=1 w=1.000u l=130.00n ng=1
.ENDS

************************************************************************
* Library Name: sg13cmos5l_stdcell
* Cell Name:    sg13cmos5l_or3_2
* View Name:    schematic
************************************************************************

.SUBCKT sg13cmos5l_or3_2 X A B C VDD VSS
*.PININFO A:I B:I C:I X:O VDD:B VSS:B
MN2 net1 C VSS VSS sg13_lv_nmos m=1 w=550.00n l=130.00n ng=1
MN3 X net1 VSS VSS sg13_lv_nmos m=1 w=1.48u l=130.00n ng=2
MN1 net1 B VSS VSS sg13_lv_nmos m=1 w=550.00n l=130.00n ng=1
MN0 net1 A VSS VSS sg13_lv_nmos m=1 w=550.00n l=130.00n ng=1
MP3 X net1 VDD VDD sg13_lv_pmos m=1 w=2.24u l=130.00n ng=2
MP1 net9 B net12 VDD sg13_lv_pmos m=1 w=1.000u l=130.00n ng=1
MP0 net12 A VDD VDD sg13_lv_pmos m=1 w=1.000u l=130.00n ng=1
MP2 net1 C net9 VDD sg13_lv_pmos m=1 w=1.000u l=130.00n ng=1
.ENDS

************************************************************************
* Library Name: sg13cmos5l_stdcell
* Cell Name:    sg13cmos5l_or4_1
* View Name:    schematic
************************************************************************

.SUBCKT sg13cmos5l_or4_1 X A B C D VDD VSS
*.PININFO A:I B:I C:I D:I X:O VDD:B VSS:B
MN4 X net1 VSS VSS sg13_lv_nmos m=1 w=740.00n l=130.00n ng=1
MN3 net1 D VSS VSS sg13_lv_nmos m=1 w=550.00n l=130.00n ng=1
MN2 net1 C VSS VSS sg13_lv_nmos m=1 w=550.00n l=130.00n ng=1
MN1 net1 B VSS VSS sg13_lv_nmos m=1 w=550.00n l=130.00n ng=1
MN0 net1 A VSS VSS sg13_lv_nmos m=1 w=550.00n l=130.00n ng=1
MP0 net4 A VDD VDD sg13_lv_pmos m=1 w=1.000u l=130.00n ng=1
MP1 net3 B net4 VDD sg13_lv_pmos m=1 w=1.000u l=130.00n ng=1
MP2 net2 C net3 VDD sg13_lv_pmos m=1 w=1.000u l=130.00n ng=1
MP3 net1 D net2 VDD sg13_lv_pmos m=1 w=1.000u l=130.00n ng=1
MP4 X net1 VDD VDD sg13_lv_pmos m=1 w=1.12u l=130.00n ng=1
.ENDS

************************************************************************
* Library Name: sg13cmos5l_stdcell
* Cell Name:    sg13cmos5l_or4_2
* View Name:    schematic
************************************************************************

.SUBCKT sg13cmos5l_or4_2 X A B C D VDD VSS
*.PININFO A:I B:I C:I D:I X:O VDD:B VSS:B
MN4 X net1 VSS VSS sg13_lv_nmos m=1 w=1.48u l=130.00n ng=2
MN3 net1 D VSS VSS sg13_lv_nmos m=1 w=550.00n l=130.00n ng=1
MN2 net1 C VSS VSS sg13_lv_nmos m=1 w=550.00n l=130.00n ng=1
MN1 net1 B VSS VSS sg13_lv_nmos m=1 w=550.00n l=130.00n ng=1
MN0 net1 A VSS VSS sg13_lv_nmos m=1 w=550.00n l=130.00n ng=1
MP0 net4 A VDD VDD sg13_lv_pmos m=1 w=1.000u l=130.00n ng=1
MP1 net3 B net4 VDD sg13_lv_pmos m=1 w=1.000u l=130.00n ng=1
MP2 net2 C net3 VDD sg13_lv_pmos m=1 w=1.000u l=130.00n ng=1
MP3 net1 D net2 VDD sg13_lv_pmos m=1 w=1.000u l=130.00n ng=1
MP4 X net1 VDD VDD sg13_lv_pmos m=1 w=2.24u l=130.00n ng=2
.ENDS

************************************************************************
* Library Name: sg13cmos5l_stdcell
* Cell Name:    sg13cmos5l_sdfbbp_1
* View Name:    schematic
************************************************************************

.SUBCKT sg13cmos5l_sdfbbp_1 Q Q_N CLK D RESET_B SCD SCE SET_B VDD VSS
*.PININFO CLK:I D:I RESET_B:I SCD:I SCE:I SET_B:I Q:O Q_N:O VDD:B VSS:B
MP1 resetbb RESET_B VDD VDD sg13_lv_pmos m=1 w=640.00n l=130.00n ng=1
MP19 pre_q DbbLatch2 net8 VDD sg13_lv_pmos m=1 w=1.000u l=130.00n ng=1
MP20 pre_q SET_B VDD VDD sg13_lv_pmos m=1 w=1.000u l=130.00n ng=1
MP3 CLKbb CLKb VDD VDD sg13_lv_pmos m=1 w=1.12u l=130.00n ng=1
MP0 SCEb SCE VDD VDD sg13_lv_pmos m=1 w=640.00n l=130.00n ng=1
MP7 Db D net3 VDD sg13_lv_pmos m=1 w=640.00n l=130.00n ng=1
MP13 DbbTG CLKb net10 VDD sg13_lv_pmos m=1 w=420.00n l=130.00n ng=1
MP12 net10 DbLatchM VDD VDD sg13_lv_pmos m=1 w=420.00n l=130.00n ng=1
MP6 net3 SCE VDD VDD sg13_lv_pmos m=1 w=640.00n l=130.00n ng=1
MP21 Q_N pre_q VDD VDD sg13_lv_pmos m=1 w=1.12u l=130.00n ng=1
MP14 net1 DbLatchM VDD VDD sg13_lv_pmos m=1 w=840.00n l=130.00n ng=1
MP18 net8 resetbb VDD VDD sg13_lv_pmos m=1 w=1.000u l=130.00n ng=1
MP11 DbLatchM SET_B VDD VDD sg13_lv_pmos m=1 w=840.00n l=130.00n ng=1
MP4 net2 SCD VDD VDD sg13_lv_pmos m=1 w=640.00n l=130.00n ng=1
MP2 CLKb CLK VDD VDD sg13_lv_pmos m=1 w=1.12u l=130.00n ng=1
MP10 DbLatchM DbbTG net7 VDD sg13_lv_pmos m=1 w=840.00n l=130.00n ng=1
MP8 Db CLKbb DbbTG VDD sg13_lv_pmos m=1 w=640.00n l=130.00n ng=1
MP5 Db SCEb net2 VDD sg13_lv_pmos m=1 w=640.00n l=130.00n ng=1
MP22 pre_qb pre_q VDD VDD sg13_lv_pmos m=1 w=840.00n l=130.00n ng=1
MP9 net7 resetbb VDD VDD sg13_lv_pmos m=1 w=840.00n l=130.00n ng=1
MP16 net6 pre_q VDD VDD sg13_lv_pmos m=1 w=420.00n l=130.00n ng=1
MP17 DbbLatch2 CLKbb net6 VDD sg13_lv_pmos m=1 w=420.00n l=130.00n ng=1
MP15 DbbLatch2 CLKb net1 VDD sg13_lv_pmos m=1 w=840.00n l=130.00n ng=1
MP23 Q pre_qb VDD VDD sg13_lv_pmos m=1 w=1.12u l=130.00n ng=1
MN4 Db SCE net5 VSS sg13_lv_nmos m=1 w=420.00n l=130.00n ng=1
MN5 net5 SCD VSS VSS sg13_lv_nmos m=1 w=420.00n l=130.00n ng=1
MN18 pre_q DbbLatch2 net11 VSS sg13_lv_nmos m=1 w=740.00n l=130.00n ng=1
MN8 Db CLKb DbbTG VSS sg13_lv_nmos m=1 w=420.00n l=130.00n ng=1
MN7 net4 SCEb VSS VSS sg13_lv_nmos m=1 w=420.00n l=130.00n ng=1
MN3 CLKbb CLKb VSS VSS sg13_lv_nmos m=1 w=740.00n l=130.00n ng=1
MN1 resetbb RESET_B VSS VSS sg13_lv_nmos m=1 w=420.00n l=130.00n ng=1
MN17 net14 pre_q VSS VSS sg13_lv_nmos m=1 w=420.00n l=130.00n ng=1
MN9 DbLatchM DbbTG net12 VSS sg13_lv_nmos m=1 w=550.00n l=130.00n ng=1
MN0 SCEb SCE VSS VSS sg13_lv_nmos m=1 w=420.00n l=130.00n ng=1
MN10 net12 SET_B VSS VSS sg13_lv_nmos m=1 w=550.00n l=130.00n ng=1
MN13 net15 DbLatchM VSS VSS sg13_lv_nmos m=1 w=420.00n l=130.00n ng=1
MN19 net11 SET_B VSS VSS sg13_lv_nmos m=1 w=740.00n l=130.00n ng=1
MN12 DbbTG CLKbb net15 VSS sg13_lv_nmos m=1 w=420.00n l=130.00n ng=1
MN6 Db D net4 VSS sg13_lv_nmos m=1 w=420.00n l=130.00n ng=1
MN22 pre_qb pre_q VSS VSS sg13_lv_nmos m=1 w=550.00n l=130.00n ng=1
MN16 DbbLatch2 CLKb net14 VSS sg13_lv_nmos m=1 w=420.00n l=130.00n ng=1
MN23 Q pre_qb VSS VSS sg13_lv_nmos m=1 w=740.00n l=130.00n ng=1
MN15 net13 DbLatchM VSS VSS sg13_lv_nmos m=1 w=550.00n l=130.00n ng=1
MN2 CLKb CLK VSS VSS sg13_lv_nmos m=1 w=740.00n l=130.00n ng=1
MN14 DbbLatch2 CLKbb net13 VSS sg13_lv_nmos m=1 w=550.00n l=130.00n ng=1
MN11 DbLatchM resetbb net12 VSS sg13_lv_nmos m=1 w=550.00n l=130.00n ng=1
MN21 Q_N pre_q VSS VSS sg13_lv_nmos m=1 w=740.00n l=130.00n ng=1
MN20 pre_q resetbb net11 VSS sg13_lv_nmos m=1 w=740.00n l=130.00n ng=1
.ENDS

************************************************************************
* Library Name: sg13cmos5l_stdcell
* Cell Name:    sg13cmos5l_sighold
* View Name:    schematic
************************************************************************

.SUBCKT sg13cmos5l_sighold SH VDD VSS
*.PININFO SH:B VDD:B VSS:B
MN1 net1 SH VSS VSS sg13_lv_nmos m=1 w=300.0n l=130.00n ng=1
MN0 SH net1 VSS VSS sg13_lv_nmos m=1 w=300.0n l=700.0n ng=1
MP1 net1 SH VDD VDD sg13_lv_pmos m=1 w=450.00n l=130.00n ng=1
MP0 SH net1 VDD VDD sg13_lv_pmos m=1 w=300.0n l=700.0n ng=1
.ENDS

************************************************************************
* Library Name: sg13cmos5l_stdcell
* Cell Name:    sg13cmos5l_slgcp_1
* View Name:    schematic
************************************************************************

.SUBCKT sg13cmos5l_slgcp_1 GCLK CLK GATE SCE VDD VSS
*.PININFO CLK:I GATE:I SCE:I GCLK:O VDD:B VSS:B
MP10 GCLK net5 VDD VDD sg13_lv_pmos m=1 w=1.12u l=130.00n ng=1
MP4 net1 CLKbb net6 VDD sg13_lv_pmos m=1 w=840.00n l=130.00n ng=1
MP1 CLKbb CLKb VDD VDD sg13_lv_pmos m=1 w=840.00n l=130.00n ng=1
MP8 net5 int_GATE VDD VDD sg13_lv_pmos m=1 w=840.00n l=130.00n ng=1
MP2 net3 SCE VDD VDD sg13_lv_pmos m=1 w=840.00n l=130.00n ng=1
MP7 net6 CLKb net4 VDD sg13_lv_pmos m=1 w=420.00n l=130.00n ng=1
MP5 int_GATE net6 VDD VDD sg13_lv_pmos m=1 w=1.12u l=130.00n ng=1
MP0 CLKb CLK VDD VDD sg13_lv_pmos m=1 w=840.00n l=130.00n ng=1
MP9 net5 CLK VDD VDD sg13_lv_pmos m=1 w=840.00n l=130.00n ng=1
MP6 net4 int_GATE VDD VDD sg13_lv_pmos m=1 w=420.00n l=130.00n ng=1
MP3 net1 GATE net3 VDD sg13_lv_pmos m=1 w=840.00n l=130.00n ng=1
MN5 int_GATE net6 VSS VSS sg13_lv_nmos m=1 w=740.00n l=130.00n ng=1
MN9 net2 CLK VSS VSS sg13_lv_nmos m=1 w=640.00n l=130.00n ng=1
MN2 net1 SCE VSS VSS sg13_lv_nmos m=1 w=550.00n l=130.00n ng=1
MN4 net6 CLKb net1 VSS sg13_lv_nmos m=1 w=550.00n l=130.00n ng=1
MN7 net7 int_GATE VSS VSS sg13_lv_nmos m=1 w=420.00n l=130.00n ng=1
MN8 net5 int_GATE net2 VSS sg13_lv_nmos m=1 w=640.00n l=130.00n ng=1
MN10 GCLK net5 VSS VSS sg13_lv_nmos m=1 w=740.00n l=130.00n ng=1
MN1 CLKbb CLKb VSS VSS sg13_lv_nmos m=1 w=740.00n l=130.00n ng=1
MN3 net1 GATE VSS VSS sg13_lv_nmos m=1 w=550.00n l=130.00n ng=1
MN0 CLKb CLK VSS VSS sg13_lv_nmos m=1 w=740.00n l=130.00n ng=1
MN6 net6 CLKbb net7 VSS sg13_lv_nmos m=1 w=420.00n l=130.00n ng=1
.ENDS

************************************************************************
* Library Name: sg13cmos5l_stdcell
* Cell Name:    sg13cmos5l_tiehi
* View Name:    schematic
************************************************************************

.SUBCKT sg13cmos5l_tiehi L_HI VDD VSS
*.PININFO L_HI:O VDD:B VSS:B
MN1 net3 net2 VSS VSS sg13_lv_nmos m=1 w=795.00n l=130.00n ng=1
MN0 net1 net1 VSS VSS sg13_lv_nmos m=1 w=300n l=130.00n ng=1
MP1 L_HI net3 VDD VDD sg13_lv_pmos m=1 w=1.155u l=130.00n ng=1
MP0 net2 net1 VDD VDD sg13_lv_pmos m=1 w=660.0n l=130.00n ng=1
.ENDS

************************************************************************
* Library Name: sg13cmos5l_stdcell
* Cell Name:    sg13cmos5l_tielo
* View Name:    schematic
************************************************************************

.SUBCKT sg13cmos5l_tielo L_LO VDD VSS
*.PININFO L_LO:O VDD:B VSS:B
MN0 net3 net2 VSS VSS sg13_lv_nmos m=1 w=385.00n l=130.00n ng=1
MN1 L_LO net1 VSS VSS sg13_lv_nmos m=1 w=880.0n l=130.00n ng=1
MP0 net2 net2 VDD VDD sg13_lv_pmos m=1 w=300n l=130.00n ng=1
MP1 net1 net3 VDD VDD sg13_lv_pmos m=1 w=1.045u l=130.00n ng=1
.ENDS

************************************************************************
* Library Name: sg13cmos5l_stdcell
* Cell Name:    sg13cmos5l_xnor2_1
* View Name:    schematic
************************************************************************

.SUBCKT sg13cmos5l_xnor2_1 Y A B VDD VSS
*.PININFO A:I B:I Y:O VDD:B VSS:B
MP4 Y net1 VDD VDD sg13_lv_pmos m=1 w=1.12u l=130.00n ng=1
MP3 Y B net4 VDD sg13_lv_pmos m=1 w=1.12u l=130.00n ng=1
MP2 net4 A VDD VDD sg13_lv_pmos m=1 w=1.12u l=130.00n ng=1
MP1 net1 B VDD VDD sg13_lv_pmos m=1 w=840.00n l=130.00n ng=1
MP0 net1 A VDD VDD sg13_lv_pmos m=1 w=840.00n l=130.00n ng=1
MN3 Y net1 net3 VSS sg13_lv_nmos m=1 w=740.00n l=130.00n ng=1
MN1 net2 A VSS VSS sg13_lv_nmos m=1 w=640.00n l=130.00n ng=1
MN0 net1 B net2 VSS sg13_lv_nmos m=1 w=640.00n l=130.00n ng=1
MN4 net3 B VSS VSS sg13_lv_nmos m=1 w=740.00n l=130.00n ng=1
MN2 net3 A VSS VSS sg13_lv_nmos m=1 w=740.00n l=130.00n ng=1
.ENDS

************************************************************************
* Library Name: sg13cmos5l_stdcell
* Cell Name:    sg13cmos5l_xor2_1
* View Name:    schematic
************************************************************************

.SUBCKT sg13cmos5l_xor2_1 X A B VDD VSS
*.PININFO A:I B:I X:O VDD:B VSS:B
MN0 net1 A VSS VSS sg13_lv_nmos m=1 w=550.00n l=130.00n ng=1
MN3 X B net3 VSS sg13_lv_nmos m=1 w=740.00n l=130.00n ng=1
MN2 X net1 VSS VSS sg13_lv_nmos m=1 w=740.00n l=130.00n ng=1
MN4 net3 A VSS VSS sg13_lv_nmos m=1 w=740.00n l=130.00n ng=1
MN1 net1 B VSS VSS sg13_lv_nmos m=1 w=550.00n l=130.00n ng=1
MP0 net6 A VDD VDD sg13_lv_pmos m=1 w=1.000u l=130.00n ng=1
MP1 net1 B net6 VDD sg13_lv_pmos m=1 w=1.000u l=130.00n ng=1
MP2 net5 A VDD VDD sg13_lv_pmos m=1 w=1.12u l=130.00n ng=1
MP4 net5 B VDD VDD sg13_lv_pmos m=1 w=1.12u l=130.00n ng=1
MP3 X net1 net5 VDD sg13_lv_pmos m=1 w=1.12u l=130.00n ng=1
.ENDS

************************************************************************
* Library Name: sg13cmos5l_stdcell
* Cell Name:    sg13cmos5l_a22oi_1
* View Name:    schematic
************************************************************************

.SUBCKT sg13cmos5l_a22oi_1 Y A1 A2 B1 B2 VDD VSS
*.PININFO A1:I A2:I B1:I B2:I Y:O VDD:B VSS:B
MN1 net1 B1 VSS VSS sg13_lv_nmos m=1 w=740.00n l=130.00n ng=1
MN0 Y B2 net1 VSS sg13_lv_nmos m=1 w=740.00n l=130.00n ng=1
MN3 net2 A2 VSS VSS sg13_lv_nmos m=1 w=740.00n l=130.00n ng=1
MN2 Y A1 net2 VSS sg13_lv_nmos m=1 w=740.00n l=130.00n ng=1
MP1 Y B1 net3 VDD sg13_lv_pmos m=1 w=1.12u l=130.00n ng=1
MP3 Y B2 net3 VDD sg13_lv_pmos m=1 w=1.12u l=130.00n ng=1
MP2 net3 A2 VDD VDD sg13_lv_pmos m=1 w=1.12u l=130.00n ng=1
MP0 net3 A1 VDD VDD sg13_lv_pmos m=1 w=1.12u l=130.00n ng=1
.ENDS

************************************************************************
* Library Name: sg13cmos5l_stdcell
* Cell Name:    sg13cmos5l_sdfrbpq_1
* View Name:    schematic
************************************************************************

.SUBCKT sg13cmos5l_sdfrbpq_1 Q CLK D RESET_B SCD SCE VDD VSS
*.PININFO CLK:I D:I RESET_B:I SCD:I SCE:I Q:O VDD:B VSS:B
MN3 Db SCD net63 VSS sg13_lv_nmos m=1 w=740.00n l=130.00n ng=1
MN1 Db D net65 VSS sg13_lv_nmos m=1 w=740.00n l=130.00n ng=1
MN0 SCEb SCE VSS VSS sg13_lv_nmos m=1 w=550.00n l=130.00n ng=1
MN4 net63 SCE VSS VSS sg13_lv_nmos m=1 w=740.00n l=130.00n ng=1
MN2 net65 SCEb VSS VSS sg13_lv_nmos m=1 w=740.00n l=130.00n ng=1
MN17 net12 net2 VSS VSS sg13_lv_nmos m=1 w=420.00n l=130.00n ng=1
MN16 net5 clkneg net12 VSS sg13_lv_nmos m=1 w=420.00n l=130.00n ng=1
MN18 net2 net5 net11 VSS sg13_lv_nmos m=1 w=420.00n l=130.00n ng=1
MN19 net11 RESET_B VSS VSS sg13_lv_nmos m=1 w=420.00n l=130.00n ng=1
MN20 Q net2 VSS VSS sg13_lv_nmos m=1 w=740.00n l=130.00n ng=1
MN6 Dbbb Dbb net10 VSS sg13_lv_nmos m=1 w=420.00n l=130.00n ng=1
MN7 net10 RESET_B VSS VSS sg13_lv_nmos m=1 w=420.00n l=130.00n ng=1
MN10 Dbbb clkneg net6 VSS sg13_lv_nmos m=1 w=420.00n l=130.00n ng=1
MN11 net6 clkpos net9 VSS sg13_lv_nmos m=1 w=420.00n l=130.00n ng=1
MN12 net9 net4 net8 VSS sg13_lv_nmos m=1 w=420.00n l=130.00n ng=1
MN13 net8 RESET_B VSS VSS sg13_lv_nmos m=1 w=420.00n l=130.00n ng=1
MN14 net4 net6 VSS VSS sg13_lv_nmos m=1 w=740.00n l=130.00n ng=1
MN8 clkneg CLK VSS VSS sg13_lv_nmos m=1 w=740.00n l=130.00n ng=1
MN15 net4 clkpos net5 VSS sg13_lv_nmos m=1 w=740.00n l=130.00n ng=1
MN9 clkpos clkneg VSS VSS sg13_lv_nmos m=1 w=740.00n l=130.00n ng=1
MN5 Dbb Db VSS VSS sg13_lv_nmos m=1 w=740.00n l=130.00n ng=1
MP1 net64 SCE VDD VDD sg13_lv_pmos m=1 w=1.000u l=130.00n ng=1
MP3 net62 SCEb VDD VDD sg13_lv_pmos m=1 w=1.000u l=130.00n ng=1
MP0 SCEb SCE VDD VDD sg13_lv_pmos m=1 w=840.00n l=130.00n ng=1
MP4 Db SCD net62 VDD sg13_lv_pmos m=1 w=1.000u l=130.00n ng=1
MP2 Db D net64 VDD sg13_lv_pmos m=1 w=1.000u l=130.00n ng=1
MP17 net5 clkpos net3 VDD sg13_lv_pmos m=1 w=420.00n l=130.00n ng=1
MP18 net2 net5 VDD VDD sg13_lv_pmos m=1 w=420.00n l=130.00n ng=1
MP19 net2 RESET_B VDD VDD sg13_lv_pmos m=1 w=420.00n l=130.00n ng=1
MP20 Q net2 VDD VDD sg13_lv_pmos m=1 w=1.12u l=130.00n ng=1
MP10 Dbbb clkpos net6 VDD sg13_lv_pmos m=1 w=420.00n l=130.00n ng=1
MP6 Dbbb RESET_B VDD VDD sg13_lv_pmos m=1 w=420.00n l=130.00n ng=1
MP7 Dbbb Dbb VDD VDD sg13_lv_pmos m=1 w=420.00n l=130.00n ng=1
MP11 net7 net4 VDD VDD sg13_lv_pmos m=1 w=420.00n l=130.00n ng=1
MP12 net6 clkneg net7 VDD sg13_lv_pmos m=1 w=420.00n l=130.00n ng=1
MP13 net6 RESET_B VDD VDD sg13_lv_pmos m=1 w=420.00n l=130.00n ng=1
MP8 clkneg CLK VDD VDD sg13_lv_pmos m=1 w=1.12u l=130.00n ng=1
MP9 clkpos clkneg VDD VDD sg13_lv_pmos m=1 w=1.12u l=130.00n ng=1
MP14 net4 net6 VDD VDD sg13_lv_pmos m=1 w=1.000u l=130.00n ng=1
MP15 net4 clkneg net5 VDD sg13_lv_pmos m=1 w=1.000u l=130.00n ng=1
MP5 Dbb Db VDD VDD sg13_lv_pmos m=1 w=1.12u l=130.00n ng=1
MP16 net3 net2 VDD VDD sg13_lv_pmos m=1 w=420.00n l=130.00n ng=1
.ENDS

************************************************************************
* Library Name: sg13cmos5l_stdcell
* Cell Name:    sg13cmos5l_sdfrbpq_2
* View Name:    schematic
************************************************************************

.SUBCKT sg13cmos5l_sdfrbpq_2 Q CLK D RESET_B SCD SCE VDD VSS
*.PININFO CLK:I D:I RESET_B:I SCD:I SCE:I Q:O VDD:B VSS:B
MN3 Db SCD net63 VSS sg13_lv_nmos m=1 w=740.00n l=130.00n ng=1
MN1 Db D net65 VSS sg13_lv_nmos m=1 w=740.00n l=130.00n ng=1
MN0 SCEb SCE VSS VSS sg13_lv_nmos m=1 w=550.00n l=130.00n ng=1
MN4 net63 SCE VSS VSS sg13_lv_nmos m=1 w=740.00n l=130.00n ng=1
MN2 net65 SCEb VSS VSS sg13_lv_nmos m=1 w=740.00n l=130.00n ng=1
MN5 Dbb Db VSS VSS sg13_lv_nmos m=1 w=740.00n l=130.00n ng=1
MN17 net12 net2 VSS VSS sg13_lv_nmos m=1 w=420.00n l=130.00n ng=1
MN16 net5 clkneg net12 VSS sg13_lv_nmos m=1 w=420.00n l=130.00n ng=1
MN18 net2 net5 net11 VSS sg13_lv_nmos m=1 w=420.00n l=130.00n ng=1
MN19 net11 RESET_B VSS VSS sg13_lv_nmos m=1 w=420.00n l=130.00n ng=1
MN20 Q net2 VSS VSS sg13_lv_nmos m=1 w=1.48u l=130.00n ng=2
MN6 Dbbb Dbb net10 VSS sg13_lv_nmos m=1 w=420.00n l=130.00n ng=1
MN7 net10 RESET_B VSS VSS sg13_lv_nmos m=1 w=420.00n l=130.00n ng=1
MN10 Dbbb clkneg net6 VSS sg13_lv_nmos m=1 w=420.00n l=130.00n ng=1
MN11 net6 clkpos net9 VSS sg13_lv_nmos m=1 w=420.00n l=130.00n ng=1
MN12 net9 net4 net8 VSS sg13_lv_nmos m=1 w=420.00n l=130.00n ng=1
MN13 net8 RESET_B VSS VSS sg13_lv_nmos m=1 w=420.00n l=130.00n ng=1
MN14 net4 net6 VSS VSS sg13_lv_nmos m=1 w=740.00n l=130.00n ng=1
MN8 clkneg CLK VSS VSS sg13_lv_nmos m=1 w=740.00n l=130.00n ng=1
MN15 net4 clkpos net5 VSS sg13_lv_nmos m=1 w=740.00n l=130.00n ng=1
MN9 clkpos clkneg VSS VSS sg13_lv_nmos m=1 w=740.00n l=130.00n ng=1
MP1 net64 SCE VDD VDD sg13_lv_pmos m=1 w=1.000u l=130.00n ng=1
MP3 net62 SCEb VDD VDD sg13_lv_pmos m=1 w=1.000u l=130.00n ng=1
MP0 SCEb SCE VDD VDD sg13_lv_pmos m=1 w=840.00n l=130.00n ng=1
MP4 Db SCD net62 VDD sg13_lv_pmos m=1 w=1.000u l=130.00n ng=1
MP2 Db D net64 VDD sg13_lv_pmos m=1 w=1.000u l=130.00n ng=1
MP5 Dbb Db VDD VDD sg13_lv_pmos m=1 w=1.12u l=130.00n ng=1
MP17 net5 clkpos net3 VDD sg13_lv_pmos m=1 w=420.00n l=130.00n ng=1
MP18 net2 net5 VDD VDD sg13_lv_pmos m=1 w=420.00n l=130.00n ng=1
MP19 net2 RESET_B VDD VDD sg13_lv_pmos m=1 w=420.00n l=130.00n ng=1
MP20 Q net2 VDD VDD sg13_lv_pmos m=1 w=2.24u l=130.00n ng=2
MP10 Dbbb clkpos net6 VDD sg13_lv_pmos m=1 w=420.00n l=130.00n ng=1
MP6 Dbbb RESET_B VDD VDD sg13_lv_pmos m=1 w=420.00n l=130.00n ng=1
MP7 Dbbb Dbb VDD VDD sg13_lv_pmos m=1 w=420.00n l=130.00n ng=1
MP11 net7 net4 VDD VDD sg13_lv_pmos m=1 w=420.00n l=130.00n ng=1
MP12 net6 clkneg net7 VDD sg13_lv_pmos m=1 w=420.00n l=130.00n ng=1
MP13 net6 RESET_B VDD VDD sg13_lv_pmos m=1 w=420.00n l=130.00n ng=1
MP8 clkneg CLK VDD VDD sg13_lv_pmos m=1 w=1.12u l=130.00n ng=1
MP9 clkpos clkneg VDD VDD sg13_lv_pmos m=1 w=1.12u l=130.00n ng=1
MP14 net4 net6 VDD VDD sg13_lv_pmos m=1 w=1.000u l=130.00n ng=1
MP15 net4 clkneg net5 VDD sg13_lv_pmos m=1 w=1.000u l=130.00n ng=1
MP16 net3 net2 VDD VDD sg13_lv_pmos m=1 w=420.00n l=130.00n ng=1
.ENDS

************************************************************************
* Library Name: sg13cmos5l_stdcell
* Cell Name:    sg13cmos5l_sdfrbp_2
* View Name:    schematic
************************************************************************

.SUBCKT sg13cmos5l_sdfrbp_2 Q Q_N CLK D RESET_B SCD SCE VDD VSS
*.PININFO CLK:I D:I RESET_B:I SCD:I SCE:I Q:O Q_N:O VDD:B VSS:B
MN3 Db SCD net63 VSS sg13_lv_nmos m=1 w=740.00n l=130.00n ng=1
MN1 Db D net65 VSS sg13_lv_nmos m=1 w=740.00n l=130.00n ng=1
MN0 SCEb SCE VSS VSS sg13_lv_nmos m=1 w=550.00n l=130.00n ng=1
MN4 net63 SCE VSS VSS sg13_lv_nmos m=1 w=740.00n l=130.00n ng=1
MN2 net65 SCEb VSS VSS sg13_lv_nmos m=1 w=740.00n l=130.00n ng=1
MN5 Dbb Db VSS VSS sg13_lv_nmos m=1 w=740.00n l=130.00n ng=1
MN17 net12 net2 VSS VSS sg13_lv_nmos m=1 w=420.00n l=130.00n ng=1
MN16 net5 clkneg net12 VSS sg13_lv_nmos m=1 w=420.00n l=130.00n ng=1
MN18 net2 net5 net11 VSS sg13_lv_nmos m=1 w=420.00n l=130.00n ng=1
MN19 net11 RESET_B VSS VSS sg13_lv_nmos m=1 w=420.00n l=130.00n ng=1
MN20 Q_N net5 VSS VSS sg13_lv_nmos m=1 w=1.48u l=130.00n ng=2
MN6 Dbbb Dbb net10 VSS sg13_lv_nmos m=1 w=420.00n l=130.00n ng=1
MN7 net10 RESET_B VSS VSS sg13_lv_nmos m=1 w=420.00n l=130.00n ng=1
MN10 Dbbb clkneg net6 VSS sg13_lv_nmos m=1 w=420.00n l=130.00n ng=1
MN11 net6 clkpos net9 VSS sg13_lv_nmos m=1 w=420.00n l=130.00n ng=1
MN12 net9 net4 net8 VSS sg13_lv_nmos m=1 w=420.00n l=130.00n ng=1
MN13 net8 RESET_B VSS VSS sg13_lv_nmos m=1 w=420.00n l=130.00n ng=1
MN14 net4 net6 VSS VSS sg13_lv_nmos m=1 w=740.00n l=130.00n ng=1
MN8 clkneg CLK VSS VSS sg13_lv_nmos m=1 w=740.00n l=130.00n ng=1
MN15 net4 clkpos net5 VSS sg13_lv_nmos m=1 w=740.00n l=130.00n ng=1
MN9 clkpos clkneg VSS VSS sg13_lv_nmos m=1 w=740.00n l=130.00n ng=1
MN22 Q net1 VSS VSS sg13_lv_nmos m=1 w=1.48u l=130.00n ng=2
MN21 net1 net5 VSS VSS sg13_lv_nmos m=1 w=640.00n l=130.00n ng=1
MP1 net64 SCE VDD VDD sg13_lv_pmos m=1 w=1.000u l=130.00n ng=1
MP3 net62 SCEb VDD VDD sg13_lv_pmos m=1 w=1.000u l=130.00n ng=1
MP0 SCEb SCE VDD VDD sg13_lv_pmos m=1 w=840.00n l=130.00n ng=1
MP4 Db SCD net62 VDD sg13_lv_pmos m=1 w=1.000u l=130.00n ng=1
MP2 Db D net64 VDD sg13_lv_pmos m=1 w=1.000u l=130.00n ng=1
MP5 Dbb Db VDD VDD sg13_lv_pmos m=1 w=1.12u l=130.00n ng=1
MP17 net5 clkpos net3 VDD sg13_lv_pmos m=1 w=420.00n l=130.00n ng=1
MP18 net2 net5 VDD VDD sg13_lv_pmos m=1 w=420.00n l=130.00n ng=1
MP19 net2 RESET_B VDD VDD sg13_lv_pmos m=1 w=420.00n l=130.00n ng=1
MP20 Q_N net5 VDD VDD sg13_lv_pmos m=1 w=2.24u l=130.00n ng=2
MP10 Dbbb clkpos net6 VDD sg13_lv_pmos m=1 w=420.00n l=130.00n ng=1
MP6 Dbbb RESET_B VDD VDD sg13_lv_pmos m=1 w=420.00n l=130.00n ng=1
MP7 Dbbb Dbb VDD VDD sg13_lv_pmos m=1 w=420.00n l=130.00n ng=1
MP11 net7 net4 VDD VDD sg13_lv_pmos m=1 w=420.00n l=130.00n ng=1
MP12 net6 clkneg net7 VDD sg13_lv_pmos m=1 w=420.00n l=130.00n ng=1
MP13 net6 RESET_B VDD VDD sg13_lv_pmos m=1 w=420.00n l=130.00n ng=1
MP8 clkneg CLK VDD VDD sg13_lv_pmos m=1 w=1.12u l=130.00n ng=1
MP9 clkpos clkneg VDD VDD sg13_lv_pmos m=1 w=1.12u l=130.00n ng=1
MP14 net4 net6 VDD VDD sg13_lv_pmos m=1 w=1.000u l=130.00n ng=1
MP15 net4 clkneg net5 VDD sg13_lv_pmos m=1 w=1.000u l=130.00n ng=1
MP22 Q net1 VDD VDD sg13_lv_pmos m=1 w=2.24u l=130.00n ng=2
MP16 net3 net2 VDD VDD sg13_lv_pmos m=1 w=420.00n l=130.00n ng=1
MP21 net1 net5 VDD VDD sg13_lv_pmos m=1 w=1.000u l=130.00n ng=1
.ENDS

************************************************************************
* Library Name: sg13cmos5l_stdcell
* Cell Name:    sg13cmos5l_sdfrbp_1
* View Name:    schematic
************************************************************************

.SUBCKT sg13cmos5l_sdfrbp_1 Q Q_N CLK D RESET_B SCD SCE VDD VSS
*.PININFO CLK:I D:I RESET_B:I SCD:I SCE:I Q:O Q_N:O VDD:B VSS:B
MN3 Db SCD net63 VSS sg13_lv_nmos m=1 w=740.00n l=130.00n ng=1
MN1 Db D net65 VSS sg13_lv_nmos m=1 w=740.00n l=130.00n ng=1
MN0 SCEb SCE VSS VSS sg13_lv_nmos m=1 w=550.00n l=130.00n ng=1
MN4 net63 SCE VSS VSS sg13_lv_nmos m=1 w=740.00n l=130.00n ng=1
MN2 net65 SCEb VSS VSS sg13_lv_nmos m=1 w=740.00n l=130.00n ng=1
MN5 net13 Db VSS VSS sg13_lv_nmos m=1 w=740.00n l=130.00n ng=1
MN17 net12 net2 VSS VSS sg13_lv_nmos m=1 w=420.00n l=130.00n ng=1
MN16 net5 clkneg net12 VSS sg13_lv_nmos m=1 w=420.00n l=130.00n ng=1
MN18 net2 net5 net11 VSS sg13_lv_nmos m=1 w=420.00n l=130.00n ng=1
MN19 net11 RESET_B VSS VSS sg13_lv_nmos m=1 w=420.00n l=130.00n ng=1
MN20 Q_N net5 VSS VSS sg13_lv_nmos m=1 w=740.00n l=130.00n ng=1
MN6 Dbb net13 net10 VSS sg13_lv_nmos m=1 w=420.00n l=130.00n ng=1
MN7 net10 RESET_B VSS VSS sg13_lv_nmos m=1 w=420.00n l=130.00n ng=1
MN10 Dbb clkneg net6 VSS sg13_lv_nmos m=1 w=420.00n l=130.00n ng=1
MN11 net6 clkpos net9 VSS sg13_lv_nmos m=1 w=420.00n l=130.00n ng=1
MN12 net9 net4 net8 VSS sg13_lv_nmos m=1 w=420.00n l=130.00n ng=1
MN13 net8 RESET_B VSS VSS sg13_lv_nmos m=1 w=420.00n l=130.00n ng=1
MN14 net4 net6 VSS VSS sg13_lv_nmos m=1 w=740.00n l=130.00n ng=1
MN8 clkneg CLK VSS VSS sg13_lv_nmos m=1 w=740.00n l=130.00n ng=1
MN15 net4 clkpos net5 VSS sg13_lv_nmos m=1 w=740.00n l=130.00n ng=1
MN9 clkpos clkneg VSS VSS sg13_lv_nmos m=1 w=740.00n l=130.00n ng=1
MN22 Q net1 VSS VSS sg13_lv_nmos m=1 w=740.00n l=130.00n ng=1
MN21 net1 net5 VSS VSS sg13_lv_nmos m=1 w=640.00n l=130.00n ng=1
MP1 net64 SCE VDD VDD sg13_lv_pmos m=1 w=1.000u l=130.00n ng=1
MP3 net62 SCEb VDD VDD sg13_lv_pmos m=1 w=1.000u l=130.00n ng=1
MP0 SCEb SCE VDD VDD sg13_lv_pmos m=1 w=840.00n l=130.00n ng=1
MP4 Db SCD net62 VDD sg13_lv_pmos m=1 w=1.000u l=130.00n ng=1
MP2 Db D net64 VDD sg13_lv_pmos m=1 w=1.000u l=130.00n ng=1
MP5 net13 Db VDD VDD sg13_lv_pmos m=1 w=1.12u l=130.00n ng=1
MP17 net5 clkpos net3 VDD sg13_lv_pmos m=1 w=420.00n l=130.00n ng=1
MP18 net2 net5 VDD VDD sg13_lv_pmos m=1 w=420.00n l=130.00n ng=1
MP19 net2 RESET_B VDD VDD sg13_lv_pmos m=1 w=420.00n l=130.00n ng=1
MP20 Q_N net5 VDD VDD sg13_lv_pmos m=1 w=1.12u l=130.00n ng=1
MP10 Dbb clkpos net6 VDD sg13_lv_pmos m=1 w=420.00n l=130.00n ng=1
MP6 Dbb RESET_B VDD VDD sg13_lv_pmos m=1 w=420.00n l=130.00n ng=1
MP7 Dbb net13 VDD VDD sg13_lv_pmos m=1 w=420.00n l=130.00n ng=1
MP11 net7 net4 VDD VDD sg13_lv_pmos m=1 w=420.00n l=130.00n ng=1
MP12 net6 clkneg net7 VDD sg13_lv_pmos m=1 w=420.00n l=130.00n ng=1
MP13 net6 RESET_B VDD VDD sg13_lv_pmos m=1 w=420.00n l=130.00n ng=1
MP8 clkneg CLK VDD VDD sg13_lv_pmos m=1 w=1.12u l=130.00n ng=1
MP9 clkpos clkneg VDD VDD sg13_lv_pmos m=1 w=1.12u l=130.00n ng=1
MP14 net4 net6 VDD VDD sg13_lv_pmos m=1 w=1.000u l=130.00n ng=1
MP15 net4 clkneg net5 VDD sg13_lv_pmos m=1 w=1.000u l=130.00n ng=1
MP22 Q net1 VDD VDD sg13_lv_pmos m=1 w=1.12u l=130.00n ng=1
MP16 net3 net2 VDD VDD sg13_lv_pmos m=1 w=420.00n l=130.00n ng=1
MP21 net1 net5 VDD VDD sg13_lv_pmos m=1 w=1.000u l=130.00n ng=1
.ENDS

************************************************************************
* Library Name: sg13cmos5l_stdcell
* Cell Name:    sg13cmos5l_dfrbpq_2
* View Name:    schematic
************************************************************************

.SUBCKT sg13cmos5l_dfrbpq_2 Q CLK D RESET_B VDD VSS
*.PININFO CLK:I D:I RESET_B:I Q:O VDD:B VSS:B
MN11 net12 net2 VSS VSS sg13_lv_nmos m=1 w=420.00n l=130.00n ng=1
MN10 net5 clkneg net12 VSS sg13_lv_nmos m=1 w=420.00n l=130.00n ng=1
MN12 net2 net5 net11 VSS sg13_lv_nmos m=1 w=420.00n l=130.00n ng=1
MN13 net11 RESET_B VSS VSS sg13_lv_nmos m=1 w=420.00n l=130.00n ng=1
MN0 Db D net10 VSS sg13_lv_nmos m=1 w=420.00n l=130.00n ng=1
MN1 net10 RESET_B VSS VSS sg13_lv_nmos m=1 w=420.00n l=130.00n ng=1
MN4 Db clkneg net6 VSS sg13_lv_nmos m=1 w=420.00n l=130.00n ng=1
MN5 net6 clkpos net9 VSS sg13_lv_nmos m=1 w=420.00n l=130.00n ng=1
MN6 net9 net4 net8 VSS sg13_lv_nmos m=1 w=420.00n l=130.00n ng=1
MN7 net8 RESET_B VSS VSS sg13_lv_nmos m=1 w=420.00n l=130.00n ng=1
MN8 net4 net6 VSS VSS sg13_lv_nmos m=1 w=740.00n l=130.00n ng=1
MN2 clkneg CLK VSS VSS sg13_lv_nmos m=1 w=740.00n l=130.00n ng=1
MN9 net4 clkpos net5 VSS sg13_lv_nmos m=1 w=740.00n l=130.00n ng=1
MN3 clkpos clkneg VSS VSS sg13_lv_nmos m=1 w=740.00n l=130.00n ng=1
MN15 Q net1 VSS VSS sg13_lv_nmos m=1 w=1.48u l=130.00n ng=2
MN14 net1 net5 VSS VSS sg13_lv_nmos m=1 w=640.00n l=130.00n ng=1
MP11 net5 clkpos net3 VDD sg13_lv_pmos m=1 w=420.00n l=130.00n ng=1
MP12 net2 net5 VDD VDD sg13_lv_pmos m=1 w=420.00n l=130.00n ng=1
MP13 net2 RESET_B VDD VDD sg13_lv_pmos m=1 w=420.00n l=130.00n ng=1
MP4 Db clkpos net6 VDD sg13_lv_pmos m=1 w=420.00n l=130.00n ng=1
MP0 Db RESET_B VDD VDD sg13_lv_pmos m=1 w=420.00n l=130.00n ng=1
MP1 Db D VDD VDD sg13_lv_pmos m=1 w=420.00n l=130.00n ng=1
MP5 net7 net4 VDD VDD sg13_lv_pmos m=1 w=420.00n l=130.00n ng=1
MP6 net6 clkneg net7 VDD sg13_lv_pmos m=1 w=420.00n l=130.00n ng=1
MP7 net6 RESET_B VDD VDD sg13_lv_pmos m=1 w=420.00n l=130.00n ng=1
MP2 clkneg CLK VDD VDD sg13_lv_pmos m=1 w=1.12u l=130.00n ng=1
MP3 clkpos clkneg VDD VDD sg13_lv_pmos m=1 w=1.12u l=130.00n ng=1
MP8 net4 net6 VDD VDD sg13_lv_pmos m=1 w=1.000u l=130.00n ng=1
MP9 net4 clkneg net5 VDD sg13_lv_pmos m=1 w=1.000u l=130.00n ng=1
MP15 Q net1 VDD VDD sg13_lv_pmos m=1 w=2.24u l=130.00n ng=2
MP10 net3 net2 VDD VDD sg13_lv_pmos m=1 w=420.00n l=130.00n ng=1
MP14 net1 net5 VDD VDD sg13_lv_pmos m=1 w=1.000u l=130.00n ng=1
.ENDS

************************************************************************
* Library Name: sg13cmos5l_stdcell
* Cell Name:    sg13cmos5l_dfrbpq_1
* View Name:    schematic
************************************************************************

.SUBCKT sg13cmos5l_dfrbpq_1 Q CLK D RESET_B VDD VSS
*.PININFO CLK:I D:I RESET_B:I Q:O VDD:B VSS:B
MN11 net12 net2 VSS VSS sg13_lv_nmos m=1 w=420.00n l=130.00n ng=1
MN10 net5 clkneg net12 VSS sg13_lv_nmos m=1 w=420.00n l=130.00n ng=1
MN12 net2 net5 net11 VSS sg13_lv_nmos m=1 w=420.00n l=130.00n ng=1
MN13 net11 RESET_B VSS VSS sg13_lv_nmos m=1 w=420.00n l=130.00n ng=1
MN0 Db D net10 VSS sg13_lv_nmos m=1 w=420.00n l=130.00n ng=1
MN1 net10 RESET_B VSS VSS sg13_lv_nmos m=1 w=420.00n l=130.00n ng=1
MN4 Db clkneg net6 VSS sg13_lv_nmos m=1 w=420.00n l=130.00n ng=1
MN5 net6 clkpos net9 VSS sg13_lv_nmos m=1 w=420.00n l=130.00n ng=1
MN6 net9 net4 net8 VSS sg13_lv_nmos m=1 w=420.00n l=130.00n ng=1
MN7 net8 RESET_B VSS VSS sg13_lv_nmos m=1 w=420.00n l=130.00n ng=1
MN8 net4 net6 VSS VSS sg13_lv_nmos m=1 w=740.00n l=130.00n ng=1
MN2 clkneg CLK VSS VSS sg13_lv_nmos m=1 w=740.00n l=130.00n ng=1
MN9 net4 clkpos net5 VSS sg13_lv_nmos m=1 w=740.00n l=130.00n ng=1
MN3 clkpos clkneg VSS VSS sg13_lv_nmos m=1 w=740.00n l=130.00n ng=1
MN15 Q net1 VSS VSS sg13_lv_nmos m=1 w=740.00n l=130.00n ng=1
MN14 net1 net5 VSS VSS sg13_lv_nmos m=1 w=740.00n l=130.00n ng=1
MP11 net5 clkpos net3 VDD sg13_lv_pmos m=1 w=420.00n l=130.00n ng=1
MP12 net2 net5 VDD VDD sg13_lv_pmos m=1 w=420.00n l=130.00n ng=1
MP13 net2 RESET_B VDD VDD sg13_lv_pmos m=1 w=420.00n l=130.00n ng=1
MP4 Db clkpos net6 VDD sg13_lv_pmos m=1 w=420.00n l=130.00n ng=1
MP0 Db RESET_B VDD VDD sg13_lv_pmos m=1 w=420.00n l=130.00n ng=1
MP1 Db D VDD VDD sg13_lv_pmos m=1 w=420.00n l=130.00n ng=1
MP5 net7 net4 VDD VDD sg13_lv_pmos m=1 w=420.00n l=130.00n ng=1
MP6 net6 clkneg net7 VDD sg13_lv_pmos m=1 w=420.00n l=130.00n ng=1
MP7 net6 RESET_B VDD VDD sg13_lv_pmos m=1 w=420.00n l=130.00n ng=1
MP2 clkneg CLK VDD VDD sg13_lv_pmos m=1 w=1.12u l=130.00n ng=1
MP3 clkpos clkneg VDD VDD sg13_lv_pmos m=1 w=1.12u l=130.00n ng=1
MP8 net4 net6 VDD VDD sg13_lv_pmos m=1 w=1.000u l=130.00n ng=1
MP9 net4 clkneg net5 VDD sg13_lv_pmos m=1 w=1.000u l=130.00n ng=1
MP15 Q net1 VDD VDD sg13_lv_pmos m=1 w=1.12u l=130.00n ng=1
MP10 net3 net2 VDD VDD sg13_lv_pmos m=1 w=420.00n l=130.00n ng=1
MP14 net1 net5 VDD VDD sg13_lv_pmos m=1 w=1.12u l=130.00n ng=1
.ENDS

************************************************************************
* Library Name: sg13cmos5l_stdcell
* Cell Name:    sg13cmos5l_fill_1
* View Name:    schematic
************************************************************************

.SUBCKT sg13cmos5l_fill_1 VDD VSS
*.PININFO VDD:B VSS:B
.ENDS

************************************************************************
* Library Name: sg13cmos5l_stdcell
* Cell Name:    sg13cmos5l_fill_2
* View Name:    schematic
************************************************************************

.SUBCKT sg13cmos5l_fill_2 VDD VSS
*.PININFO VDD:B VSS:B
.ENDS

************************************************************************
* Library Name: sg13cmos5l_stdcell
* Cell Name:    sg13cmos5l_fill_4
* View Name:    schematic
************************************************************************

.SUBCKT sg13cmos5l_fill_4 VDD VSS
*.PININFO VDD:B VSS:B
.ENDS

************************************************************************
* Library Name: sg13cmos5l_stdcell
* Cell Name:    sg13cmos5l_fill_8
* View Name:    schematic
************************************************************************

.SUBCKT sg13cmos5l_fill_8 VDD VSS
*.PININFO VDD:B VSS:B
.ENDS
.END
