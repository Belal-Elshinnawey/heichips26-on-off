** sch_path: /home/belal/HeiChips/heichips26-on-off/macros/heichips26_ook/macros/ook_analog_system/schematic/xschem/comparator_adc.sch
.subckt comparator_adc VDDL VDD vin q3 VSS q2 q1 q0 clk vref_1 vref_2 vref_3 vref_4
*.PININFO VDD:B VDDL:B q0:B VSS:B clk:I q1:B q2:B q3:B vin:I vref_4:B vref_3:B vref_2:B vref_1:B
XR1 VDD vref_4 VSS rhigh w=2e-6 l=4.2e-5 m=1 b=0 mm_ok=1
XR2 vref_4 vref_3 VSS rppd w=2e-6 l=2.0e-6 m=1 b=0 mm_ok=1
XR4 vref_2 vref_1 VSS rppd w=2e-6 l=3.6e-6 m=1 b=0 mm_ok=1
XR3 vref_3 vref_2 VSS rppd w=2e-6 l=1.28e-6 m=1 b=0 mm_ok=1
XR10 clk_h net2 VSS rppd w=2e-6 l=10e-6 m=1 b=0 mm_ok=1
XR6 net1 clk VSS rppd w=2e-6 l=10e-6 m=1 b=0 mm_ok=1
XR5 vref_1 VSS VSS rhigh w=2e-6 l=3.49e-6 m=1 b=0 mm_ok=1
x1 clk_h vref_1 VDDL VDD vin q0 VSS clocked_comparator
x2 clk_h vref_2 VDDL VDD vin q1 VSS clocked_comparator
x3 clk_h vref_3 VDDL VDD vin q2 VSS clocked_comparator
x4 clk_h vref_4 VDDL VDD vin q3 VSS clocked_comparator
x5 VDD net1 net2 VSS VDDL level_up_shifter W_P_HV=3.0u L_P_HV=0.50u W_N_HV=10.0u L_N_HV=0.50u W_P_LV=1.0u L_P_LV=0.13u W_N_LV=1.0u
+ L_N_LV=0.13u
.ends

* expanding   symbol:  clocked_comparator.sym # of pins=7
** sym_path: /home/belal/HeiChips/heichips26-on-off/macros/heichips26_ook/macros/ook_analog_system/schematic/xschem/clocked_comparator.sym
** sch_path: /home/belal/HeiChips/heichips26-on-off/macros/heichips26_ook/macros/ook_analog_system/schematic/xschem/clocked_comparator.sch
.subckt clocked_comparator clk vref VDDL VDD vin vout VSS
*.PININFO VDD:B VDDL:B vin:I vref:I vout:B clk:I VSS:B
XMT VDD clkb net3 VDD sg13_hv_pmos w=5u l=0.5u ng=1 m=1 mm_ok=1
XM5 net3 vin net1 VDD sg13_hv_pmos w=5u l=0.5u ng=1 m=1 mm_ok=1
XM6 net1 net2 net5 VDD sg13_hv_pmos w=2u l=0.5u ng=1 m=1 mm_ok=1
XM7 net5 net2 VSS VSS sg13_hv_nmos w=1u l=0.5u ng=1 m=1 mm_ok=1
XM8 net3 vref net4 VDD sg13_hv_pmos w=5u l=0.5u ng=1 m=1 mm_ok=1
XM9 net4 net5 net2 VDD sg13_hv_pmos w=2u l=0.5u ng=1 m=1 mm_ok=1
XM10 net2 net5 VSS VSS sg13_hv_nmos w=1u l=0.5u ng=1 m=1 mm_ok=1
XM11 net5 clkb VSS VSS sg13_hv_nmos w=1u l=0.5u ng=1 m=1 mm_ok=1
XM12 net2 clkb VSS VSS sg13_hv_nmos w=1u l=0.5u ng=1 m=1 mm_ok=1
XM13 net4 clkb VSS VSS sg13_hv_nmos w=1u l=0.5u ng=1 m=1 mm_ok=1
XMPA1 VDDL net5 net8 VDDL sg13_hv_pmos w=4u l=0.5u ng=1 m=1 mm_ok=1
XMPA2 net8 net6 vout VDDL sg13_hv_pmos w=4u l=0.5u ng=1 m=1 mm_ok=1
XMNA1 vout net5 VSS VSS sg13_hv_nmos w=1u l=0.5u ng=1 m=1 mm_ok=1
XMNA2 vout net6 VSS VSS sg13_hv_nmos w=1u l=0.5u ng=1 m=1 mm_ok=1
XMPB1 VDDL net2 net7 VDDL sg13_hv_pmos w=4u l=0.5u ng=1 m=1 mm_ok=1
XMPB2 net7 vout net6 VDDL sg13_hv_pmos w=4u l=0.5u ng=1 m=1 mm_ok=1
XMNB1 net6 net2 VSS VSS sg13_hv_nmos w=1u l=0.5u ng=1 m=1 mm_ok=1
XMNB2 net6 vout VSS VSS sg13_hv_nmos w=1u l=0.5u ng=1 m=1 mm_ok=1
XM14 net1 clkb VSS VSS sg13_hv_nmos w=1u l=0.5u ng=1 m=1 mm_ok=1
XMIP1 clkb VSS clk VDD sg13_hv_pmos w=24u l=0.5u ng=12 m=1 mm_ok=1
XMIN1 clkb VDD clk VSS sg13_hv_nmos w=24u l=0.5u ng=12 m=1 mm_ok=1
XMT1 VDD VDD VDD VDD sg13_hv_pmos w=5u l=0.5u ng=1 m=1 mm_ok=1
XMT2 net3 net3 net3 VDD sg13_hv_pmos w=5u l=0.5u ng=1 m=1 mm_ok=1
XMIN2 clkb clkb clkb VSS sg13_hv_nmos w=2u l=0.5u ng=1 m=1 mm_ok=1
XMIN3 clk clk clk VSS sg13_hv_nmos w=2u l=0.5u ng=1 m=1 mm_ok=1
XMIP2 clk clk clk VDD sg13_hv_pmos w=2u l=0.5u ng=1 m=1 mm_ok=1
XMIP3 clkb clkb clkb VDD sg13_hv_pmos w=2u l=0.5u ng=1 m=1 mm_ok=1
XM1 net3 net3 net3 VDD sg13_hv_pmos w=5u l=0.5u ng=1 m=1 mm_ok=1
XM2 net3 net3 net3 VDD sg13_hv_pmos w=5u l=0.5u ng=1 m=1 mm_ok=1
XM3 net4 net4 net4 VDD sg13_hv_pmos w=5u l=0.5u ng=1 m=1 mm_ok=1
XM4 net1 net1 net1 VDD sg13_hv_pmos w=5u l=0.5u ng=1 m=1 mm_ok=1
XM15 net1 net1 net1 VDD sg13_hv_pmos w=2u l=0.5u ng=1 m=1 mm_ok=1
XM16 net4 net4 net4 VDD sg13_hv_pmos w=2u l=0.5u ng=1 m=1 mm_ok=1
XM17 net4 net4 net4 VSS sg13_hv_nmos w=1u l=0.5u ng=1 m=1 mm_ok=1
XM18 net1 net1 net1 VSS sg13_hv_nmos w=1u l=0.5u ng=1 m=1 mm_ok=1
XM19 net5 net5 net5 VDD sg13_hv_pmos w=2u l=0.5u ng=1 m=1 mm_ok=1
XM20 net2 net2 net2 VDD sg13_hv_pmos w=2u l=0.5u ng=1 m=1 mm_ok=1
XM21 VSS VSS VSS VSS sg13_hv_nmos w=1u l=0.5u ng=1 m=1 mm_ok=1
XM22 VSS VSS VSS VSS sg13_hv_nmos w=1u l=0.5u ng=1 m=1 mm_ok=1
XM23 net2 net2 net2 VSS sg13_hv_nmos w=1u l=0.5u ng=1 m=1 mm_ok=1
XM24 net5 net5 net5 VSS sg13_hv_nmos w=1u l=0.5u ng=1 m=1 mm_ok=1
XM25 VSS VSS VSS VSS sg13_hv_nmos w=1u l=0.5u ng=1 m=1 mm_ok=1
XM26 VSS VSS VSS VSS sg13_hv_nmos w=1u l=0.5u ng=1 m=1 mm_ok=1
XMPA3 VDDL VDDL VDDL VDDL sg13_hv_pmos w=4u l=0.5u ng=1 m=1 mm_ok=1
XMPB3 VDDL VDDL VDDL VDDL sg13_hv_pmos w=4u l=0.5u ng=1 m=1 mm_ok=1
XMPB4 net7 net7 net7 VDDL sg13_hv_pmos w=4u l=0.5u ng=1 m=1 mm_ok=1
XMPA4 net8 net8 net8 VDDL sg13_hv_pmos w=4u l=0.5u ng=1 m=1 mm_ok=1
XMPA5 net8 net8 net8 VDDL sg13_hv_pmos w=4u l=0.5u ng=1 m=1 mm_ok=1
XMPB5 net7 net7 net7 VDDL sg13_hv_pmos w=4u l=0.5u ng=1 m=1 mm_ok=1
XMPA6 vout vout vout VDDL sg13_hv_pmos w=4u l=0.5u ng=1 m=1 mm_ok=1
XMPB6 net6 net6 net6 VDDL sg13_hv_pmos w=4u l=0.5u ng=1 m=1 mm_ok=1
XMNA3 vout vout vout VSS sg13_hv_nmos w=1u l=0.5u ng=1 m=1 mm_ok=1
XMNA4 vout vout vout VSS sg13_hv_nmos w=1u l=0.5u ng=1 m=1 mm_ok=1
XMNB3 net6 net6 net6 VSS sg13_hv_nmos w=1u l=0.5u ng=1 m=1 mm_ok=1
XMNB4 net6 net6 net6 VSS sg13_hv_nmos w=1u l=0.5u ng=1 m=1 mm_ok=1
XMNB5 VSS VSS VSS VSS sg13_hv_nmos w=1u l=0.5u ng=1 m=1 mm_ok=1
XMNB6 VSS VSS VSS VSS sg13_hv_nmos w=1u l=0.5u ng=1 m=1 mm_ok=1
XMNA5 VSS VSS VSS VSS sg13_hv_nmos w=1u l=0.5u ng=1 m=1 mm_ok=1
XMNA6 VSS VSS VSS VSS sg13_hv_nmos w=1u l=0.5u ng=1 m=1 mm_ok=1
XM27 net5 net5 net5 VSS sg13_hv_nmos w=1u l=0.5u ng=1 m=1 mm_ok=1
XM28 VSS VSS VSS VSS sg13_hv_nmos w=1u l=0.5u ng=1 m=1 mm_ok=1
XM29 net2 net2 net2 VSS sg13_hv_nmos w=1u l=0.5u ng=1 m=1 mm_ok=1
XM30 VSS VSS VSS VSS sg13_hv_nmos w=1u l=0.5u ng=1 m=1 mm_ok=1
.ends

* expanding   symbol:  level_up_shifter.sym # of pins=5
** sym_path: /home/belal/HeiChips/heichips26-on-off/macros/heichips26_ook/macros/ook_analog_system/schematic/xschem/level_up_shifter.sym
** sch_path: /home/belal/HeiChips/heichips26-on-off/macros/heichips26_ook/macros/ook_analog_system/schematic/xschem/level_up_shifter.sch
.subckt level_up_shifter VDD2 A B VSS VDD1  W_P_HV=3.0u L_P_HV=0.50u W_N_HV=10.0u L_N_HV=0.50u W_P_LV=1.0u L_P_LV=0.13u
+ W_N_LV=1.0u L_N_LV=0.13u
*.PININFO VSS:B VDD2:B B:O A:I VDD1:B
XM1 net1 AB VSS VSS sg13_hv_nmos w=10u l=0.5u ng=1 m=1 mm_ok=1
XM4 T net1 VDD2 VDD2 sg13_hv_pmos w=1u l=0.5u ng=1 m=1 mm_ok=1
XM3 net1 T VDD2 VDD2 sg13_hv_pmos w=1u l=0.5u ng=1 m=1 mm_ok=1
XM2 T AM VSS VSS sg13_hv_nmos w=10u l=0.5u ng=1 m=1 mm_ok=1
XM5 B T VDD2 VDD2 sg13_hv_pmos w=3u l=0.5u ng=1 m=1 mm_ok=1
XM6 B T VSS VSS sg13_hv_nmos w=1u l=0.5u ng=1 m=1 mm_ok=1
XM7 VSS VSS VSS VSS sg13_hv_nmos w=1u l=0.5u ng=1 m=1 mm_ok=1
XM8 VDD2 VDD2 VDD2 VDD2 sg13_hv_pmos w=3u l=0.5u ng=1 m=1 mm_ok=1
XM9 VDD1 VDD1 VDD1 VDD1 sg13_lv_pmos w=1u l=0.13u ng=1 m=1 mm_ok=1
XM12 AB A VDD1 VDD1 sg13_lv_pmos w=1u l=0.13u ng=1 m=1 mm_ok=1
XM10 VSS VSS VSS VSS sg13_lv_nmos w=1u l=0.13u ng=1 m=1 mm_ok=1
XM11 VDD1 VDD1 VDD1 VDD1 sg13_lv_pmos w=1u l=0.13u ng=1 m=1 mm_ok=1
XM14 AM AB VDD1 VDD1 sg13_lv_pmos w=1u l=0.13u ng=1 m=1 mm_ok=1
XM15 VSS VSS VSS VSS sg13_lv_nmos w=1u l=0.13u ng=1 m=1 mm_ok=1
XM17 AB A VSS VSS sg13_lv_nmos w=1u l=0.13u ng=1 m=1 mm_ok=1
XM13 AM AB VSS VSS sg13_lv_nmos w=1u l=0.13u ng=1 m=1 mm_ok=1
XM16 AB AB AB VSS sg13_lv_nmos w=1u l=0.13u ng=1 m=1 mm_ok=1
XM18 AB AB AB VDD1 sg13_lv_pmos w=1u l=0.13u ng=1 m=1 mm_ok=1
XM19 AM AM AM VDD1 sg13_lv_pmos w=1u l=0.13u ng=1 m=1 mm_ok=1
XM20 AM AM AM VSS sg13_lv_nmos w=1u l=0.13u ng=1 m=1 mm_ok=1
XM21 B B B VDD2 sg13_hv_pmos w=3u l=0.5u ng=1 m=1 mm_ok=1
XM22 B B B VSS sg13_hv_nmos w=1u l=0.5u ng=1 m=1 mm_ok=1
.ends
