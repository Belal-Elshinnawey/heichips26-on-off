** sch_path: /home/belal/HeiChips/heichips26-on-off/macros/heichips26_ook/macros/ook_analog_system/schematic/xschem/output_buffer.sch
.subckt output_buffer vout_fb vctrl VDD vin vout VSS vctrl_b
*.PININFO VDD:B VSS:B vin:I vout:O vctrl:I vout_fb:O vctrl_b:I
MM7 vout_fb vin VDD VDD sg13_lv_pmos w=13.5u l=0.13u ng=10
MM8 vout_fb vin VSS VSS sg13_lv_nmos w=6u l=0.13u ng=5
MM3 net2 net1 VDD VDD sg13_lv_pmos w=40u l=0.13u ng=20
MM4 net2 net1 VSS VSS sg13_lv_nmos w=18u l=0.13u ng=10
MM1 vout net2 VDD VDD sg13_lv_pmos w=200u l=0.13u ng=50
MM2 vout net2 VSS VSS sg13_lv_nmos w=80u l=0.13u ng=20
MM5 net1 vctrl_b vout_fb VDD sg13_lv_pmos w=13.5u l=0.13u ng=10
MM6 net1 vctrl vout_fb VSS sg13_lv_nmos w=6u l=0.13u ng=5
MM11 net1 vctrl VSS VDD sg13_lv_pmos w=13.5u l=0.13u ng=10
MM12 net1 vctrl_b VSS VSS sg13_lv_nmos w=6u l=0.13u ng=5
MM17 VDD VDD VDD VDD sg13_lv_pmos w=1.3u l=0.13u ng=1
MM18 vout_fb vout_fb vout_fb VDD sg13_lv_pmos w=1.3u l=0.13u ng=1
MM19 vout_fb vout_fb vout_fb VSS sg13_lv_nmos w=1.2u l=0.13u ng=1
MM20 VSS VSS VSS VSS sg13_lv_nmos w=1.2u l=0.13u ng=1
MM21 vout_fb vout_fb vout_fb VDD sg13_lv_pmos w=1.3u l=0.13u ng=1
MM22 vout_fb vout_fb vout_fb VSS sg13_lv_nmos w=1.2u l=0.13u ng=1
MM23 VSS VSS VSS VSS sg13_lv_nmos w=1.2u l=0.13u ng=1
MM24 VSS VSS VSS VDD sg13_lv_pmos w=1.3u l=0.13u ng=1
MM25 net1 net1 net1 VDD sg13_lv_pmos w=1.3u l=0.13u ng=1
MM26 net1 net1 net1 VSS sg13_lv_nmos w=1.2u l=0.13u ng=1
MM27 net1 net1 net1 VSS sg13_lv_nmos w=1.2u l=0.13u ng=1
MM28 net1 net1 net1 VDD sg13_lv_pmos w=1.3u l=0.13u ng=1
MM29 VDD VDD VDD VDD sg13_lv_pmos w=2u l=0.13u ng=1
MM30 net2 net2 net2 VDD sg13_lv_pmos w=2u l=0.13u ng=1
MM31 net2 net2 net2 VSS sg13_lv_nmos w=1.8u l=0.13u ng=1
MM32 VSS VSS VSS VSS sg13_lv_nmos w=1.8u l=0.13u ng=1
MM33 VDD VDD VDD VDD sg13_lv_pmos w=4u l=0.13u ng=1
MM34 vout vout vout VDD sg13_lv_pmos w=4u l=0.13u ng=1
MM35 vout vout vout VSS sg13_lv_nmos w=4u l=0.13u ng=1
MM36 VSS VSS VSS VSS sg13_lv_nmos w=4u l=0.13u ng=1
.ends
