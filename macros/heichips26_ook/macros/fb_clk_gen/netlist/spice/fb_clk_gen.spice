* NGSPICE file created from fb_clk_gen.ext - technology: ihp-sg13cmos5l

* Black-box entry subcircuit for sg13cmos5l_fill_2 abstract view
.subckt sg13cmos5l_fill_2 VDD VSS
.ends

* Black-box entry subcircuit for sg13cmos5l_inv_1 abstract view
.subckt sg13cmos5l_inv_1 Y A VDD VSS
.ends

* Black-box entry subcircuit for sg13cmos5l_o21ai_1 abstract view
.subckt sg13cmos5l_o21ai_1 Y A1 A2 B1 VDD VSS
.ends

* Black-box entry subcircuit for sg13cmos5l_decap_8 abstract view
.subckt sg13cmos5l_decap_8 VDD VSS
.ends

* Black-box entry subcircuit for sg13cmos5l_nand4_1 abstract view
.subckt sg13cmos5l_nand4_1 Y A B C D VDD VSS
.ends

* Black-box entry subcircuit for sg13cmos5l_decap_4 abstract view
.subckt sg13cmos5l_decap_4 VDD VSS
.ends

* Black-box entry subcircuit for sg13cmos5l_fill_1 abstract view
.subckt sg13cmos5l_fill_1 VDD VSS
.ends

* Black-box entry subcircuit for sg13cmos5l_tiehi abstract view
.subckt sg13cmos5l_tiehi L_HI VDD VSS
.ends

* Black-box entry subcircuit for sg13cmos5l_dfrbpq_1 abstract view
.subckt sg13cmos5l_dfrbpq_1 Q CLK D RESET_B VDD VSS
.ends

* Black-box entry subcircuit for sg13cmos5l_nand2_1 abstract view
.subckt sg13cmos5l_nand2_1 Y A B VDD VSS
.ends

* Black-box entry subcircuit for sg13cmos5l_and2_1 abstract view
.subckt sg13cmos5l_and2_1 X A B VDD VSS
.ends

* Black-box entry subcircuit for sg13cmos5l_xnor2_1 abstract view
.subckt sg13cmos5l_xnor2_1 Y A B VDD VSS
.ends

* Black-box entry subcircuit for sg13cmos5l_nor4_1 abstract view
.subckt sg13cmos5l_nor4_1 Y A B C D VDD VSS
.ends

* Black-box entry subcircuit for sg13cmos5l_and4_2 abstract view
.subckt sg13cmos5l_and4_2 X A B C D VDD VSS
.ends

* Black-box entry subcircuit for sg13cmos5l_nand3_1 abstract view
.subckt sg13cmos5l_nand3_1 Y A B C VDD VSS
.ends

* Black-box entry subcircuit for sg13cmos5l_and3_1 abstract view
.subckt sg13cmos5l_and3_1 X A B C VDD VSS
.ends

* Black-box entry subcircuit for sg13cmos5l_buf_8 abstract view
.subckt sg13cmos5l_buf_8 X A VDD VSS
.ends

* Black-box entry subcircuit for sg13cmos5l_nor3_2 abstract view
.subckt sg13cmos5l_nor3_2 Y A B C VDD VSS
.ends

* Black-box entry subcircuit for sg13cmos5l_nand3b_1 abstract view
.subckt sg13cmos5l_nand3b_1 Y A_N B C VDD VSS
.ends

* Black-box entry subcircuit for sg13cmos5l_or2_2 abstract view
.subckt sg13cmos5l_or2_2 X A B VDD VSS
.ends

* Black-box entry subcircuit for sg13cmos5l_nand2b_1 abstract view
.subckt sg13cmos5l_nand2b_1 Y A_N B VDD VSS
.ends

* Black-box entry subcircuit for sg13cmos5l_a21oi_1 abstract view
.subckt sg13cmos5l_a21oi_1 Y A1 A2 B1 VDD VSS
.ends

* Black-box entry subcircuit for sg13cmos5l_or3_1 abstract view
.subckt sg13cmos5l_or3_1 X A B C VDD VSS
.ends

* Black-box entry subcircuit for sg13cmos5l_buf_1 abstract view
.subckt sg13cmos5l_buf_1 X A VDD VSS
.ends

* Black-box entry subcircuit for sg13cmos5l_a221oi_1 abstract view
.subckt sg13cmos5l_a221oi_1 Y A1 A2 B1 B2 C1 VDD VSS
.ends

* Black-box entry subcircuit for sg13cmos5l_nor2b_1 abstract view
.subckt sg13cmos5l_nor2b_1 Y A B_N VDD VSS
.ends

.subckt fb_clk_gen VGND VPWR clk_i clk_out
XFILLER_3_56 VPWR VGND sg13cmos5l_fill_2
X_056__16 _093_/D _099_/CLK VPWR VGND sg13cmos5l_inv_1
X_062_ _062_/Y _087_/C _061_/Y _091_/Q VPWR VGND sg13cmos5l_o21ai_1
XFILLER_5_130 VPWR VGND sg13cmos5l_decap_8
XFILLER_0_14 VPWR VGND sg13cmos5l_decap_8
X_061_ _061_/Y _083_/A _099_/Q _089_/Q _090_/Q VPWR VGND sg13cmos5l_nand4_1
XFILLER_2_122 VPWR VGND sg13cmos5l_decap_8
XFILLER_3_14 VPWR VGND sg13cmos5l_decap_8
X_060_ _087_/C _073_/A _073_/B _096_/Q _097_/Q VPWR VGND sg13cmos5l_nand4_1
XFILLER_6_69 VPWR VGND sg13cmos5l_decap_8
XFILLER_6_14 VPWR VGND sg13cmos5l_decap_8
XFILLER_1_0 VPWR VGND sg13cmos5l_decap_8
XFILLER_5_7 VPWR VGND sg13cmos5l_decap_4
XFILLER_6_26 VPWR VGND sg13cmos5l_fill_2
XFILLER_1_70 VPWR VGND sg13cmos5l_fill_1
XFILLER_0_28 VPWR VGND sg13cmos5l_fill_1
XFILLER_2_136 VPWR VGND sg13cmos5l_decap_4
Xclkload0 clkload0/Y _099_/CLK VPWR VGND sg13cmos5l_inv_1
XFILLER_5_123 VPWR VGND sg13cmos5l_decap_8
X_089__15 _089__15/L_HI VPWR VGND sg13cmos5l_tiehi
XFILLER_3_28 VPWR VGND sg13cmos5l_fill_1
XFILLER_6_28 VPWR VGND sg13cmos5l_fill_1
X_091__8 _091__8/L_HI VPWR VGND sg13cmos5l_tiehi
XFILLER_4_61 VPWR VGND sg13cmos5l_fill_2
XFILLER_3_7 VPWR VGND sg13cmos5l_decap_8
X_099_ _099_/Q _099_/CLK _099_/D _099__5/L_HI VPWR VGND sg13cmos5l_dfrbpq_1
XFILLER_5_114 VPWR VGND sg13cmos5l_decap_4
X_098_ _098_/Q _098_/CLK _098_/D _098__6/L_HI VPWR VGND sg13cmos5l_dfrbpq_1
XFILLER_5_137 VPWR VGND sg13cmos5l_fill_2
XFILLER_4_63 VPWR VGND sg13cmos5l_fill_1
XFILLER_2_118 VPWR VGND sg13cmos5l_fill_1
XFILLER_2_129 VPWR VGND sg13cmos5l_decap_8
X_097_ _097_/Q _098_/CLK _097_/D _097__9/L_HI VPWR VGND sg13cmos5l_dfrbpq_1
X_097__9 _097__9/L_HI VPWR VGND sg13cmos5l_tiehi
XFILLER_1_7 VPWR VGND sg13cmos5l_decap_4
XFILLER_1_21 VPWR VGND sg13cmos5l_fill_1
X_096_ _096_/Q _098_/CLK _096_/D _096__10/L_HI VPWR VGND sg13cmos5l_dfrbpq_1
XFILLER_1_76 VPWR VGND sg13cmos5l_fill_2
X_079_ _079_/Y _096_/Q _097_/Q VPWR VGND sg13cmos5l_nand2_1
XFILLER_5_139 VPWR VGND sg13cmos5l_fill_1
X_094__12 _094__12/L_HI VPWR VGND sg13cmos5l_tiehi
XFILLER_4_87 VPWR VGND sg13cmos5l_fill_1
X_095_ _095_/Q _098_/CLK _095_/D _095__11/L_HI VPWR VGND sg13cmos5l_dfrbpq_1
XFILLER_1_120 VPWR VGND sg13cmos5l_decap_8
X_078_ _078_/X _094_/Q _083_/A VPWR VGND sg13cmos5l_and2_1
XFILLER_5_118 VPWR VGND sg13cmos5l_fill_1
X_094_ _094_/Q _098_/CLK _094_/D _094__12/L_HI VPWR VGND sg13cmos5l_dfrbpq_1
X_077_ _077_/Y _083_/A VPWR VGND sg13cmos5l_inv_1
XFILLER_4_130 VPWR VGND sg13cmos5l_decap_8
XFILLER_6_0 VPWR VGND sg13cmos5l_decap_8
X_093_ _093_/Q clk_i _093_/D _093__13/L_HI VPWR VGND sg13cmos5l_dfrbpq_1
X_076_ _076_/Y _076_/A _083_/A VPWR VGND sg13cmos5l_nand2_1
XFILLER_1_68 VPWR VGND sg13cmos5l_fill_2
X_059_ _090_/D _090_/Q _059_/B VPWR VGND sg13cmos5l_xnor2_1
XFILLER_4_79 VPWR VGND sg13cmos5l_fill_1
XFILLER_1_134 VPWR VGND sg13cmos5l_decap_4
X_092_ _092_/Q _098_/CLK _092_/D _092__14/L_HI VPWR VGND sg13cmos5l_dfrbpq_1
X_058_ _059_/B _083_/A _099_/Q _089_/Q _083_/B VPWR VGND sg13cmos5l_nand4_1
X_075_ _075_/Y _090_/Q _075_/B _075_/C _075_/D VPWR VGND sg13cmos5l_nor4_1
XFILLER_1_113 VPWR VGND sg13cmos5l_decap_8
X_091_ _091_/Q _099_/CLK _091_/D _091__8/L_HI VPWR VGND sg13cmos5l_dfrbpq_1
XFILLER_1_26 VPWR VGND sg13cmos5l_decap_4
X_074_ _097_/D _097_/Q _074_/B VPWR VGND sg13cmos5l_xnor2_1
X_057_ _083_/B _073_/A _073_/B _096_/Q _097_/Q VPWR VGND sg13cmos5l_and4_2
XFILLER_4_26 VPWR VGND sg13cmos5l_fill_2
X_090_ _090_/Q _099_/CLK _090_/D _090__7/L_HI VPWR VGND sg13cmos5l_dfrbpq_1
X_073_ _074_/B _073_/A _073_/B _096_/Q VPWR VGND sg13cmos5l_nand3_1
XFILLER_5_81 VPWR VGND sg13cmos5l_fill_2
XFILLER_4_123 VPWR VGND sg13cmos5l_decap_4
X_072_ _096_/D _096_/Q _072_/B VPWR VGND sg13cmos5l_xnor2_1
X_055_ _092_/D _076_/A _073_/B _055_/C VPWR VGND sg13cmos5l_and3_1
XFILLER_4_28 VPWR VGND sg13cmos5l_fill_1
XFILLER_1_127 VPWR VGND sg13cmos5l_decap_8
XFILLER_1_138 VPWR VGND sg13cmos5l_fill_2
Xclkbuf_0_div2 clkbuf_0_div2/X _093_/Q VPWR VGND sg13cmos5l_buf_8
X_071_ _072_/B _073_/A _073_/B VPWR VGND sg13cmos5l_nand2_1
X_098__6 _098__6/L_HI VPWR VGND sg13cmos5l_tiehi
X_054_ _055_/C _075_/C _075_/D _066_/C VPWR VGND sg13cmos5l_nor3_2
XFILLER_1_19 VPWR VGND sg13cmos5l_fill_2
X_070_ _095_/D _055_/C _066_/D _069_/Y VPWR VGND sg13cmos5l_o21ai_1
X_053_ _066_/C _090_/Q _091_/Q _083_/A VPWR VGND sg13cmos5l_nand3b_1
XFILLER_2_0 VPWR VGND sg13cmos5l_decap_8
XFILLER_4_137 VPWR VGND sg13cmos5l_fill_2
XFILLER_4_19 VPWR VGND sg13cmos5l_decap_4
XFILLER_6_7 VPWR VGND sg13cmos5l_decap_8
XFILLER_5_40 VPWR VGND sg13cmos5l_fill_1
XFILLER_4_4 VPWR VGND sg13cmos5l_fill_1
X_052_ _075_/D _096_/Q _097_/Q VPWR VGND sg13cmos5l_or2_2
XFILLER_0_130 VPWR VGND sg13cmos5l_decap_8
XFILLER_5_30 VPWR VGND sg13cmos5l_fill_1
X_051_ _075_/C _099_/Q _089_/Q VPWR VGND sg13cmos5l_nand2b_1
XFILLER_4_139 VPWR VGND sg13cmos5l_fill_1
XFILLER_0_0 VPWR VGND sg13cmos5l_decap_8
X_096__10 _096__10/L_HI VPWR VGND sg13cmos5l_tiehi
X_050_ _076_/A _073_/A VPWR VGND sg13cmos5l_inv_1
X_093__13 _093__13/L_HI VPWR VGND sg13cmos5l_tiehi
XFILLER_5_21 VPWR VGND sg13cmos5l_fill_1
XFILLER_2_11 VPWR VGND sg13cmos5l_fill_1
XFILLER_2_66 VPWR VGND sg13cmos5l_fill_1
XFILLER_3_130 VPWR VGND sg13cmos5l_decap_8
XFILLER_2_23 VPWR VGND sg13cmos5l_decap_4
XFILLER_0_123 VPWR VGND sg13cmos5l_decap_8
Xclkbuf_1_1__f_div2 _099_/CLK clkbuf_0_div2/X VPWR VGND sg13cmos5l_buf_8
XFILLER_2_7 VPWR VGND sg13cmos5l_decap_4
X_089_ _089_/Q _099_/CLK _089_/D _089__15/L_HI VPWR VGND sg13cmos5l_dfrbpq_1
XFILLER_0_80 VPWR VGND sg13cmos5l_fill_1
XFILLER_6_120 VPWR VGND sg13cmos5l_decap_8
X_088_ _089_/D _086_/Y _087_/X _066_/Y VPWR VGND sg13cmos5l_a21oi_1
XFILLER_5_26 VPWR VGND sg13cmos5l_decap_4
XFILLER_0_137 VPWR VGND sg13cmos5l_fill_2
XFILLER_3_123 VPWR VGND sg13cmos5l_decap_8
XFILLER_2_16 VPWR VGND sg13cmos5l_decap_8
XFILLER_2_27 VPWR VGND sg13cmos5l_fill_2
X_087_ _087_/X _089_/Q _087_/B _087_/C VPWR VGND sg13cmos5l_or3_1
XFILLER_5_38 VPWR VGND sg13cmos5l_fill_2
XFILLER_0_60 VPWR VGND sg13cmos5l_decap_4
XFILLER_0_71 VPWR VGND sg13cmos5l_fill_2
XFILLER_6_92 VPWR VGND sg13cmos5l_decap_8
X_090__7 _090__7/L_HI VPWR VGND sg13cmos5l_tiehi
XFILLER_0_7 VPWR VGND sg13cmos5l_decap_8
X_086_ _086_/Y _087_/B _087_/C _089_/Q VPWR VGND sg13cmos5l_o21ai_1
XFILLER_0_139 VPWR VGND sg13cmos5l_fill_1
X_069_ _069_/Y _073_/B _073_/A VPWR VGND sg13cmos5l_nand2b_1
X_099__5 _099__5/L_HI VPWR VGND sg13cmos5l_tiehi
XFILLER_6_134 VPWR VGND sg13cmos5l_decap_4
X_085_ _087_/B _098_/Q _099_/Q VPWR VGND sg13cmos5l_nand2_1
XFILLER_3_137 VPWR VGND sg13cmos5l_fill_2
X_068_ _094_/D _073_/B _055_/C _073_/A VPWR VGND sg13cmos5l_a21oi_1
Xoutput1 clk_out _092_/Q VPWR VGND sg13cmos5l_buf_1
XFILLER_6_113 VPWR VGND sg13cmos5l_decap_8
X_067_ _091_/D _062_/Y _064_/Y _066_/Y VPWR VGND sg13cmos5l_a21oi_1
X_084_ _099_/D _099_/Q _084_/B VPWR VGND sg13cmos5l_xnor2_1
Xfanout2 _083_/A _098_/Q VPWR VGND sg13cmos5l_buf_1
XFILLER_5_19 VPWR VGND sg13cmos5l_fill_2
XFILLER_5_0 VPWR VGND sg13cmos5l_decap_8
X_083_ _084_/B _083_/A _083_/B VPWR VGND sg13cmos5l_nand2_1
X_066_ _066_/Y _075_/C _075_/D _066_/C _066_/D VPWR VGND sg13cmos5l_nor4_1
XFILLER_0_64 VPWR VGND sg13cmos5l_fill_2
XFILLER_3_139 VPWR VGND sg13cmos5l_fill_1
Xfanout3 _073_/B _095_/Q VPWR VGND sg13cmos5l_buf_1
XFILLER_3_64 VPWR VGND sg13cmos5l_fill_1
X_082_ _098_/D _075_/Y _076_/Y _081_/Y VPWR VGND sg13cmos5l_o21ai_1
X_065_ _066_/D _073_/A _073_/B VPWR VGND sg13cmos5l_nand2b_1
XFILLER_0_21 VPWR VGND sg13cmos5l_decap_8
Xfanout4 _073_/A _094_/Q VPWR VGND sg13cmos5l_buf_1
XFILLER_6_138 VPWR VGND sg13cmos5l_fill_2
XFILLER_6_127 VPWR VGND sg13cmos5l_decap_8
X_095__11 _095__11/L_HI VPWR VGND sg13cmos5l_tiehi
X_081_ _081_/Y _077_/Y _083_/B _078_/X _079_/Y _080_/Y VPWR VGND sg13cmos5l_a221oi_1
XFILLER_3_21 VPWR VGND sg13cmos5l_decap_8
X_092__14 _092__14/L_HI VPWR VGND sg13cmos5l_tiehi
Xclkbuf_1_0__f_div2 _098_/CLK clkbuf_0_div2/X VPWR VGND sg13cmos5l_buf_8
X_064_ _064_/Y _061_/Y _075_/B _083_/B VPWR VGND sg13cmos5l_nand3b_1
XFILLER_6_87 VPWR VGND sg13cmos5l_fill_1
XFILLER_6_76 VPWR VGND sg13cmos5l_decap_8
XFILLER_6_21 VPWR VGND sg13cmos5l_fill_1
XFILLER_6_106 VPWR VGND sg13cmos5l_decap_8
X_080_ _080_/Y _095_/Q _083_/A VPWR VGND sg13cmos5l_nor2b_1
X_063_ _075_/B _091_/Q VPWR VGND sg13cmos5l_inv_1
XFILLER_3_0 VPWR VGND sg13cmos5l_decap_8
XFILLER_0_78 VPWR VGND sg13cmos5l_fill_2
XFILLER_6_99 VPWR VGND sg13cmos5l_decap_8
.ends
