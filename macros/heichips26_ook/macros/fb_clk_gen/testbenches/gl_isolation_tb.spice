* Isolation test: drive fb_clk_gen.xspice (the real synthesized gate-level model)
* with a clean ideal clock, bypassing the noisy analog VCO/vfb path entirely --
* checks whether the 2x discrepancy lives in the synthesized netlist itself or
* in the analog interface upstream of it.

.param VDD=1.5

.control
save all
tran 10p 10u
write gl_isolation_tb.raw
wrdata gl_isolation_tb.txt v(a_clk_i) v(a_clk_out)
.endc

.include /home/belal/HeiChips/heichips26-on-off/macros/heichips26_ook/macros/fb_clk_gen/netlist/xspice/fb_clk_gen.xspice

VVPWR a_VPWR 0 DC {VDD}
VVGND a_VGND 0 DC 0
* ~1.2GHz clean 50% duty clock, matching the real VCO's observed frequency
VCLK a_clk_i 0 PULSE(0 {VDD} 0 20p 20p 396.5p 833.3p)

XDUT a_VPWR a_VGND a_clk_i a_clk_out fb_clk_gen

.end
