** sch_path: /home/belal/HeiChips/heichips26-on-off/macros/heichips26_ook/macros/fb_clk_gen/testbenches/xschem/fb_clk_gen_tb_tran.sch
**.subckt fb_clk_gen_tb_tran
VDD VDD GND {VDD}
vclk clk_i GND pulse(0 {VDD} 0 10p 10p {0.5/fclk} {1/fclk})
x1 VDD GND clk_i clk_out fb_clk_gen
**** begin user architecture code

.include ../../../netlist/xspice/fb_clk_gen.xspice
.param VDD=1.5
.param temp=27
.param fclk=433.92e6
.csparam fclk=fclk
.options savecurrents klu method=gear reltol=1e-4 abstol=1e-15 gmin=1e-15
.control

set num_threads=8

save all

* User Constants
let tstop = 1e-4
let tstep = 1/fclk

* Operating Point Analysis
op
remzerovec
write fb_clk_gen_tb_tran.raw
set appendwrite

* Transient Analysis
tran $&tstep $&tstop
write fb_clk_gen_tb_tran.raw

plot v(clk_i)
plot v(clk_i) v(clk_out)

* Writing Data
unset appendwrite
set wr_vecnames
set wr_singlescale
wrdata ../plot_simulations/data/fb_clk_gen_tb_tran.txt clk_i clk_out
set appendwrite

let clk_out_fft = clk_out
linearize clk_out_fft
fft clk_out_fft
let clk_out_spectrum_db = db(mag(clk_out_fft))
write fb_clk_gen_tb_tran.raw

plot clk_out_spectrum_db

*quit
.endc

.lib cornerMOSlv.lib mos_tt
.lib cornerMOShv.lib mos_tt
.lib cornerRES.lib res_typ
.lib cornerDIO.lib dio_tt

**** end user architecture code
**.ends
.GLOBAL GND
.GLOBAL VDD
.end
