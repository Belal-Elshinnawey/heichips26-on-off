** sch_path: /home/belal/HeiChips/heichips26-on-off/macros/heichips26_ook_top/macros/ook_analog_system/testbenches/xschem/lna_tb_inp_imp.sch
**.subckt lna_tb_inp_imp
VDD1 VDD GND {VDD}
I0 GND i_in dc 0 ac 1
x1 VDD vout net2 GND lna_pex
x2 GND VDD GND VDD net1 net2 sg13cmos5l_IOPadAnalog
Cb1 net3 net1 1p
C2 GND net3 1n
L12 net3 GND 134.5p
C1 net4 net3 0.558p
L6 net3 GND 138.95n
RBIAS i_in GND 10meg
C3 net4 i_in 10.02p
L14 net4 GND 17.56n
**** begin user architecture code

.param VDD=3.3
.param temp=27
.options savecurrents klu reltol=1e-4 abstol=1e-15 gmin=1e-15 rshunt=1e9

.control
let Rs = 50
let f_ism = 433.92e6

save all
op
print all
write lna_tb_inp_imp\.raw
set appendwrite

ac lin 401 200e6 600e6

let Zin      = v(i_in)
let Zin_mag  = mag(Zin)
let Zin_re   = real(Zin)
let Zin_im   = imag(Zin)
let Zin_ph   = 180/PI*cphase(Zin)

let Zpin     = v(net1)
let Zpin_mag = mag(Zpin)
let Zpin_re  = real(Zpin)
let Zpin_im  = imag(Zpin)

let Gam    = (Zin - Rs)/(Zin + Rs)
let Gmag   = mag(Gam)
let S11_dB = db(Gmag)
let ML_dB  = -10*log10(1 - Gmag*Gmag)

remzerovec
write lna_tb_inp_imp\.raw
unset appendwrite

meas ac Zmag_ism find Zin_mag  when frequency=$&f_ism
meas ac Zre_ism  find Zin_re   when frequency=$&f_ism
meas ac Zim_ism  find Zin_im   when frequency=$&f_ism
meas ac Zph_ism  find Zin_ph   when frequency=$&f_ism

meas ac Zpre_ism find Zpin_re  when frequency=$&f_ism
meas ac Zpim_ism find Zpin_im  when frequency=$&f_ism

meas ac S11_ism  find S11_dB   when frequency=$&f_ism
meas ac ML_ism   find ML_dB    when frequency=$&f_ism

echo
echo   Zin  magnitude = $&Zmag_ism ohm
echo   Zin  real      = $&Zre_ism ohm
echo   Zin  imag      = $&Zim_ism ohm
echo   Zin  phase     = $&Zph_ism deg
echo
echo   Zpin real      = $&Zpre_ism ohm
echo   Zpin imag      = $&Zpim_ism ohm
echo
echo   S11            = $&S11_ism dB
echo   mismatch loss  = $&ML_ism dB
echo

plot Zin_re Zin_im xlimit 200e6 600e6 ylabel 'Zin real / imag [ohm]' xlabel 'Frequency [Hz]'

.endc

.lib cornerMOSlv.lib mos_tt
.lib cornerMOShv.lib mos_tt
.lib cornerRES.lib res_typ
.lib cornerDIO.lib dio_tt
.include /home/belal/HeiChips/heichips26-on-off/macros/heichips26_ook_top/macros/ook_analog_system/netlist/pex/lna_magic_pex_3.spice
.include /home/belal/HeiChips/heichips26-on-off/IHP-Open-PDK/ihp-sg13cmos5l/libs.ref/sg13cmos5l_io/spice/sg13cmos5l_io.spi

**** end user architecture code
**.ends
.GLOBAL GND
.GLOBAL VDD
.end
