* Extracted by KLayout with SG13CMOS5L LVS runset on : 29/09/2026 02:43

.SUBCKT heichips26_ook_top VAPWR VGND VPWR analog_0 analog_1 analog_2 clk
+ clk_ref data_in_tx in_tieoff in_tieon q0 q0_d q1 q1_d q2 q2_d q3 q3_d rst_n
+ rst_n_in vctrl_b_in vctrl_in
X$301 VPWR \$3317 VGND \$2854 \$2985 \$3496 \$3106 sg13cmos5l_nand4_1
X$303 VPWR VGND \$2783 \$2786 \$2780 \$2854 \$2792 sg13cmos5l_or4_1
X$325 VGND \$1625 VPWR \$1595 \$526 sg13cmos5l_xor2_1
X$326 VGND \$4016 VPWR \$4148 \$2982 sg13cmos5l_xor2_1
X$327 VGND \$2183 VPWR \$2182 \$2233 sg13cmos5l_xor2_1
X$328 VGND \$4213 VPWR \$4412 \$4513 sg13cmos5l_xor2_1
X$329 VGND \$4008 VPWR \$3364 \$3685 sg13cmos5l_xor2_1
X$330 VGND \$1963 VPWR \$1856 \$2181 sg13cmos5l_xor2_1
X$331 VGND \$3995 VPWR \$3869 \$3389 sg13cmos5l_xor2_1
X$332 VGND \$3237 VPWR \$3028 \$2984 sg13cmos5l_xor2_1
X$333 VGND \$4135 VPWR \$4008 \$3895 sg13cmos5l_xor2_1
X$334 VGND \$3902 VPWR \$3623 \$3378 sg13cmos5l_xor2_1
X$335 VGND \$3922 VPWR \$3512 \$3385 sg13cmos5l_xor2_1
X$336 VGND \$3505 VPWR \$3504 \$3506 sg13cmos5l_xor2_1
X$337 VGND \$4501 VPWR \$3586 \$4354 sg13cmos5l_xor2_1
X$338 VGND \$2918 VPWR \$2924 \$2985 sg13cmos5l_xor2_1
X$339 VGND \$3233 VPWR \$3083 \$3314 sg13cmos5l_xor2_1
X$340 VGND \$4265 VPWR \$3378 \$3948 sg13cmos5l_xor2_1
X$341 VGND \$3894 VPWR \$4061 \$2766 sg13cmos5l_xor2_1
X$342 VGND \$4026 VPWR \$3798 \$3453 sg13cmos5l_xor2_1
X$343 VGND \$3645 VPWR \$3040 \$3385 sg13cmos5l_xor2_1
X$344 VGND \$2401 VPWR \$2491 \$1898 sg13cmos5l_xor2_1
X$345 VGND \$4513 VPWR \$3389 \$4368 sg13cmos5l_xor2_1
X$346 VGND \$3074 VPWR \$2902 \$2636 sg13cmos5l_xor2_1
X$408 VPWR VGND \$4358 \$3035 \$4356 sg13cmos5l_xnor2_1
X$409 VPWR VGND \$4308 \$3039 \$4223 sg13cmos5l_xnor2_1
X$410 VPWR VGND \$3900 \$4015 \$3378 sg13cmos5l_xnor2_1
X$411 VPWR VGND \$2899 \$2326 \$2814 sg13cmos5l_xnor2_1
X$412 VPWR VGND \$2902 \$742 \$2772 sg13cmos5l_xnor2_1
X$413 VPWR VGND \$3089 \$2918 \$2917 sg13cmos5l_xnor2_1
X$414 VPWR VGND \$3142 \$3036 \$3106 sg13cmos5l_xnor2_1
X$415 VPWR \$2554 VGND \$2786 \$3031 \$3039 \$3043 sg13cmos5l_nand4_1
X$416 VPWR VGND \$3749 \$3514 \$3388 sg13cmos5l_xnor2_1
X$417 VPWR VGND \$2532 \$2458 \$2537 sg13cmos5l_xnor2_1
X$418 VPWR VGND \$2029 \$2030 \$2080 sg13cmos5l_xnor2_1
X$419 VPWR VGND \$2647 \$2536 \$2537 sg13cmos5l_xnor2_1
X$420 VPWR VGND \$4084 \$2982 \$4352 sg13cmos5l_xnor2_1
X$421 VPWR VGND \$3128 \$2334 \$3364 sg13cmos5l_xnor2_1
X$422 VPWR VGND \$4303 \$4373 \$4300 sg13cmos5l_xnor2_1
X$423 VPWR VGND \$3964 \$3969 \$3581 sg13cmos5l_xnor2_1
X$424 VPWR VGND \$4269 \$4235 \$4186 sg13cmos5l_xnor2_1
X$425 VPWR VGND \$526 \$1020 \$996 sg13cmos5l_xnor2_1
X$426 VPWR VGND \$3838 \$3773 \$3496 sg13cmos5l_xnor2_1
X$427 VPWR VGND \$1615 \$1740 \$373 sg13cmos5l_xnor2_1
X$428 VPWR VGND \$4367 \$4512 \$4510 sg13cmos5l_xnor2_1
X$429 VPWR VGND \$3022 \$3090 \$2918 sg13cmos5l_xnor2_1
X$430 VPWR VGND \$3028 \$2990 \$3586 sg13cmos5l_xnor2_1
X$431 VPWR VGND \$4220 \$3891 \$4123 sg13cmos5l_xnor2_1
X$432 VPWR VGND \$4061 \$2839 \$3945 sg13cmos5l_xnor2_1
X$433 VPWR VGND \$2764 \$2594 \$2529 sg13cmos5l_xnor2_1
X$434 VPWR VGND \$3083 \$3236 \$3317 sg13cmos5l_xnor2_1
X$435 VPWR VGND \$3748 \$3612 \$3506 sg13cmos5l_xnor2_1
X$436 VPWR VGND \$2131 \$2187 \$283 sg13cmos5l_xnor2_1
X$437 VPWR VGND \$2799 \$742 \$2358 sg13cmos5l_xnor2_1
X$438 VPWR VGND \$2087 \$2038 \$2091 sg13cmos5l_xnor2_1
X$439 VPWR VGND \$4123 \$3936 \$2804 sg13cmos5l_xnor2_1
X$440 VPWR VGND \$3478 \$3128 \$3080 sg13cmos5l_xnor2_1
X$441 VPWR VGND \$3592 \$3142 \$3204 sg13cmos5l_xnor2_1
X$475 VPWR VGND \$1082 \$233 \$592 \$523 sg13cmos5l_or3_1
X$476 VPWR VGND \$3969 \$3586 \$3035 \$3798 sg13cmos5l_or3_1
X$487 VGND VPWR \$828 \$755 \$235 \$78 sg13cmos5l_nand3_1
X$488 VGND VPWR \$2997 \$3043 \$3040 \$3039 sg13cmos5l_nand3_1
X$489 VGND VPWR \$3383 \$3142 \$3201 \$3330 sg13cmos5l_nand3_1
X$490 VGND VPWR \$3032 \$2881 \$2913 \$3035 sg13cmos5l_nand3_1
X$491 VGND VPWR \$1993 \$863 \$1763 \$1907 sg13cmos5l_nand3_1
X$492 VGND VPWR \$3687 \$3549 \$2823 \$3424 sg13cmos5l_nand3_1
X$493 VGND VPWR \$3302 \$3128 \$2958 \$2772 sg13cmos5l_nand3_1
X$494 VGND VPWR \$3319 \$1979 \$2913 \$3378 sg13cmos5l_nand3_1
X$495 VGND VPWR \$694 \$930 \$373 \$555 sg13cmos5l_nand3_1
X$496 VGND VPWR \$3096 \$3028 \$3025 \$3027 sg13cmos5l_nand3_1
X$497 VGND VPWR \$289 \$592 \$373 \$233 sg13cmos5l_nand3_1
X$498 VGND VPWR \$2563 \$2673 \$2679 \$2678 sg13cmos5l_nand3_1
X$499 VGND VPWR \$3016 \$3083 \$3017 \$3084 sg13cmos5l_nand3_1
X$500 VGND VPWR \$2920 \$2553 \$2393 \$2982 sg13cmos5l_nand3_1
X$501 VGND VPWR \$3773 \$2982 \$3623 \$3317 sg13cmos5l_nand3_1
X$502 VGND VPWR \$1475 \$1429 \$1231 \$1408 sg13cmos5l_nand3_1
X$515 VPWR VGND \$3080 \$2772 \$2326 \$2245 sg13cmos5l_a21o_1
X$516 VPWR VGND \$3086 \$3087 \$2975 \$3022 sg13cmos5l_a21o_1
X$517 VPWR VGND \$2546 \$2601 \$2333 \$1710 sg13cmos5l_a21o_1
X$518 VPWR VGND \$3904 \$2543 \$3773 \$3626 sg13cmos5l_a21o_1
X$519 VPWR VGND \$2261 \$2144 \$863 \$1763 sg13cmos5l_a21o_1
X$520 VPWR VGND \$2218 \$1599 \$1635 \$177 sg13cmos5l_a21o_1
X$521 VPWR VGND \$3892 \$3655 \$3742 \$3654 sg13cmos5l_a21o_1
X$522 VPWR VGND \$2260 \$1635 \$2002 \$2382 sg13cmos5l_a21o_1
X$523 VPWR VGND \$2679 \$2802 \$2801 \$2800 sg13cmos5l_a21o_1
X$524 VPWR VGND \$4300 \$4514 \$4513 \$4412 sg13cmos5l_a21o_1
X$525 VPWR VGND \$2309 \$2482 \$2394 \$2542 sg13cmos5l_a21o_1
X$526 VPWR VGND \$3626 \$2982 \$3317 \$3623 sg13cmos5l_a21o_1
X$527 VPWR VGND \$685 \$639 \$300 \$636 sg13cmos5l_a21o_1
X$528 VPWR VGND \$3017 \$3128 \$2772 \$2958 sg13cmos5l_a21o_1
X$529 VPWR VGND \$3201 \$3028 \$3027 \$3025 sg13cmos5l_a21o_1
X$530 VPWR VGND \$2533 \$2538 \$2394 \$2650 sg13cmos5l_a21o_1
X$531 VPWR VGND \$4046 \$4300 \$4223 \$3039 sg13cmos5l_a21o_1
X$532 VPWR VGND \$235 \$526 \$521 \$523 sg13cmos5l_a21o_1
X$565 VPWR VGND \$2500 \$2254 \$2216 \$2345 sg13cmos5l_nand3b_1
X$566 VPWR VGND \$485 \$1082 \$592 \$930 sg13cmos5l_nand3b_1
X$567 VPWR VGND \$2133 \$1763 \$2504 \$2349 sg13cmos5l_nand3b_1
X$568 VPWR VGND \$996 \$555 \$1020 \$1082 \$307 sg13cmos5l_nor4_1
X$569 VPWR VGND \$3389 \$3385 \$3108 \$3249 \$3255 sg13cmos5l_nor4_1
X$570 VPWR VGND \$3364 \$2839 \$3378 \$3074 \$4148 sg13cmos5l_nor4_1
X$571 VPWR VGND \$3389 \$3453 \$3039 \$3798 \$3042 sg13cmos5l_nor4_1
X$572 VPWR VGND \$1021 \$1504 \$1412 \$786 \$1429 sg13cmos5l_nor4_1
X$573 VPWR VGND \$2783 \$2780 \$2854 \$2786 \$2543 sg13cmos5l_nor4_1
X$574 VPWR VGND \$786 \$1227 \$924 \$1137 \$1181 sg13cmos5l_nor4_1
X$575 VPWR VGND \$1961 \$2178 \$1856 \$2393 \$2636 sg13cmos5l_nor4_1
X$576 VPWR VGND \$742 \$379 \$570 \$629 \$814 sg13cmos5l_nor4_1
X$577 VGND \$967 \$233 \$95 \$375 VPWR sg13cmos5l_mux2_1
X$578 VGND \$3049 \$2504 \$2556 \$3048 VPWR sg13cmos5l_mux2_1
X$579 VGND \$2955 \$2245 \$2899 \$2772 VPWR sg13cmos5l_mux2_1
X$580 VGND \$3215 \$2504 \$2730 \$3042 VPWR sg13cmos5l_mux2_1
X$581 VGND \$941 \$584 \$1356 \$708 VPWR sg13cmos5l_mux2_1
X$582 VGND \$2958 \$2636 \$2902 \$2899 VPWR sg13cmos5l_mux2_1
X$583 VGND \$628 \$83 VPWR sg13cmos5l_buf_8
X$584 VGND \$1702 \$1491 VPWR sg13cmos5l_buf_8
X$585 VGND \$1236 \$1293 VPWR sg13cmos5l_buf_8
X$586 VGND \$1744 \$1700 VPWR sg13cmos5l_buf_8
X$587 VGND clk_ref \$628 VPWR sg13cmos5l_buf_8
X$588 VGND \$628 \$3959 VPWR sg13cmos5l_buf_8
X$589 VGND \$1702 \$2103 VPWR sg13cmos5l_buf_8
X$590 VGND \$628 \$2376 VPWR sg13cmos5l_buf_8
X$591 VGND \$1342 \$1744 VPWR sg13cmos5l_buf_8
X$592 VGND \$1161 \$1859 VPWR sg13cmos5l_buf_8
X$593 VGND \$1214 \$1745 VPWR sg13cmos5l_buf_8
X$594 VGND \$1555 \$573 VPWR sg13cmos5l_buf_8
X$595 VGND \$1734 \$1161 VPWR sg13cmos5l_buf_8
X$596 VGND \$628 \$2190 VPWR sg13cmos5l_buf_8
X$597 VGND \$1416 \$1236 VPWR sg13cmos5l_buf_8
X$598 VGND \$1161 \$554 VPWR sg13cmos5l_buf_8
X$599 VGND \$1214 \$734 VPWR sg13cmos5l_buf_8
X$600 VGND \$1342 \$1341 VPWR sg13cmos5l_buf_8
X$601 VGND \$1755 \$1702 VPWR sg13cmos5l_buf_8
X$602 VGND \$1805 VPWR \$1599 \$1020 sg13cmos5l_xor2_1
X$603 VGND \$628 \$3864 VPWR sg13cmos5l_buf_8
X$604 VGND \$1298 \$1734 VPWR sg13cmos5l_buf_8
X$605 VGND \$1341 \$1214 VPWR sg13cmos5l_buf_8
X$606 VGND \$1416 \$1755 VPWR sg13cmos5l_buf_8
X$607 VGND \$628 \$1204 VPWR sg13cmos5l_buf_8
X$608 VGND \$1298 \$1555 VPWR sg13cmos5l_buf_8
X$609 VGND \$628 \$1643 VPWR sg13cmos5l_buf_8
X$610 \$836 VGND VPWR \$854 \$431 \$515 \$33 sg13cmos5l_a22oi_1
X$611 \$2185 VGND VPWR \$2265 \$2309 \$2237 \$2238 sg13cmos5l_a22oi_1
X$612 \$934 VGND VPWR \$849 \$1082 \$1166 \$927 sg13cmos5l_a22oi_1
X$613 \$447 VGND VPWR \$451 \$98 \$963 \$204 sg13cmos5l_a22oi_1
X$614 \$3465 VGND VPWR \$2730 \$3394 \$3270 \$2554 sg13cmos5l_a22oi_1
X$615 \$238 VGND VPWR \$927 \$1020 \$708 \$584 sg13cmos5l_a22oi_1
X$616 \$540 VGND VPWR \$708 \$584 \$990 \$930 sg13cmos5l_a22oi_1
X$617 \$636 VGND VPWR \$238 \$687 \$635 \$440 sg13cmos5l_a22oi_1
X$618 \$2939 VGND VPWR \$3049 \$2612 \$3007 \$2510 sg13cmos5l_a22oi_1
X$619 \$3394 VGND VPWR \$3391 \$2804 \$2556 \$3266 sg13cmos5l_a22oi_1
X$620 \$960 VGND VPWR \$451 \$964 \$963 \$959 sg13cmos5l_a22oi_1
X$621 \$538 VGND VPWR \$307 \$31 \$593 \$178 sg13cmos5l_a22oi_1
X$622 \$506 VGND VPWR \$631 \$431 \$714 \$33 sg13cmos5l_a22oi_1
X$623 VPWR VGND \$786 \$612 \$857 \$861 sg13cmos5l_or3_1
X$624 \$2526 VGND VPWR \$2260 \$2533 \$2631 \$2537 sg13cmos5l_a22oi_1
X$727 \$2382 \$2800 \$2930 VPWR VGND sg13cmos5l_or2_1
X$728 \$3424 \$3366 \$2334 VPWR VGND sg13cmos5l_or2_1
X$729 \$3251 \$4212 \$3972 VPWR VGND sg13cmos5l_or2_1
X$730 \$2772 \$2823 \$2245 VPWR VGND sg13cmos5l_or2_1
X$731 \$1021 \$1227 \$1336 VPWR VGND sg13cmos5l_or2_1
X$732 \$33 \$438 \$631 VPWR VGND sg13cmos5l_or2_1
X$733 \$2265 \$4030 \$4112 VPWR VGND sg13cmos5l_or2_1
X$734 \$2633 \$2638 \$2454 VPWR VGND sg13cmos5l_or2_1
X$735 \$996 \$1356 \$1020 VPWR VGND sg13cmos5l_or2_1
X$736 \$283 \$2321 \$485 VPWR VGND sg13cmos5l_or2_1
X$737 \$379 \$623 \$570 VPWR VGND sg13cmos5l_or2_1
X$738 \$1028 \$796 \$849 VPWR VGND sg13cmos5l_or2_1
X$739 VGND VPWR \$4351 \$4085 \$4499 sg13cmos5l_nor2b_1
X$740 VGND VPWR \$4355 \$4503 \$4357 sg13cmos5l_nor2b_1
X$741 VGND VPWR \$3190 \$3085 \$3016 sg13cmos5l_nor2b_1
X$742 VGND VPWR \$3451 \$3249 \$3383 sg13cmos5l_nor2b_1
X$743 VGND VPWR \$4512 \$4408 \$4407 sg13cmos5l_nor2b_1
X$744 VGND VPWR \$1166 \$930 \$996 sg13cmos5l_nor2b_1
X$745 VGND VPWR \$3512 \$2854 \$3623 sg13cmos5l_nor2b_1
X$746 VGND VPWR \$317 \$592 \$930 sg13cmos5l_nor2b_1
X$747 VGND VPWR \$3897 \$4015 \$4340 sg13cmos5l_nor2b_1
X$748 VGND VPWR \$1581 \$1504 \$808 sg13cmos5l_nor2b_1
X$749 VGND VPWR \$2491 \$2333 \$2038 sg13cmos5l_nor2b_1
X$750 VGND VPWR \$3768 \$3623 \$3687 sg13cmos5l_nor2b_1
X$754 VGND \$1141 VPWR \$1763 \$906 \$177 \$1475 \$992 sg13cmos5l_a221oi_1
X$755 VGND \$4016 VPWR \$3957 \$2540 \$2653 \$3225 \$3904 sg13cmos5l_a221oi_1
X$756 VGND \$3478 VPWR \$3680 \$3225 \$3227 \$2975 \$3363 sg13cmos5l_a221oi_1
X$757 VGND \$669 VPWR \$531 \$623 \$629 \$78 \$510 sg13cmos5l_a221oi_1
X$758 VGND \$337 \$584 \$526 \$523 VPWR sg13cmos5l_mux2_1
X$759 VGND \$3237 VPWR \$3240 \$2382 \$3227 \$2975 \$3243 sg13cmos5l_a221oi_1
X$760 VGND \$3233 VPWR \$3230 \$3225 \$3227 \$2975 \$3190 sg13cmos5l_a221oi_1
X$761 VGND \$3592 VPWR \$3725 \$3347 \$3227 \$2975 \$3451 sg13cmos5l_a221oi_1
X$762 VGND \$2955 VPWR \$3291 \$3225 \$3227 \$2958 \$2975 sg13cmos5l_a221oi_1
X$763 VGND \$299 VPWR \$368 \$237 \$240 \$31 \$75 sg13cmos5l_a221oi_1
X$764 VGND \$2540 VPWR \$2538 \$2647 \$2653 \$2418 \$2543 sg13cmos5l_a221oi_1
X$765 VGND \$3995 VPWR \$4112 \$2540 \$2802 \$3347 \$3932 sg13cmos5l_a221oi_1
X$766 VGND \$963 VPWR \$1558 \$1700 \$1695 \$1293 \$1166 sg13cmos5l_a221oi_1
X$767 VGND \$1166 VPWR \$1219 \$1164 \$555 \$483 \$317 sg13cmos5l_a221oi_1
X$768 VGND \$452 VPWR \$805 \$1558 \$373 \$960 \$1219 sg13cmos5l_a221oi_1
X$769 VGND \$3645 VPWR \$3729 \$3347 \$3227 \$3253 \$3502 sg13cmos5l_a221oi_1
X$770 VGND \$3748 VPWR \$3741 \$3347 \$3227 \$3253 \$3505 sg13cmos5l_a221oi_1
X$771 VGND \$2388 VPWR \$2482 \$2540 \$2653 \$2382 \$2543 sg13cmos5l_a221oi_1
X$772 VGND \$3973 VPWR \$3972 \$2540 \$2802 \$3347 \$3855 sg13cmos5l_a221oi_1
X$773 VGND \$2556 VPWR \$2394 \$2554 \$2415 \$2261 \$1993 sg13cmos5l_a221oi_1
X$774 VGND \$3895 VPWR \$4009 \$4008 \$3824 \$3948 \$3378 sg13cmos5l_a221oi_1
X$812 VPWR VGND \$1011 \$584 \$526 sg13cmos5l_and2_1
X$813 VPWR VGND \$3545 \$3424 \$2334 sg13cmos5l_and2_1
X$814 VPWR VGND \$3043 \$3385 \$3389 sg13cmos5l_and2_1
X$815 VPWR VGND \$2540 \$2794 \$2930 sg13cmos5l_and2_1
X$816 VPWR VGND \$348 \$438 \$308 sg13cmos5l_and2_1
X$817 VPWR VGND \$662 \$343 \$306 sg13cmos5l_and2_1
X$818 VPWR VGND \$4514 \$4295 \$3389 sg13cmos5l_and2_1
X$819 VPWR VGND \$3514 \$3043 \$3512 sg13cmos5l_and2_1
X$820 VPWR VGND \$2794 \$1763 \$1711 sg13cmos5l_and2_1
X$821 VPWR VGND \$3363 \$3017 \$3302 sg13cmos5l_and2_1
X$822 VPWR VGND \$1633 \$1559 \$1205 sg13cmos5l_and2_1
X$823 VPWR VGND \$3824 \$3685 \$3364 sg13cmos5l_and2_1
X$824 VPWR VGND \$451 \$592 \$930 sg13cmos5l_and2_1
X$825 VPWR VGND \$3199 \$3378 \$3236 sg13cmos5l_and2_1
X$826 VPWR VGND \$3243 \$3201 \$3096 sg13cmos5l_and2_1
X$827 VPWR VGND \$369 \$555 \$373 sg13cmos5l_and2_1
X$828 VPWR VGND \$629 \$49 \$694 sg13cmos5l_and2_1
X$829 VPWR VGND \$987 \$1581 \$1575 sg13cmos5l_and2_1
X$830 VPWR VGND \$4042 \$2554 \$3042 sg13cmos5l_and2_1
X$831 VPWR VGND \$306 \$435 \$124 sg13cmos5l_and2_1
X$832 VPWR VGND \$1435 \$644 \$1179 sg13cmos5l_and2_1
X$833 VPWR VGND \$2649 \$2633 \$2454 sg13cmos5l_and2_1
X$834 VPWR VGND \$1595 \$1475 \$992 sg13cmos5l_and2_1
X$835 VPWR VGND \$3108 \$3035 \$3036 sg13cmos5l_and2_1
X$836 VPWR VGND \$4394 \$4352 \$2982 sg13cmos5l_and2_1
X$837 VPWR VGND \$36 \$178 \$176 sg13cmos5l_and2_1
X$838 VPWR VGND \$124 \$85 \$36 sg13cmos5l_and2_1
X$839 VPWR VGND \$1711 \$858 \$987 sg13cmos5l_and2_1
X$840 VPWR VGND \$1020 \$996 \$927 sg13cmos5l_nand2b_1
X$841 VPWR VGND \$2638 \$2649 \$2594 sg13cmos5l_nand2b_1
X$842 VPWR VGND \$1136 \$1094 \$1137 sg13cmos5l_nand2b_1
X$843 VPWR VGND \$4148 \$2982 \$3969 sg13cmos5l_nand2b_1
X$844 VPWR VGND \$77 \$1807 \$1710 sg13cmos5l_nand2b_1
X$845 VPWR VGND \$630 \$49 \$669 sg13cmos5l_nand2b_1
X$846 VPWR VGND \$631 \$708 \$584 \$451 sg13cmos5l_a21o_1
X$847 VPWR VGND \$592 \$930 \$990 sg13cmos5l_nand2b_1
X$848 VPWR VGND \$2593 \$2536 \$2388 sg13cmos5l_nand2b_1
X$849 VPWR VGND \$3452 \$3504 \$3502 sg13cmos5l_nand2b_1
X$850 VPWR VGND \$78 \$238 \$344 sg13cmos5l_nand2b_1
X$851 VPWR VGND \$3869 \$3389 \$4038 sg13cmos5l_nand2b_1
X$852 VPWR VGND \$2143 \$1907 \$2144 sg13cmos5l_nand2b_1
X$853 VPWR VGND \$4190 \$3586 \$3251 sg13cmos5l_nand2_1
X$854 VPWR VGND \$3227 \$2802 \$3341 sg13cmos5l_nand2_1
X$855 VPWR VGND \$3007 \$2510 \$3215 sg13cmos5l_nand2_1
X$856 VPWR VGND \$3391 \$3043 \$3040 sg13cmos5l_nand2_1
X$857 VPWR VGND \$3341 \$2554 \$2556 sg13cmos5l_nand2_1
X$858 VPWR VGND \$3612 \$3385 \$3040 sg13cmos5l_nand2_1
X$859 VPWR VGND \$2346 \$2216 \$1710 sg13cmos5l_nand2_1
X$860 VPWR VGND \$3890 \$2554 \$3936 sg13cmos5l_nand2_1
X$861 VPWR VGND \$2187 \$1599 \$2386 sg13cmos5l_nand2_1
X$862 VPWR VGND \$2364 \$1856 \$2265 sg13cmos5l_nand2_1
X$863 VPWR VGND \$854 \$755 \$994 sg13cmos5l_nand2_1
X$864 VPWR VGND \$3036 \$2881 \$2913 sg13cmos5l_nand2_1
X$865 VPWR VGND \$2990 \$2099 \$2913 sg13cmos5l_nand2_1
X$866 VPWR VGND \$2741 \$2345 \$1710 sg13cmos5l_nand2_1
X$867 VPWR VGND \$2387 \$1166 \$1595 sg13cmos5l_nand2_1
X$868 VPWR VGND \$2924 \$2553 \$2393 sg13cmos5l_nand2_1
X$869 VPWR VGND \$2542 \$2388 \$2975 sg13cmos5l_nand2_1
X$870 VPWR VGND \$1913 \$2104 \$1710 sg13cmos5l_nand2_1
X$871 VPWR VGND \$3236 \$1979 \$2913 sg13cmos5l_nand2_1
X$872 VPWR VGND \$2663 \$2605 \$1710 sg13cmos5l_nand2_1
X$873 VPWR VGND \$2130 \$2178 \$1961 sg13cmos5l_nand2_1
X$874 VPWR VGND \$2930 \$3044 \$3042 sg13cmos5l_nand2_1
X$875 VPWR VGND \$2194 \$2038 \$1710 sg13cmos5l_nand2_1
X$876 VPWR VGND \$2880 \$2794 \$2930 sg13cmos5l_nand2_1
X$877 VPWR VGND \$354 \$440 \$235 sg13cmos5l_nand2_1
X$878 VPWR VGND \$1179 \$584 \$317 sg13cmos5l_nand2_1
X$879 VPWR VGND \$2650 \$2975 \$2647 sg13cmos5l_nand2_1
X$880 VPWR VGND \$3782 \$2982 \$3251 sg13cmos5l_nand2_1
X$881 VPWR VGND \$786 \$796 \$808 sg13cmos5l_nand2_1
X$882 VPWR VGND \$521 \$555 \$373 sg13cmos5l_nand2_1
X$883 VPWR VGND \$2002 \$863 \$1763 sg13cmos5l_nand2_1
X$884 VPWR VGND \$319 \$374 \$317 sg13cmos5l_nand2_1
X$885 VPWR VGND \$362 \$178 \$540 sg13cmos5l_nand2_1
X$886 VPWR VGND \$542 \$541 \$368 \$443 \$512 sg13cmos5l_nor4_1
X$887 VPWR VGND \$542 \$438 \$506 \$612 sg13cmos5l_nand3b_1
X$888 VPWR VGND \$4316 \$4354 \$3586 sg13cmos5l_nand2_1
X$889 VPWR VGND \$2673 \$2799 \$2394 sg13cmos5l_nand2_1
X$890 VPWR VGND \$2418 \$1763 \$1711 sg13cmos5l_nand2_1
X$891 VPWR VGND \$3330 \$3586 \$2990 sg13cmos5l_nand2_1
X$892 VPWR VGND \$4105 \$3389 \$2265 sg13cmos5l_nand2_1
X$893 VPWR VGND \$3973 \$3798 \$3971 sg13cmos5l_nand2_1
X$894 VPWR VGND \$3756 \$3317 \$3251 sg13cmos5l_nand2_1
X$895 VPWR VGND \$4380 \$3945 \$2839 sg13cmos5l_nand2_1
X$896 VPWR VGND \$290 \$137 \$289 sg13cmos5l_nand2_1
X$897 VPWR VGND \$3334 \$3125 \$3251 sg13cmos5l_nand2_1
X$898 VPWR VGND \$593 \$849 \$990 sg13cmos5l_nand2_1
X$899 VPWR VGND \$4154 \$3035 \$3251 sg13cmos5l_nand2_1
X$900 VPWR VGND \$2233 \$2181 \$1856 sg13cmos5l_nand2_1
X$901 VPWR VGND \$2531 \$2080 \$2030 sg13cmos5l_nand2_1
X$902 VPWR VGND \$3716 \$3413 \$3251 sg13cmos5l_nand2_1
X$903 VPWR VGND \$2417 \$2361 \$1710 sg13cmos5l_nand2_1
X$904 VPWR VGND \$515 \$523 \$485 sg13cmos5l_nand2_1
X$905 VPWR VGND \$3861 \$3385 \$3251 sg13cmos5l_nand2_1
X$906 VPWR VGND \$3549 \$2839 \$2913 sg13cmos5l_nand2_1
X$907 VPWR VGND \$3084 \$3364 \$2334 sg13cmos5l_nand2_1
X$908 VPWR VGND \$3654 \$2802 \$3465 sg13cmos5l_nand2_1
X$909 VPWR VGND \$452 \$573 \$451 sg13cmos5l_nand2_1
X$910 VPWR VGND \$4407 \$4365 \$3453 sg13cmos5l_nand2_1
X$911 VPWR VGND \$849 \$521 \$523 sg13cmos5l_nand2_1
X$912 VPWR VGND \$3027 \$2985 \$2924 sg13cmos5l_nand2_1
X$913 VPWR VGND \$2094 \$1898 \$1710 sg13cmos5l_nand2_1
X$1049 VGND \$638 VPWR \$31 \$708 \$756 sg13cmos5l_o21ai_1
X$1050 VGND VPWR \$639 \$755 \$638 \$362 sg13cmos5l_nand3_1
X$1051 VGND \$456 VPWR \$538 \$534 \$531 sg13cmos5l_o21ai_1
X$1052 VGND \$938 VPWR \$178 \$742 \$1011 sg13cmos5l_o21ai_1
X$1053 VGND \$2253 VPWR \$2346 \$2337 \$2133 sg13cmos5l_o21ai_1
X$1054 VGND \$3774 VPWR \$3782 \$3700 \$3957 sg13cmos5l_o21ai_1
X$1055 VGND \$3921 VPWR \$2678 \$3923 \$2802 sg13cmos5l_o21ai_1
X$1056 VGND \$3887 VPWR \$3890 \$3891 \$4006 sg13cmos5l_o21ai_1
X$1057 VGND \$534 VPWR \$354 \$593 \$31 sg13cmos5l_o21ai_1
X$1058 VGND \$3821 VPWR \$3825 \$3897 \$2880 sg13cmos5l_o21ai_1
X$1059 VGND \$3760 VPWR \$2678 \$3821 \$2653 sg13cmos5l_o21ai_1
X$1060 VGND \$3910 VPWR \$3779 \$3964 \$2880 sg13cmos5l_o21ai_1
X$1061 VGND \$2984 VPWR \$2920 \$2918 \$2917 sg13cmos5l_o21ai_1
X$1062 VGND \$2801 VPWR \$2799 \$2792 \$2794 sg13cmos5l_o21ai_1
X$1063 VGND \$3040 VPWR \$3032 \$3202 \$3204 sg13cmos5l_o21ai_1
X$1064 VGND \$2565 VPWR \$2364 \$2563 \$2680 sg13cmos5l_o21ai_1
X$1065 VGND \$3314 VPWR \$3366 \$3545 \$3080 sg13cmos5l_o21ai_1
X$1066 VGND \$2335 VPWR \$2663 \$2731 \$2133 sg13cmos5l_o21ai_1
X$1067 VGND \$3923 VPWR \$4102 \$4026 \$2880 sg13cmos5l_o21ai_1
X$1068 VGND \$2337 VPWR \$2500 \$2254 \$2216 sg13cmos5l_o21ai_1
X$1069 VGND \$3891 VPWR \$4046 \$3039 \$4223 sg13cmos5l_o21ai_1
X$1070 VGND \$3025 VPWR \$2918 \$3085 \$3199 sg13cmos5l_o21ai_1
X$1071 VGND \$2142 VPWR \$2094 \$2214 \$2133 sg13cmos5l_o21ai_1
X$1072 VGND \$4357 VPWR \$4501 \$4085 \$4394 sg13cmos5l_o21ai_1
X$1073 VGND \$2326 VPWR \$2330 \$485 \$283 sg13cmos5l_o21ai_1
X$1074 VGND \$858 VPWR \$817 \$512 \$717 sg13cmos5l_o21ai_1
X$1075 VGND \$2386 VPWR \$2387 \$1595 \$927 sg13cmos5l_o21ai_1
X$1076 VGND \$1575 VPWR \$796 \$1412 \$1435 sg13cmos5l_o21ai_1
X$1077 VGND \$3895 VPWR \$4380 \$4061 \$2766 sg13cmos5l_o21ai_1
X$1078 VGND \$2416 VPWR \$2417 \$2418 \$1807 sg13cmos5l_o21ai_1
X$1079 VGND \$3536 VPWR \$2678 \$3359 \$2653 sg13cmos5l_o21ai_1
X$1080 VGND \$3779 VPWR \$3225 \$3838 \$2543 sg13cmos5l_o21ai_1
X$1081 VGND \$3825 VPWR \$3225 \$3768 \$2543 sg13cmos5l_o21ai_1
X$1082 VGND \$3855 VPWR \$2792 \$3783 \$3512 sg13cmos5l_o21ai_1
X$1083 VGND \$3181 VPWR \$3334 \$3291 \$3536 sg13cmos5l_o21ai_1
X$1084 VGND \$2334 VPWR \$2134 \$485 \$283 sg13cmos5l_o21ai_1
X$1085 VGND \$3270 VPWR \$2794 \$3255 \$3266 sg13cmos5l_o21ai_1
X$1086 VGND \$4499 VPWR \$4084 \$4009 \$4083 sg13cmos5l_o21ai_1
X$1087 VGND \$4208 VPWR \$4154 \$4212 \$3725 sg13cmos5l_o21ai_1
X$1088 VGND \$1695 VPWR \$555 \$927 \$1533 sg13cmos5l_o21ai_1
X$1089 VGND \$3418 VPWR \$3225 \$3184 \$2543 sg13cmos5l_o21ai_1
X$1090 VGND \$234 VPWR \$45 \$52 \$49 sg13cmos5l_o21ai_1
X$1091 VGND \$3452 VPWR \$3453 \$3249 \$3108 sg13cmos5l_o21ai_1
X$1092 VGND \$1018 VPWR \$644 \$927 \$521 sg13cmos5l_o21ai_1
X$1093 VGND \$3901 VPWR \$3225 \$3902 \$2543 sg13cmos5l_o21ai_1
X$1094 VGND \$1740 VPWR \$1599 \$1613 \$1965 sg13cmos5l_o21ai_1
X$1095 VGND \$3818 VPWR \$2678 \$3951 \$2653 sg13cmos5l_o21ai_1
X$1096 VGND \$1775 VPWR \$1632 \$1633 \$1630 sg13cmos5l_o21ai_1
X$1097 VGND \$4102 VPWR \$3347 \$3922 \$2543 sg13cmos5l_o21ai_1
X$1098 VGND \$3932 VPWR \$2792 \$3793 \$3514 sg13cmos5l_o21ai_1
X$1099 VGND \$2593 VPWR \$1961 \$2393 \$1856 sg13cmos5l_o21ai_1
X$1100 VGND \$857 VPWR \$940 \$941 \$87 sg13cmos5l_o21ai_1
X$1101 VGND \$848 VPWR \$828 \$934 \$687 sg13cmos5l_o21ai_1
X$1102 VGND \$968 VPWR \$730 \$967 \$485 sg13cmos5l_o21ai_1
X$1103 VGND \$1971 VPWR \$2194 \$2136 \$2133 sg13cmos5l_o21ai_1
X$1104 VGND \$299 VPWR \$169 \$298 \$279 sg13cmos5l_o21ai_1
X$1105 VGND \$1772 VPWR \$1913 \$2002 \$1807 sg13cmos5l_o21ai_1
X$1106 VGND \$3669 VPWR \$3716 \$3680 \$3760 sg13cmos5l_o21ai_1
X$1107 VGND \$3813 VPWR \$3756 \$3230 \$3818 sg13cmos5l_o21ai_1
X$1108 VGND \$4412 VPWR \$4407 \$4408 \$4511 sg13cmos5l_o21ai_1
X$1109 VGND \$3971 VPWR \$3035 \$3969 \$3586 sg13cmos5l_o21ai_1
X$1110 VGND \$863 VPWR \$987 \$861 \$615 sg13cmos5l_o21ai_1
X$1111 VGND \$2529 VPWR \$2531 \$2029 \$2233 sg13cmos5l_o21ai_1
X$1112 VGND \$4340 VPWR \$3364 \$3074 \$2839 sg13cmos5l_o21ai_1
X$1113 VGND \$300 VPWR \$344 \$298 \$279 sg13cmos5l_o21ai_1
X$1114 VGND \$1231 VPWR \$1181 \$838 \$1062 sg13cmos5l_o21ai_1
X$1115 VGND \$3700 VPWR \$2678 \$3086 \$3227 sg13cmos5l_o21ai_1
X$1116 VGND \$4089 VPWR \$2678 \$3910 \$2653 sg13cmos5l_o21ai_1
X$1117 VGND \$852 VPWR \$850 \$848 \$910 sg13cmos5l_o21ai_1
X$1118 VGND \$4032 VPWR \$4105 \$3741 \$4030 sg13cmos5l_o21ai_1
X$1119 VGND \$865 VPWR \$864 \$662 \$721 sg13cmos5l_o21ai_1
X$1120 VGND \$3951 VPWR \$3901 \$3900 \$2880 sg13cmos5l_o21ai_1
X$1121 VGND \$3359 VPWR \$3418 \$2880 \$3074 sg13cmos5l_o21ai_1
X$1122 VGND \$4191 VPWR \$4190 \$4089 \$3240 sg13cmos5l_o21ai_1
X$1123 VGND \$1408 VPWR \$1018 \$857 \$752 sg13cmos5l_o21ai_1
X$1124 VGND \$1136 VPWR \$87 \$941 \$742 sg13cmos5l_o21ai_1
X$1125 VGND \$3977 VPWR \$3861 \$3921 \$3729 sg13cmos5l_o21ai_1
X$2119 VPWR VGND \$3249 \$3504 \$3108 \$3385 sg13cmos5l_nor3_1
X$2120 VPWR VGND \$4009 \$4085 \$4084 \$4083 sg13cmos5l_nor3_1
X$2121 VPWR VGND \$1633 \$1636 \$1600 \$77 sg13cmos5l_nor3_1
X$2122 VPWR VGND \$2393 \$2536 \$1856 \$1961 sg13cmos5l_nor3_1
X$2123 VPWR VGND \$690 \$910 \$706 \$814 sg13cmos5l_nor3_1
X$2124 VPWR VGND \$742 \$1012 \$1011 \$178 sg13cmos5l_nor3_1
X$2125 VPWR VGND \$1336 \$1412 \$1021 \$1136 sg13cmos5l_nor3_1
X$2126 VPWR VGND \$1595 \$1965 \$927 \$283 sg13cmos5l_nor3_1
X$2127 VPWR VGND \$2208 \$2601 \$2133 \$2333 sg13cmos5l_nor3_1
X$2128 VPWR VGND \$1205 \$1187 \$1098 \$77 sg13cmos5l_nor3_1
X$2129 VPWR VGND \$662 \$426 \$614 \$26 sg13cmos5l_nor3_1
X$2130 VPWR VGND \$3074 \$4015 \$3364 \$2839 sg13cmos5l_nor3_1
X$2131 VPWR VGND \$306 \$100 \$360 \$26 sg13cmos5l_nor3_1
X$2132 VPWR VGND \$3650 \$4044 \$3935 \$2802 sg13cmos5l_nor3_1
X$2133 VPWR VGND \$52 \$218 \$137 \$26 sg13cmos5l_nor3_1
X$2134 VGND \$290 VPWR \$298 \$337 \$379 \$28 \$286 sg13cmos5l_a221oi_1
X$2135 VPWR VGND \$70 \$174 \$160 \$26 sg13cmos5l_nor3_1
X$2136 VPWR VGND \$941 \$1094 \$1090 \$87 sg13cmos5l_nor3_1
X$2137 VPWR VGND \$176 \$155 \$123 \$26 sg13cmos5l_nor3_1
X$2138 VPWR VGND \$373 \$708 \$592 \$233 sg13cmos5l_nor3_1
X$2139 VPWR VGND \$4501 \$4503 \$4085 \$4394 sg13cmos5l_nor3_1
X$2140 VPWR VGND \$307 \$443 \$369 \$178 sg13cmos5l_nor3_1
X$2141 VPWR VGND \$2393 \$2458 \$1853 \$2238 sg13cmos5l_nor3_1
X$2142 VPWR VGND \$2605 \$2491 \$1979 \$2254 sg13cmos5l_and3_1
X$2143 VPWR VGND \$2804 \$2730 \$2802 \$2680 sg13cmos5l_and3_1
X$2144 VPWR VGND \$555 \$373 \$930 \$630 sg13cmos5l_and3_1
X$2145 VPWR VGND \$555 \$1595 \$1166 \$1613 sg13cmos5l_and3_1
X$2146 VPWR VGND \$1050 \$662 \$644 \$1205 sg13cmos5l_and3_1
X$2147 VPWR VGND \$3266 \$3255 \$2794 \$2730 sg13cmos5l_and3_1
X$2148 VPWR VGND \$4316 \$4358 \$4357 \$4359 sg13cmos5l_and3_1
X$2149 VPWR VGND \$2216 \$2254 \$2345 \$2208 sg13cmos5l_and3_1
X$2150 VPWR VGND \$483 \$407 sg13cmos5l_inv_1
X$2151 VPWR VGND \$1856 \$1853 sg13cmos5l_inv_1
X$2152 VPWR VGND \$3039 \$3266 sg13cmos5l_inv_1
X$2153 VPWR VGND \$488 \$375 sg13cmos5l_inv_1
X$2154 VPWR VGND \$3319 \$3316 sg13cmos5l_inv_1
X$2155 VPWR VGND \$836 \$838 sg13cmos5l_inv_1
X$2156 VPWR VGND \$1487 \$1533 sg13cmos5l_inv_1
X$2157 VPWR VGND \$3142 \$3202 sg13cmos5l_inv_1
X$2158 VPWR VGND \$66 \$117 sg13cmos5l_inv_1
X$2159 VPWR VGND \$374 \$490 sg13cmos5l_inv_1
X$2160 VPWR VGND \$964 \$1607 sg13cmos5l_inv_1
X$2161 VPWR VGND \$959 \$1727 sg13cmos5l_inv_1
X$2162 VPWR VGND \$1745 \$1743 sg13cmos5l_inv_1
X$2163 VPWR VGND \$204 \$482 sg13cmos5l_inv_1
X$2164 VPWR VGND \$31 \$687 sg13cmos5l_inv_1
X$2165 VPWR VGND \$78 \$440 sg13cmos5l_inv_1
X$2166 VPWR VGND \$1810 \$2004 sg13cmos5l_inv_1
X$2167 VPWR VGND \$2091 \$2330 sg13cmos5l_inv_1
X$2168 VPWR VGND \$865 \$913 sg13cmos5l_inv_1
X$2169 VPWR VGND \$1859 \$1640 sg13cmos5l_inv_1
X$2170 VPWR VGND \$2030 \$2238 sg13cmos5l_inv_1
X$2171 VPWR VGND \$3364 \$3424 sg13cmos5l_inv_1
X$2172 VPWR VGND \$506 \$434 sg13cmos5l_inv_1
X$2173 VPWR VGND \$98 \$412 sg13cmos5l_inv_1
X$2174 VPWR VGND \$2143 \$2414 sg13cmos5l_inv_1
X$2175 VPWR VGND \$2454 \$2537 sg13cmos5l_inv_1
X$2176 VPWR VGND \$234 \$172 sg13cmos5l_inv_1
X$2177 VPWR VGND \$2839 \$2772 sg13cmos5l_inv_1
X$2178 VPWR VGND \$46 \$144 sg13cmos5l_inv_1
X$2179 VPWR VGND \$2804 \$2612 sg13cmos5l_inv_1
X$2180 VPWR VGND \$3586 \$3581 sg13cmos5l_inv_1
X$2181 VPWR VGND \$2103 \$1866 sg13cmos5l_inv_1
X$2182 VPWR VGND \$235 \$510 sg13cmos5l_inv_1
X$2183 VPWR VGND \$1164 \$1842 sg13cmos5l_inv_1
X$2256 \$2760 VPWR VGND sg13cmos5l_tiehi
X$2257 \$1944 VPWR VGND sg13cmos5l_tiehi
X$2258 \$4229 VPWR VGND sg13cmos5l_tiehi
X$2259 \$2110 VPWR VGND sg13cmos5l_tiehi
X$2260 \$2759 VPWR VGND sg13cmos5l_tiehi
X$2261 \$2291 VPWR VGND sg13cmos5l_tiehi
X$2262 \$1877 VPWR VGND sg13cmos5l_tiehi
X$2263 \$4124 VPWR VGND sg13cmos5l_tiehi
X$2264 \$1791 VPWR VGND sg13cmos5l_tiehi
X$2265 \$3355 VPWR VGND sg13cmos5l_tiehi
X$2266 \$2225 VPWR VGND sg13cmos5l_tiehi
X$2267 \$2022 VPWR VGND sg13cmos5l_tiehi
X$2268 \$2012 VPWR VGND sg13cmos5l_tiehi
X$2269 \$3470 VPWR VGND sg13cmos5l_tiehi
X$2270 \$3406 VPWR VGND sg13cmos5l_tiehi
X$2271 \$2014 VPWR VGND sg13cmos5l_tiehi
X$2397 VPWR VGND sg13cmos5l_decap_8
X$2398 VPWR VGND sg13cmos5l_decap_8
X$2399 VPWR VGND sg13cmos5l_decap_8
X$2400 VPWR VGND sg13cmos5l_decap_8
X$2401 VPWR VGND sg13cmos5l_decap_8
X$2402 VPWR VGND sg13cmos5l_decap_8
X$2403 VPWR VGND sg13cmos5l_decap_8
X$2404 VPWR VGND sg13cmos5l_decap_8
X$2405 VPWR VGND sg13cmos5l_decap_8
X$2406 VPWR VGND sg13cmos5l_decap_8
X$2407 VPWR VGND sg13cmos5l_decap_8
X$2408 VPWR VGND sg13cmos5l_decap_8
X$2409 VPWR VGND sg13cmos5l_decap_8
X$2410 VPWR VGND sg13cmos5l_decap_8
X$2411 VPWR VGND sg13cmos5l_decap_8
X$2412 VPWR VGND sg13cmos5l_decap_8
X$2413 VPWR VGND sg13cmos5l_decap_8
X$2414 VPWR VGND sg13cmos5l_decap_8
X$2415 VPWR VGND sg13cmos5l_decap_8
X$2416 VPWR VGND sg13cmos5l_decap_8
X$2417 VPWR VGND sg13cmos5l_decap_8
X$2418 VPWR VGND sg13cmos5l_decap_8
X$2419 VPWR VGND sg13cmos5l_decap_8
X$2420 VPWR VGND sg13cmos5l_decap_8
X$2421 VPWR VGND sg13cmos5l_decap_8
X$2422 VPWR VGND sg13cmos5l_decap_8
X$2423 VPWR VGND sg13cmos5l_decap_8
X$2424 VPWR VGND sg13cmos5l_decap_8
X$2425 VPWR VGND sg13cmos5l_decap_8
X$2426 VPWR VGND sg13cmos5l_decap_8
X$2427 VPWR VGND sg13cmos5l_decap_8
X$2428 VPWR VGND sg13cmos5l_decap_8
X$2429 VPWR VGND sg13cmos5l_decap_8
X$2430 VPWR VGND sg13cmos5l_decap_8
X$2431 VPWR VGND sg13cmos5l_decap_8
X$2432 VPWR VGND sg13cmos5l_decap_8
X$2433 VPWR VGND sg13cmos5l_decap_8
X$2434 VPWR VGND sg13cmos5l_decap_8
X$2435 VPWR VGND sg13cmos5l_decap_8
X$2436 VPWR VGND sg13cmos5l_decap_8
X$2437 VPWR VGND sg13cmos5l_decap_8
X$2438 VPWR VGND sg13cmos5l_decap_8
X$2439 VPWR VGND sg13cmos5l_decap_8
X$2440 VPWR VGND sg13cmos5l_decap_8
X$2441 VPWR VGND sg13cmos5l_decap_8
X$2442 VPWR VGND sg13cmos5l_decap_8
X$2443 VPWR VGND sg13cmos5l_decap_8
X$2444 VPWR VGND sg13cmos5l_decap_8
X$2445 VPWR VGND sg13cmos5l_decap_8
X$2446 VPWR VGND sg13cmos5l_decap_8
X$2447 VPWR VGND sg13cmos5l_decap_8
X$2448 VPWR VGND sg13cmos5l_decap_8
X$2449 VPWR VGND sg13cmos5l_decap_8
X$2450 VPWR VGND sg13cmos5l_decap_8
X$2451 VPWR VGND sg13cmos5l_decap_8
X$2452 VPWR VGND sg13cmos5l_decap_8
X$2453 VPWR VGND sg13cmos5l_decap_8
X$2454 VPWR VGND sg13cmos5l_decap_8
X$2455 VPWR VGND sg13cmos5l_decap_8
X$2456 VPWR VGND sg13cmos5l_decap_8
X$2457 VPWR VGND sg13cmos5l_decap_8
X$2458 VPWR VGND sg13cmos5l_decap_8
X$2459 VPWR VGND sg13cmos5l_decap_8
X$2460 VPWR VGND sg13cmos5l_decap_8
X$2461 VPWR VGND sg13cmos5l_decap_8
X$2462 VPWR VGND \$786 \$857 \$817 sg13cmos5l_nor2_1
X$2463 VPWR VGND \$3089 \$2794 \$3087 sg13cmos5l_nor2_1
X$2464 VPWR VGND \$485 \$283 \$1090 sg13cmos5l_nor2_1
X$2465 VPWR VGND \$26 \$46 \$27 sg13cmos5l_nor2_1
X$2466 VPWR VGND \$521 \$592 \$286 sg13cmos5l_nor2_1
X$2467 VPWR VGND \$2401 \$2208 \$2214 sg13cmos5l_nor2_1
X$2468 VPWR VGND \$37 \$36 \$34 sg13cmos5l_nor2_1
X$2469 VPWR VGND \$3378 \$3948 \$4083 sg13cmos5l_nor2_1
X$2470 VPWR VGND \$3085 \$3199 \$3090 sg13cmos5l_nor2_1
X$2471 VPWR VGND \$75 \$362 \$240 sg13cmos5l_nor2_1
X$2472 VPWR VGND \$4044 \$2265 \$3742 sg13cmos5l_nor2_1
X$2473 VPWR VGND \$2913 \$2814 \$2783 sg13cmos5l_nor2_1
X$2474 VPWR VGND \$1020 \$996 \$963 sg13cmos5l_nor2_1
X$2475 VPWR VGND \$307 \$369 \$75 sg13cmos5l_nor2_1
X$2476 VPWR VGND \$2320 \$2458 \$2385 sg13cmos5l_nor2_1
X$2477 VPWR VGND \$4504 \$4359 \$4360 sg13cmos5l_nor2_1
X$2478 VPWR VGND \$2990 \$3581 \$3445 sg13cmos5l_nor2_1
X$2479 VPWR VGND \$742 \$1018 \$1021 sg13cmos5l_nor2_1
X$2480 VPWR VGND \$2245 \$2772 \$3127 sg13cmos5l_nor2_1
X$2481 VPWR VGND \$3870 \$3347 \$3650 sg13cmos5l_nor2_1
X$2482 VPWR VGND \$540 \$178 \$541 sg13cmos5l_nor2_1
X$2483 VPWR VGND \$238 \$30 \$275 sg13cmos5l_nor2_1
X$2484 VPWR VGND \$2678 \$3266 \$3655 sg13cmos5l_nor2_1
X$2485 VPWR VGND \$3388 \$2554 \$3261 sg13cmos5l_nor2_1
X$2486 VPWR VGND \$863 \$858 \$906 sg13cmos5l_nor2_1
X$2487 VPWR VGND \$1090 \$177 \$1141 sg13cmos5l_nor2_1
X$2488 VPWR VGND \$306 \$343 \$614 sg13cmos5l_nor2_1
X$2489 VPWR VGND \$307 \$177 \$992 sg13cmos5l_nor2_1
X$2490 VPWR VGND \$927 \$521 \$756 sg13cmos5l_nor2_1
X$2491 VPWR VGND \$1638 \$1635 \$1599 sg13cmos5l_nor2_1
X$2492 VPWR VGND \$2790 \$2254 \$2788 sg13cmos5l_nor2_1
X$2493 VPWR VGND \$708 \$756 \$635 sg13cmos5l_nor2_1
X$2494 VPWR VGND \$2087 \$2208 \$2136 sg13cmos5l_nor2_1
X$2495 VPWR VGND \$1205 \$1559 \$1507 sg13cmos5l_nor2_1
X$2496 VPWR VGND \$124 \$435 \$360 sg13cmos5l_nor2_1
X$2497 VPWR VGND \$3936 \$2554 \$4006 sg13cmos5l_nor2_1
X$2498 VPWR VGND \$36 \$85 \$97 sg13cmos5l_nor2_1
X$2499 VPWR VGND \$3453 \$4365 \$4408 sg13cmos5l_nor2_1
X$2500 VPWR VGND \$563 \$805 \$730 sg13cmos5l_nor2_1
X$2501 VPWR VGND \$3781 \$3035 \$3783 sg13cmos5l_nor2_1
X$2502 VPWR VGND \$46 \$66 \$137 sg13cmos5l_nor2_1
X$2503 VPWR VGND \$3773 \$3581 \$3781 sg13cmos5l_nor2_1
X$2504 VPWR VGND \$3354 \$2794 \$3048 sg13cmos5l_nor2_1
X$2505 VPWR VGND \$144 \$117 \$52 sg13cmos5l_nor2_1
X$2506 VPWR VGND \$1599 \$996 \$1675 sg13cmos5l_nor2_1
X$2507 VPWR VGND \$854 \$33 \$840 sg13cmos5l_nor2_1
X$2508 VPWR VGND \$612 \$506 \$717 sg13cmos5l_nor2_1
X$2509 VPWR VGND \$2788 \$2208 \$2731 sg13cmos5l_nor2_1
X$2510 VPWR VGND \$694 \$49 \$690 sg13cmos5l_nor2_1
X$2511 VPWR VGND \$542 \$541 \$608 sg13cmos5l_nor2_1
X$2512 VPWR VGND \$714 \$431 \$612 sg13cmos5l_nor2_1
X$2513 VPWR VGND \$70 \$67 \$55 sg13cmos5l_nor2_1
X$2514 VPWR VGND \$3798 \$3453 \$3869 sg13cmos5l_nor2_1
X$2515 VPWR VGND \$515 \$431 \$924 sg13cmos5l_nor2_1
X$2516 VPWR VGND \$286 \$49 \$279 sg13cmos5l_nor2_1
X$2517 VPWR VGND \$275 \$76 \$237 sg13cmos5l_nor2_1
X$2518 \$2504 VGND \$1993 VPWR \$2261 \$2415 sg13cmos5l_a21oi_1
X$2519 \$864 VGND \$662 VPWR \$721 \$77 sg13cmos5l_a21oi_1
X$2520 \$850 VGND \$934 VPWR \$687 \$1012 sg13cmos5l_a21oi_1
X$2521 \$2415 VGND \$1711 VPWR \$1763 \$2414 sg13cmos5l_a21oi_1
X$2522 \$808 VGND \$849 VPWR \$1028 \$1307 sg13cmos5l_a21oi_1
X$2523 \$3204 VGND \$3028 VPWR \$2984 \$3445 sg13cmos5l_a21oi_1
X$2524 \$2766 VGND \$2638 VPWR \$2529 \$2649 sg13cmos5l_a21oi_1
X$2525 \$1051 VGND \$662 VPWR \$644 \$1050 sg13cmos5l_a21oi_1
X$2526 \$3184 VGND \$2902 VPWR \$2245 \$3127 sg13cmos5l_a21oi_1
X$2527 \$3249 VGND \$3201 VPWR \$3330 \$3142 sg13cmos5l_a21oi_1
X$2528 \$2476 VGND \$2393 VPWR \$1853 \$2130 sg13cmos5l_a21oi_1
X$2529 \$3623 VGND \$2823 VPWR \$3549 \$3424 sg13cmos5l_a21oi_1
X$2530 \$563 VGND \$447 VPWR \$319 \$521 sg13cmos5l_a21oi_1
X$2531 \$752 VGND \$685 VPWR \$608 \$717 sg13cmos5l_a21oi_1
X$2532 \$107 VGND \$52 VPWR \$49 \$78 sg13cmos5l_a21oi_1
X$2533 \$4511 VGND \$3035 VPWR \$4356 \$4504 sg13cmos5l_a21oi_1
X$2534 \$2780 VGND \$2913 VPWR \$2839 \$2476 sg13cmos5l_a21oi_1
X$2535 \$3354 VGND \$3514 VPWR \$3388 \$2612 sg13cmos5l_a21oi_1
X$2536 \$2510 VGND \$2382 VPWR \$2002 \$1635 sg13cmos5l_a21oi_1
X$2537 \$1336 VGND \$755 VPWR \$1179 \$644 sg13cmos5l_a21oi_1
X$2538 \$2615 VGND \$2254 VPWR \$2099 \$2345 sg13cmos5l_a21oi_1
X$2539 \$1632 VGND \$1633 VPWR \$1630 \$77 sg13cmos5l_a21oi_1
X$2540 \$4504 VGND \$4357 VPWR \$4316 \$4358 sg13cmos5l_a21oi_1
X$2541 \$615 VGND \$348 VPWR \$456 \$434 sg13cmos5l_a21oi_1
X$2542 \$706 VGND \$235 VPWR \$755 \$78 sg13cmos5l_a21oi_1
X$2543 \$2320 VGND \$742 VPWR \$1856 \$2030 sg13cmos5l_a21oi_1
X$2544 \$3935 VGND \$3749 VPWR \$2792 \$2794 sg13cmos5l_a21oi_1
X$2545 \$2631 VGND \$2532 VPWR \$2418 \$2265 sg13cmos5l_a21oi_1
X$2546 \$1674 VGND \$1625 VPWR \$1599 \$1675 sg13cmos5l_a21oi_1
X$2547 \$940 VGND \$941 VPWR \$87 \$1097 sg13cmos5l_a21oi_1
X$2548 \$379 VGND \$289 VPWR \$144 \$117 sg13cmos5l_a21oi_1
X$2549 \$1062 VGND \$852 VPWR \$938 \$840 sg13cmos5l_a21oi_1
X$2550 \$3253 VGND \$3255 VPWR \$3261 \$3347 sg13cmos5l_a21oi_1
X$2551 \$2556 VGND \$1711 VPWR \$1763 \$2997 sg13cmos5l_a21oi_1
X$2552 \$2790 VGND \$2491 VPWR \$1979 \$2605 sg13cmos5l_a21oi_1
X$2553 \$3085 VGND \$3017 VPWR \$3084 \$3083 sg13cmos5l_a21oi_1
X$2554 \$3793 VGND \$3512 VPWR \$3385 \$3794 sg13cmos5l_a21oi_1
X$2555 \$1638 VGND \$906 VPWR \$1141 \$1595 sg13cmos5l_a21oi_1
X$2556 \$3870 VGND \$4038 VPWR \$3039 \$4042 sg13cmos5l_a21oi_1
X$2557 \$994 VGND \$963 VPWR \$584 \$708 sg13cmos5l_a21oi_1
X$2558 \$2917 VGND \$3083 VPWR \$3314 \$3316 sg13cmos5l_a21oi_1
X$2559 \$2237 VGND \$2385 VPWR \$2382 \$2265 sg13cmos5l_a21oi_1
X$2560 \$714 VGND \$523 VPWR \$521 \$630 sg13cmos5l_a21oi_1
X$2561 \$4186 VGND \$4008 VPWR \$3895 \$3824 sg13cmos5l_a21oi_1
X$2562 \$2405 VGND \$2741 VPWR \$2133 \$2666 sg13cmos5l_a21oi_1
X$4023 VGND \$167 \$28 \$172 \$81 VPWR sg13cmos5l_dfrbpq_1
X$4024 VGND \$1552 \$1298 \$1640 \$1491 VPWR sg13cmos5l_dfrbpq_1
X$4025 VGND \$1543 \$1961 \$2033 \$1643 VPWR sg13cmos5l_dfrbpq_1
X$4026 VGND \$167 \$103 \$270 \$81 VPWR sg13cmos5l_dfrbpq_1
X$4027 VGND \$1552 \$1164 \$1842 \$1487 VPWR sg13cmos5l_dfrbpq_1
X$4028 VGND \$68 \$374 \$490 \$98 VPWR sg13cmos5l_dfrbpq_1
X$4029 VGND \$68 \$625 \$968 \$81 VPWR sg13cmos5l_dfrbpq_1
X$4030 VGND \$4059 \$4152 \$4355 \$3959 VPWR sg13cmos5l_dfrbpq_1
X$4031 VGND \$4059 \$4189 \$4351 \$3959 VPWR sg13cmos5l_dfrbpq_1
X$4032 VGND \$3726 \$3475 \$3813 \$2376 VPWR sg13cmos5l_dfrbpq_1
X$4033 VGND \$72 \$33 \$141 \$83 VPWR sg13cmos5l_dfrbpq_1
X$4034 VGND \$1752 \$1504 \$2004 \$1204 VPWR sg13cmos5l_dfrbpq_1
X$4035 VGND \$4242 \$3106 \$4208 \$3864 VPWR sg13cmos5l_dfrbpq_1
X$4036 VGND \$1552 \$1487 \$1533 \$734 VPWR sg13cmos5l_dfrbpq_1
X$4037 VGND \$4242 \$3730 \$3977 \$2190 VPWR sg13cmos5l_dfrbpq_1
X$4038 VGND \$1703 \$1499 \$1805 \$1204 VPWR sg13cmos5l_dfrbpq_1
X$4039 VGND \$4242 \$3794 \$4032 \$3864 VPWR sg13cmos5l_dfrbpq_1
X$4040 VGND \$1703 \$1352 \$1674 \$1643 VPWR sg13cmos5l_dfrbpq_1
X$4041 VGND \$1752 \$1807 \$2218 \$1204 VPWR sg13cmos5l_dfrbpq_1
X$4042 VGND \$1752 \$1979 \$1802 \$1643 VPWR sg13cmos5l_dfrbpq_1
X$4043 VGND \$1543 \$2134 \$1972 \$1643 VPWR sg13cmos5l_dfrbpq_1
X$4044 VGND \$1543 \$2122 \$1957 \$1643 VPWR sg13cmos5l_dfrbpq_1
X$4045 VGND \$1752 \$2553 \$2138 \$2190 VPWR sg13cmos5l_dfrbpq_1
X$4046 VGND \$167 \$417 \$494 \$81 VPWR sg13cmos5l_dfrbpq_1
X$4047 VGND \$2750 \$2881 \$2617 \$2190 VPWR sg13cmos5l_dfrbpq_1
X$4048 VGND \$2550 \$3044 \$2726 \$2190 VPWR sg13cmos5l_dfrbpq_1
X$4049 VGND \$4242 \$4365 \$4211 \$3864 VPWR sg13cmos5l_dfrbpq_1
X$4050 VGND \$1752 \$2143 \$2102 \$2190 VPWR sg13cmos5l_dfrbpq_1
X$4051 VGND \$72 \$105 \$34 \$83 VPWR sg13cmos5l_dfrbpq_1
X$4052 VGND \$4059 \$4334 \$4129 \$3959 VPWR sg13cmos5l_dfrbpq_1
X$4053 VGND \$1752 \$2099 \$1984 \$1204 VPWR sg13cmos5l_dfrbpq_1
X$4054 VGND \$4242 \$4295 \$4214 \$3864 VPWR sg13cmos5l_dfrbpq_1
X$4055 VGND \$1703 \$1307 \$1713 \$1204 VPWR sg13cmos5l_dfrbpq_1
X$4056 VGND \$2550 \$2149 \$2565 \$2190 VPWR sg13cmos5l_dfrbpq_1
X$4057 VGND \$261 \$1028 \$1363 \$1204 VPWR sg13cmos5l_dfrbpq_1
X$4058 VGND \$261 \$644 \$913 \$83 VPWR sg13cmos5l_dfrbpq_1
X$4059 VGND \$2550 \$2091 \$2546 \$2376 VPWR sg13cmos5l_dfrbpq_1
X$4060 VGND \$1543 \$1342 \$1743 \$554 VPWR sg13cmos5l_dfrbpq_1
X$4061 VGND \$72 \$87 \$426 \$83 VPWR sg13cmos5l_dfrbpq_1
X$4062 VGND \$1543 \$1331 \$2131 \$1643 VPWR sg13cmos5l_dfrbpq_1
X$4063 VGND \$1543 \$959 \$1727 \$1164 VPWR sg13cmos5l_dfrbpq_1
X$4064 VGND \$72 \$31 \$155 \$83 VPWR sg13cmos5l_dfrbpq_1
X$4065 VGND \$68 \$22 \$218 \$81 VPWR sg13cmos5l_dfrbpq_1
X$4066 VGND \$3726 \$3388 \$3892 \$2190 VPWR sg13cmos5l_dfrbpq_1
X$4067 VGND \$1552 \$772 \$1615 \$81 VPWR sg13cmos5l_dfrbpq_1
X$4068 VGND \$68 \$96 \$95 \$483 VPWR sg13cmos5l_dfrbpq_1
X$4069 VGND \$1543 \$964 \$1607 \$959 VPWR sg13cmos5l_dfrbpq_1
X$4070 VGND \$2550 \$2178 \$2526 \$2376 VPWR sg13cmos5l_dfrbpq_1
X$4071 VGND \$4242 \$4201 \$4360 \$3864 VPWR sg13cmos5l_dfrbpq_1
X$4072 VGND \$4059 \$2985 \$3774 \$3959 VPWR sg13cmos5l_dfrbpq_1
X$4073 VGND \$68 \$488 \$375 \$374 VPWR sg13cmos5l_dfrbpq_1
X$4074 VGND \$4059 \$3496 \$4191 \$3959 VPWR sg13cmos5l_dfrbpq_1
X$4075 VGND \$2550 \$3031 \$3669 \$2376 VPWR sg13cmos5l_dfrbpq_1
X$4076 VGND \$72 \$30 \$174 \$83 VPWR sg13cmos5l_dfrbpq_1
X$4077 VGND \$167 \$98 \$412 \$204 VPWR sg13cmos5l_dfrbpq_1
X$4078 VGND \$2550 \$2814 \$3181 \$2376 VPWR sg13cmos5l_dfrbpq_1
X$4079 VGND \$4242 \$4160 \$4320 \$3864 VPWR sg13cmos5l_dfrbpq_1
X$4080 VGND \$4242 \$4049 \$4220 \$3864 VPWR sg13cmos5l_dfrbpq_1
X$4081 VGND \$4059 \$3617 \$4007 \$2376 VPWR sg13cmos5l_dfrbpq_1
X$4082 VGND \$1752 \$1416 \$1866 \$462 VPWR sg13cmos5l_dfrbpq_1
X$4083 VGND \$4059 \$4343 \$4142 \$3959 VPWR sg13cmos5l_dfrbpq_1
X$4084 VGND \$1543 \$2078 \$1959 \$1643 VPWR sg13cmos5l_dfrbpq_1
X$4085 VGND \$1752 \$1907 \$1809 \$1204 VPWR sg13cmos5l_dfrbpq_1
X$4086 VGND \$72 \$431 \$100 \$83 VPWR sg13cmos5l_dfrbpq_1
X$4087 VGND \$68 \$483 \$407 \$964 VPWR sg13cmos5l_dfrbpq_1
X$4088 VGND \$2550 \$2818 \$2764 \$2376 VPWR sg13cmos5l_dfrbpq_1
X$4089 VGND \$4059 \$4313 \$4135 \$3959 VPWR sg13cmos5l_dfrbpq_1
X$4090 VGND \$68 \$204 \$482 \$96 VPWR sg13cmos5l_dfrbpq_1
X$4091 VPWR VGND \$1802 \$2142 sg13cmos5l_dlygate4sd3_1
X$4092 VPWR VGND \$1063 \$1499 sg13cmos5l_dlygate4sd3_1
X$4093 VPWR VGND \$2345 \$2881 sg13cmos5l_dlygate4sd3_1
X$4094 VPWR VGND \$926 \$1352 sg13cmos5l_dlygate4sd3_1
X$4095 VPWR VGND \$2102 \$2416 sg13cmos5l_dlygate4sd3_1
X$4096 VPWR VGND \$1984 \$2253 sg13cmos5l_dlygate4sd3_1
X$4097 VPWR VGND \$2726 \$2939 sg13cmos5l_dlygate4sd3_1
X$4098 VPWR VGND \$1957 \$2183 sg13cmos5l_dlygate4sd3_1
X$4099 VPWR VGND \$2138 \$2335 sg13cmos5l_dlygate4sd3_1
X$4100 VPWR VGND \$46 \$118 sg13cmos5l_dlygate4sd3_1
X$4101 VPWR VGND \$2038 \$2134 sg13cmos5l_dlygate4sd3_1
X$4102 VPWR VGND \$1972 \$1971 sg13cmos5l_dlygate4sd3_1
X$4103 VPWR VGND \$494 \$625 sg13cmos5l_dlygate4sd3_1
X$4104 VPWR VGND \$4211 \$4367 sg13cmos5l_dlygate4sd3_1
X$4105 VPWR VGND \$1098 \$1051 sg13cmos5l_dlygate4sd3_1
X$4106 VPWR VGND \$4510 \$4511 sg13cmos5l_dlygate4sd3_1
X$4107 VPWR VGND \$4352 \$4189 sg13cmos5l_dlygate4sd3_1
X$4108 VPWR VGND \$4354 \$4152 sg13cmos5l_dlygate4sd3_1
X$4109 VPWR VGND \$2454 \$2178 sg13cmos5l_dlygate4sd3_1
X$4110 VPWR VGND \$2349 \$1807 sg13cmos5l_dlygate4sd3_1
X$4111 VPWR VGND \$1363 \$1187 sg13cmos5l_dlygate4sd3_1
X$4112 VPWR VGND \$2358 \$2149 sg13cmos5l_dlygate4sd3_1
X$4113 VPWR VGND \$1635 \$1807 sg13cmos5l_dlygate4sd3_1
X$4114 VPWR VGND \$4214 \$4213 sg13cmos5l_dlygate4sd3_1
X$4115 VPWR VGND \$1959 \$1963 sg13cmos5l_dlygate4sd3_1
X$4116 VPWR VGND \$3476 \$3475 sg13cmos5l_dlygate4sd3_1
X$4117 VPWR VGND \$2030 \$1961 sg13cmos5l_dlygate4sd3_1
X$4118 VPWR VGND \$2617 \$2405 sg13cmos5l_dlygate4sd3_1
X$4119 VPWR VGND \$2181 \$2078 sg13cmos5l_dlygate4sd3_1
X$4120 VPWR VGND \$343 \$87 sg13cmos5l_dlygate4sd3_1
X$4121 VPWR VGND \$3125 \$2814 sg13cmos5l_dlygate4sd3_1
X$4122 VPWR VGND \$2104 \$1907 sg13cmos5l_dlygate4sd3_1
X$4123 VPWR VGND \$4153 \$3106 sg13cmos5l_dlygate4sd3_1
X$4124 VPWR VGND \$4078 \$2985 sg13cmos5l_dlygate4sd3_1
X$4125 VPWR VGND \$4373 \$4308 sg13cmos5l_dlygate4sd3_1
X$4126 VPWR VGND \$1809 \$1772 sg13cmos5l_dlygate4sd3_1
X$4127 VPWR VGND \$1713 \$1636 sg13cmos5l_dlygate4sd3_1
X$4128 VPWR VGND \$2605 \$2553 sg13cmos5l_dlygate4sd3_1
X$4129 VPWR VGND \$2216 \$2099 sg13cmos5l_dlygate4sd3_1
X$4130 VPWR VGND \$4235 \$4265 sg13cmos5l_dlygate4sd3_1
X$4131 VPWR VGND \$85 \$33 sg13cmos5l_dlygate4sd3_1
X$4132 VPWR VGND \$4142 \$4269 sg13cmos5l_dlygate4sd3_1
X$4133 VPWR VGND \$270 \$417 sg13cmos5l_dlygate4sd3_1
X$4134 VPWR VGND \$29 \$28 sg13cmos5l_dlygate4sd3_1
X$4135 VPWR VGND \$2033 \$2185 sg13cmos5l_dlygate4sd3_1
X$4136 VPWR VGND \$1255 \$1331 sg13cmos5l_dlygate4sd3_1
X$4137 VPWR VGND \$3936 \$4049 sg13cmos5l_dlygate4sd3_1
X$4138 VPWR VGND \$3685 \$4313 sg13cmos5l_dlygate4sd3_1
X$4139 VPWR VGND \$2182 \$2029 sg13cmos5l_dlygate4sd3_1
X$4140 VPWR VGND \$2633 \$2818 sg13cmos5l_dlygate4sd3_1
X$4141 VPWR VGND \$3506 \$3794 sg13cmos5l_dlygate4sd3_1
X$4142 VPWR VGND \$318 \$772 sg13cmos5l_dlygate4sd3_1
X$4143 VPWR VGND \$3948 \$4343 sg13cmos5l_dlygate4sd3_1
X$4144 VPWR VGND \$102 \$97 sg13cmos5l_dlygate4sd3_1
X$4145 VPWR VGND \$1050 \$1028 sg13cmos5l_dlygate4sd3_1
X$4146 VPWR VGND \$160 \$107 sg13cmos5l_dlygate4sd3_1
X$4147 VPWR VGND \$4356 \$4201 sg13cmos5l_dlygate4sd3_1
X$4148 VPWR VGND \$2804 \$3044 sg13cmos5l_dlygate4sd3_1
X$4149 VPWR VGND \$67 \$31 sg13cmos5l_dlygate4sd3_1
X$4150 VPWR VGND \$215 \$103 sg13cmos5l_dlygate4sd3_1
X$4151 VPWR VGND \$4223 \$4160 sg13cmos5l_dlygate4sd3_1
X$4152 VPWR VGND \$4129 \$3887 sg13cmos5l_dlygate4sd3_1
X$4153 VPWR VGND \$2080 \$2122 sg13cmos5l_dlygate4sd3_1
X$4154 VPWR VGND \$3945 \$3617 sg13cmos5l_dlygate4sd3_1
X$4155 VPWR VGND \$3413 \$3031 sg13cmos5l_dlygate4sd3_1
X$4156 VPWR VGND \$1600 \$1507 sg13cmos5l_dlygate4sd3_1
X$4157 VPWR VGND \$2666 \$2615 sg13cmos5l_dlygate4sd3_1
X$4158 VPWR VGND \$435 \$431 sg13cmos5l_dlygate4sd3_1
X$4159 VPWR VGND \$2361 \$2143 sg13cmos5l_dlygate4sd3_1
X$4160 VPWR VGND \$1630 \$1504 sg13cmos5l_dlygate4sd3_1
X$4161 VPWR VGND \$1810 \$1775 sg13cmos5l_dlygate4sd3_1
X$4162 VPWR VGND \$4007 \$3894 sg13cmos5l_dlygate4sd3_1
X$4163 VPWR VGND \$1559 \$1307 sg13cmos5l_dlygate4sd3_1
X$4164 VPWR VGND \$4368 \$4295 sg13cmos5l_dlygate4sd3_1
X$4165 VPWR VGND \$721 \$644 sg13cmos5l_dlygate4sd3_1
X$4166 VPWR VGND \$2333 \$2091 sg13cmos5l_dlygate4sd3_1
X$4167 VPWR VGND \$4197 \$3496 sg13cmos5l_dlygate4sd3_1
X$4168 VPWR VGND \$123 \$55 sg13cmos5l_dlygate4sd3_1
X$4169 VPWR VGND \$152 \$105 sg13cmos5l_dlygate4sd3_1
X$4170 VPWR VGND \$50 \$30 sg13cmos5l_dlygate4sd3_1
X$4171 VPWR VGND \$4320 \$4303 sg13cmos5l_dlygate4sd3_1
X$4172 VPWR VGND \$1898 \$1979 sg13cmos5l_dlygate4sd3_1
X$4280 VPWR VGND \$176 \$67 \$70 sg13cmos5l_and2_1
X$5587 VGND \$1856 VPWR \$2358 sg13cmos5l_buf_1
X$5588 VGND \$4059 VPWR \$3726 sg13cmos5l_buf_1
X$5589 VGND \$3251 VPWR \$2265 sg13cmos5l_buf_1
X$5590 VGND \$283 VPWR \$1255 sg13cmos5l_buf_1
X$5591 VGND \$3317 VPWR \$3476 sg13cmos5l_buf_1
X$5592 VGND \$2678 VPWR \$2510 sg13cmos5l_buf_1
X$5593 VGND \$4242 VPWR \$3726 sg13cmos5l_buf_1
X$5594 VGND \$1543 VPWR \$1703 sg13cmos5l_buf_1
X$5595 VGND \$3039 VPWR \$3388 sg13cmos5l_buf_1
X$5596 VGND \$3453 VPWR \$3730 sg13cmos5l_buf_1
X$5597 VGND \$3385 VPWR \$3453 sg13cmos5l_buf_1
X$5598 VGND \$1752 VPWR \$1703 sg13cmos5l_buf_1
X$5599 VGND \$755 VPWR \$2321 sg13cmos5l_buf_1
X$5600 VGND \$3586 VPWR \$4197 sg13cmos5l_buf_1
X$5601 VGND \$I18151 VPWR \$1491 sg13cmos5l_buf_1
X$5602 VGND \$49 VPWR \$29 sg13cmos5l_buf_1
X$5603 VGND \$996 VPWR \$926 sg13cmos5l_buf_1
X$5604 VGND \$1703 VPWR \$261 sg13cmos5l_buf_1
X$5605 VGND \$3347 VPWR \$2382 sg13cmos5l_buf_1
X$5606 VGND \$68 VPWR \$72 sg13cmos5l_buf_1
X$5607 VGND \$2653 VPWR \$2504 sg13cmos5l_buf_1
X$5608 VGND \$592 VPWR \$996 sg13cmos5l_buf_1
X$5609 VGND \$2975 VPWR \$3253 sg13cmos5l_buf_1
X$5610 VGND \$1082 VPWR \$318 sg13cmos5l_buf_1
X$5611 VGND \$3726 VPWR \$2550 sg13cmos5l_buf_1
X$5612 VGND \$167 VPWR \$72 sg13cmos5l_buf_1
X$5613 VGND \$2839 VPWR \$2814 sg13cmos5l_buf_1
X$5614 VGND \$1020 VPWR \$1063 sg13cmos5l_buf_1
X$5615 VGND \$78 VPWR \$50 sg13cmos5l_buf_1
X$5616 VGND \$3389 VPWR \$3506 sg13cmos5l_buf_1
X$5617 VGND \$233 VPWR \$283 sg13cmos5l_buf_1
X$5618 VGND \$408 VPWR \$41 sg13cmos5l_buf_1
X$5619 VGND \$1552 VPWR \$1703 sg13cmos5l_buf_1
X$5620 VGND \$72 VPWR \$261 sg13cmos5l_buf_1
X$5621 VPWR VGND \$169 \$78 \$238 sg13cmos5l_nand2_1
X$5622 VGND \$I18131 VPWR \$554 sg13cmos5l_buf_1
X$5623 VGND \$4311 VPWR \$4334 sg13cmos5l_buf_1
X$5624 VGND \$930 VPWR \$1020 sg13cmos5l_buf_1
X$5625 VGND \$I18128 VPWR \$734 sg13cmos5l_buf_1
X$5626 VGND \$41 VPWR vctrl_b_in sg13cmos5l_buf_1
X$5627 VGND \$2554 VPWR \$2612 sg13cmos5l_buf_1
X$5628 VGND \$43 VPWR vctrl_in sg13cmos5l_buf_1
X$5629 VGND \$555 VPWR \$1331 sg13cmos5l_buf_1
X$5630 VGND \$742 VPWR \$1090 sg13cmos5l_buf_1
X$5631 VGND \$2802 VPWR \$2653 sg13cmos5l_buf_1
X$5632 VGND \$2550 VPWR \$2750 sg13cmos5l_buf_1
X$5633 VGND \$261 VPWR \$2750 sg13cmos5l_buf_1
X$5634 VGND \$584 VPWR \$369 sg13cmos5l_buf_1
X$5635 VGND \$3035 VPWR \$4153 sg13cmos5l_buf_1
X$5636 VGND \$3225 VPWR \$2382 sg13cmos5l_buf_1
X$5637 VGND \$2393 VPWR \$755 sg13cmos5l_buf_1
X$5638 VGND \$2265 VPWR \$2260 sg13cmos5l_buf_1
X$5639 VGND \$2382 VPWR \$2418 sg13cmos5l_buf_1
X$5640 VGND \$2982 VPWR \$4078 sg13cmos5l_buf_1
X$5641 VGND \$178 VPWR \$152 sg13cmos5l_buf_1
X$5642 VGND \$3378 VPWR \$3475 sg13cmos5l_buf_1
X$5643 VGND \$2913 VPWR \$2393 sg13cmos5l_buf_1
X$5644 VGND \$77 VPWR \$79 sg13cmos5l_buf_1
X$5645 VGND \$26 VPWR \$77 sg13cmos5l_buf_1
X$5646 VGND \$2750 VPWR rst_n sg13cmos5l_buf_1
X$5647 VGND \$3364 VPWR \$3031 sg13cmos5l_buf_1
X$5648 VGND \$373 VPWR \$318 sg13cmos5l_buf_1
X$8011 VPWR VGND sg13cmos5l_decap_4
X$8012 VPWR VGND sg13cmos5l_decap_4
X$8013 VPWR VGND sg13cmos5l_decap_4
X$8014 VPWR VGND sg13cmos5l_decap_4
X$8015 VPWR VGND sg13cmos5l_decap_4
X$8016 VPWR VGND sg13cmos5l_decap_4
X$8017 VPWR VGND sg13cmos5l_decap_4
X$8018 VPWR VGND sg13cmos5l_decap_4
X$8019 VPWR VGND sg13cmos5l_decap_4
X$8020 VPWR VGND sg13cmos5l_decap_4
X$8021 VPWR VGND sg13cmos5l_decap_4
X$8022 VPWR VGND sg13cmos5l_decap_4
X$8023 VPWR VGND sg13cmos5l_decap_4
X$8024 VPWR VGND sg13cmos5l_decap_4
X$8025 VPWR VGND sg13cmos5l_decap_4
X$8026 VPWR VGND sg13cmos5l_decap_4
X$8027 VPWR VGND sg13cmos5l_decap_4
X$8028 VPWR VGND sg13cmos5l_decap_4
X$8029 VPWR VGND sg13cmos5l_decap_4
X$8030 VPWR VGND sg13cmos5l_decap_4
X$8031 VPWR VGND sg13cmos5l_decap_4
X$8032 VPWR VGND sg13cmos5l_decap_4
X$8033 VPWR VGND sg13cmos5l_decap_4
X$8034 VPWR VGND sg13cmos5l_decap_4
X$8035 VPWR VGND sg13cmos5l_decap_4
X$8036 VPWR VGND sg13cmos5l_decap_4
X$8037 VPWR VGND sg13cmos5l_decap_4
X$8038 VPWR VGND sg13cmos5l_decap_4
X$8039 VPWR VGND sg13cmos5l_decap_4
X$8040 VPWR VGND sg13cmos5l_decap_4
X$8041 VPWR VGND sg13cmos5l_decap_4
X$8042 VPWR VGND sg13cmos5l_decap_4
X$8043 VPWR VGND sg13cmos5l_decap_4
X$8044 VPWR VGND sg13cmos5l_decap_4
X$8045 VPWR VGND sg13cmos5l_decap_4
X$8046 VPWR VGND sg13cmos5l_decap_4
X$8047 VPWR VGND sg13cmos5l_decap_4
X$8048 VPWR VGND sg13cmos5l_decap_4
X$8049 VPWR VGND sg13cmos5l_decap_4
X$10732 VPWR VGND sg13cmos5l_decap_4
X$10734 VGND \$414 VPWR \$43 sg13cmos5l_buf_1
X$10738 VPWR VGND \$66 \$22 sg13cmos5l_dlygate4sd3_1
X$10739 VGND \$68 \$118 \$27 \$81 VPWR sg13cmos5l_dfrbpq_1
X$10741 \$45 VGND \$52 VPWR \$49 \$26 sg13cmos5l_a21oi_1
X$10742 VPWR VGND \$75 \$31 \$76 sg13cmos5l_nor2_1
X$10743 VPWR VGND sg13cmos5l_decap_8
X$10745 in_tieon VPWR VGND sg13cmos5l_tiehi
X$10748 VPWR VGND \$96 \$95 sg13cmos5l_inv_1
X$10749 VPWR VGND \$78 \$52 \$49 \$70 sg13cmos5l_and3_1
X$10750 VPWR VGND \$124 \$141 \$102 \$26 sg13cmos5l_nor3_1
X$10765 VGND \$37 VPWR \$177 \$176 \$178 sg13cmos5l_o21ai_1
X$10771 VPWR VGND \$270 \$215 \$177 sg13cmos5l_nand2b_1
X$10776 VGND VPWR \$79 \$215 \$270 sg13cmos5l_nor2b_1
X$10777 \$105 \$308 \$307 VPWR VGND sg13cmos5l_or2_1
X$10795 \$570 VGND VPWR \$289 \$369 \$526 \$137 sg13cmos5l_a22oi_1
X$10796 VGND \$628 \$81 VPWR sg13cmos5l_buf_8
X$10824 VPWR VGND \$1097 \$1179 \$644 sg13cmos5l_xnor2_1
X$10871 VPWR VGND \$1853 \$2130 \$283 \$485 \$2245 sg13cmos5l_or4_1
X$10888 VGND in_tieoff VPWR sg13cmos5l_tielo
M$1 \$312 \$250 \$313 VAPWR sg13_hv_pmos L=0.5u W=16u AS=5.44p AD=5.44p
+ PS=34.72u PD=34.72u rfmode=0
M$2 \$391 \$391 \$391 VGND sg13_hv_nmos L=0.5u W=2u AS=0.68p AD=0.68p PS=4.68u
+ PD=4.68u rfmode=0
M$3 \$313 \$313 \$313 VAPWR sg13_hv_pmos L=0.5u W=12u AS=4.08p AD=4.08p
+ PS=26.04u PD=26.04u rfmode=0
M$4 \$312 \$312 \$312 VGND sg13_hv_nmos L=0.5u W=2u AS=0.68p AD=0.68p PS=4.68u
+ PD=4.68u rfmode=0
M$5 \$391 analog_1 \$313 VAPWR sg13_hv_pmos L=0.5u W=16u AS=5.44p AD=5.44p
+ PS=34.72u PD=34.72u rfmode=0
M$7 VGND VGND VGND VGND sg13_hv_nmos L=0.5u W=38.5u AS=13.09p AD=13.09p
+ PS=96.72u PD=96.72u rfmode=0
M$8 \$391 \$391 VGND VGND sg13_hv_nmos L=0.5u W=8u AS=2.72p AD=2.72p PS=18.72u
+ PD=18.72u rfmode=0
M$9 \$312 \$391 VGND VGND sg13_hv_nmos L=0.5u W=8u AS=2.72p AD=2.72p PS=18.72u
+ PD=18.72u rfmode=0
M$16 \$312 \$312 \$312 VAPWR sg13_hv_pmos L=0.5u W=4u AS=1.36p AD=1.36p
+ PS=8.68u PD=8.68u rfmode=0
M$20 \$391 \$391 \$391 VAPWR sg13_hv_pmos L=0.5u W=4u AS=1.36p AD=1.36p
+ PS=8.68u PD=8.68u rfmode=0
R$25 VGND \$250 VGND rhigh w=2u l=12.9u ps=0u b=0 m=1
R$26 \$1193 VGND VGND rhigh w=2u l=4.25u ps=0u b=0 m=1
M$28 \$1368 \$1368 \$1368 VGND sg13_hv_nmos L=0.5u W=2u AS=0.68p AD=0.68p
+ PS=4.68u PD=4.68u rfmode=0
M$30 \$1368 \$1442 VGND VGND sg13_hv_nmos L=0.5u W=8u AS=2.72p AD=2.72p
+ PS=18.72u PD=18.72u rfmode=0
M$32 \$1442 \$1442 VGND VGND sg13_hv_nmos L=0.5u W=8u AS=2.72p AD=2.72p
+ PS=18.72u PD=18.72u rfmode=0
M$35 \$1442 \$1442 \$1442 VGND sg13_hv_nmos L=0.5u W=2u AS=0.68p AD=0.68p
+ PS=4.68u PD=4.68u rfmode=0
R$39 \$250 \$1268 VGND rhigh w=2u l=2.8u ps=0u b=0 m=1
M$40 \$1442 analog_1 \$1369 VAPWR sg13_hv_pmos L=0.5u W=16u AS=5.44p AD=5.44p
+ PS=34.72u PD=34.72u rfmode=0
M$42 \$1368 \$1368 \$1368 VAPWR sg13_hv_pmos L=0.5u W=4u AS=1.36p AD=1.36p
+ PS=8.68u PD=8.68u rfmode=0
M$43 \$1368 \$1268 \$1369 VAPWR sg13_hv_pmos L=0.5u W=16u AS=5.44p AD=5.44p
+ PS=34.72u PD=34.72u rfmode=0
M$45 \$1369 \$1369 \$1369 VAPWR sg13_hv_pmos L=0.5u W=12u AS=4.08p AD=4.08p
+ PS=26.04u PD=26.04u rfmode=0
M$47 \$1442 \$1442 \$1442 VAPWR sg13_hv_pmos L=0.5u W=4u AS=1.36p AD=1.36p
+ PS=8.68u PD=8.68u rfmode=0
M$52 \$2150 \$2152 VGND VGND sg13_hv_nmos L=0.5u W=8u AS=2.72p AD=2.72p
+ PS=18.72u PD=18.72u rfmode=0
M$53 \$2152 \$2152 \$2152 VGND sg13_hv_nmos L=0.5u W=2u AS=0.68p AD=0.68p
+ PS=4.68u PD=4.68u rfmode=0
M$54 \$2152 \$2152 VGND VGND sg13_hv_nmos L=0.5u W=8u AS=2.72p AD=2.72p
+ PS=18.72u PD=18.72u rfmode=0
M$58 \$2150 \$2150 \$2150 VGND sg13_hv_nmos L=0.5u W=2u AS=0.68p AD=0.68p
+ PS=4.68u PD=4.68u rfmode=0
M$61 \$2153 \$2153 \$2153 VAPWR sg13_hv_pmos L=0.5u W=12u AS=4.08p AD=4.08p
+ PS=26.04u PD=26.04u rfmode=0
M$62 \$2152 analog_1 \$2153 VAPWR sg13_hv_pmos L=0.5u W=16u AS=5.44p AD=5.44p
+ PS=34.72u PD=34.72u rfmode=0
M$64 \$2150 \$2051 \$2153 VAPWR sg13_hv_pmos L=0.5u W=16u AS=5.44p AD=5.44p
+ PS=34.72u PD=34.72u rfmode=0
M$70 VGND \$1689 \$I24101 VGND sg13_lv_nmos L=0.13u W=0.55u AS=0.14505p
+ AD=0.187p PS=1.15u PD=1.78u rfmode=0
M$71 VGND \$1788 \$I24102 VGND sg13_lv_nmos L=0.13u W=0.74u AS=0.14505p
+ AD=0.1406p PS=1.15u PD=1.12u rfmode=0
M$72 \$I24102 \$I24101 \$1887 VGND sg13_lv_nmos L=0.13u W=0.74u AS=0.1406p
+ AD=0.333p PS=1.12u PD=2.38u rfmode=0
M$73 \$I24101 \$1689 VPWR VPWR sg13_lv_pmos L=0.13u W=0.84u AS=0.2856p
+ AD=0.2198p PS=2.36u PD=1.53u rfmode=0
M$74 VPWR \$1788 \$1887 VPWR sg13_lv_pmos L=0.13u W=1.12u AS=0.2198p AD=0.2128p
+ PS=1.53u PD=1.5u rfmode=0
M$75 \$1887 \$I24101 VPWR VPWR sg13_lv_pmos L=0.13u W=1.12u AS=0.2128p
+ AD=0.3808p PS=1.5u PD=2.92u rfmode=0
M$76 \$1943 \$1884 \$I24105 VGND sg13_lv_nmos L=0.13u W=0.74u AS=0.2516p
+ AD=0.1406p PS=2.16u PD=1.12u rfmode=0
M$77 \$I24105 \$1885 VGND VGND sg13_lv_nmos L=0.13u W=0.74u AS=0.1406p
+ AD=0.2516p PS=1.12u PD=2.16u rfmode=0
M$78 \$1943 \$1883 VGND VGND sg13_lv_nmos L=0.13u W=0.74u AS=0.2516p AD=0.1406p
+ PS=2.16u PD=1.12u rfmode=0
M$79 VGND \$1888 \$I24106 VGND sg13_lv_nmos L=0.13u W=0.74u AS=0.1406p
+ AD=0.1406p PS=1.12u PD=1.12u rfmode=0
M$80 \$I24106 \$2021 \$1943 VGND sg13_lv_nmos L=0.13u W=0.74u AS=0.1406p
+ AD=0.2516p PS=1.12u PD=2.16u rfmode=0
M$81 VPWR \$1884 \$I24104 VPWR sg13_lv_pmos L=0.13u W=1.12u AS=0.3808p
+ AD=0.2128p PS=2.92u PD=1.5u rfmode=0
M$82 \$I24104 \$1885 VPWR VPWR sg13_lv_pmos L=0.13u W=1.12u AS=0.2128p
+ AD=0.3808p PS=1.5u PD=2.92u rfmode=0
M$83 \$1943 \$1883 \$I24103 VPWR sg13_lv_pmos L=0.13u W=1.12u AS=0.3808p
+ AD=0.2128p PS=2.92u PD=1.5u rfmode=0
M$84 \$I24103 \$1888 \$I24104 VPWR sg13_lv_pmos L=0.13u W=1.12u AS=0.2128p
+ AD=0.2128p PS=1.5u PD=1.5u rfmode=0
M$85 \$I24104 \$2021 \$I24103 VPWR sg13_lv_pmos L=0.13u W=1.12u AS=0.2128p
+ AD=0.3808p PS=1.5u PD=2.92u rfmode=0
M$86 \$2280 \$I24108 VGND VGND sg13_lv_nmos L=0.13u W=0.74u AS=0.2351p
+ AD=0.15745p PS=2.16u PD=1.175u rfmode=0
M$87 VGND \$1784 \$I24108 VGND sg13_lv_nmos L=0.13u W=0.64u AS=0.15745p
+ AD=0.1216p PS=1.175u PD=1.02u rfmode=0
M$88 \$I24108 \$1780 \$I24109 VGND sg13_lv_nmos L=0.13u W=0.64u AS=0.1216p
+ AD=0.0816p PS=1.02u PD=0.895u rfmode=0
M$89 \$I24109 \$1879 VGND VGND sg13_lv_nmos L=0.13u W=0.64u AS=0.0816p
+ AD=0.2176p PS=0.895u PD=1.96u rfmode=0
M$90 \$I24108 \$1784 \$I24107 VPWR sg13_lv_pmos L=0.13u W=1u AS=0.35p
+ AD=0.2125p PS=2.7u PD=1.425u rfmode=0
M$91 \$I24107 \$1780 VPWR VPWR sg13_lv_pmos L=0.13u W=1u AS=0.2125p AD=0.19p
+ PS=1.425u PD=1.38u rfmode=0
M$92 VPWR \$1879 \$I24107 VPWR sg13_lv_pmos L=0.13u W=1u AS=0.19p AD=0.34p
+ PS=1.38u PD=2.68u rfmode=0
M$93 \$2280 \$I24108 VPWR VPWR sg13_lv_pmos L=0.13u W=1.12u AS=0.3808p
+ AD=0.3808p PS=2.92u PD=2.92u rfmode=0
M$94 VGND \$1785 \$I24112 VGND sg13_lv_nmos L=0.13u W=0.64u AS=0.2272p
+ AD=0.0784p PS=1.99u PD=0.885u rfmode=0
M$95 \$I24112 \$1787 \$I24111 VGND sg13_lv_nmos L=0.13u W=0.64u AS=0.0784p
+ AD=0.2176p PS=0.885u PD=1.96u rfmode=0
M$96 VGND \$1785 \$I24110 VGND sg13_lv_nmos L=0.13u W=0.74u AS=0.1898p
+ AD=0.2516p PS=1.36u PD=2.16u rfmode=0
M$97 VGND \$1787 \$I24110 VGND sg13_lv_nmos L=0.13u W=0.74u AS=0.1898p
+ AD=0.1406p PS=1.36u PD=1.12u rfmode=0
M$98 \$I24110 \$I24111 \$1788 VGND sg13_lv_nmos L=0.13u W=0.74u AS=0.1406p
+ AD=0.2516p PS=1.12u PD=2.16u rfmode=0
M$99 VPWR \$1785 \$I24111 VPWR sg13_lv_pmos L=0.13u W=0.84u AS=0.4536p
+ AD=0.1596p PS=2.76u PD=1.22u rfmode=0
M$100 VPWR \$1787 \$I24111 VPWR sg13_lv_pmos L=0.13u W=0.84u AS=0.2891p
+ AD=0.1596p PS=1.695u PD=1.22u rfmode=0
M$101 VPWR \$1785 \$I24113 VPWR sg13_lv_pmos L=0.13u W=1.12u AS=0.2891p
+ AD=0.1428p PS=1.695u PD=1.375u rfmode=0
M$102 \$I24113 \$1787 \$1788 VPWR sg13_lv_pmos L=0.13u W=1.12u AS=0.1428p
+ AD=0.2408p PS=1.375u PD=1.55u rfmode=0
M$103 \$1788 \$I24111 VPWR VPWR sg13_lv_pmos L=0.13u W=1.12u AS=0.2408p
+ AD=0.3808p PS=1.55u PD=2.92u rfmode=0
M$104 VGND \$1687 \$I24114 VGND sg13_lv_nmos L=0.13u W=0.55u AS=0.18575p
+ AD=0.187p PS=1.26u PD=1.78u rfmode=0
M$105 VGND \$2023 \$I24116 VGND sg13_lv_nmos L=0.13u W=0.74u AS=0.18575p
+ AD=0.1406p PS=1.26u PD=1.12u rfmode=0
M$106 \$I24116 \$1887 \$I24115 VGND sg13_lv_nmos L=0.13u W=0.74u AS=0.1406p
+ AD=0.1406p PS=1.12u PD=1.12u rfmode=0
M$107 \$I24115 \$I24114 \$1885 VGND sg13_lv_nmos L=0.13u W=0.74u AS=0.1406p
+ AD=0.3404p PS=1.12u PD=2.4u rfmode=0
M$108 \$I24114 \$1687 VPWR VPWR sg13_lv_pmos L=0.13u W=0.84u AS=0.2856p
+ AD=0.2198p PS=2.36u PD=1.53u rfmode=0
M$109 VPWR \$2023 \$1885 VPWR sg13_lv_pmos L=0.13u W=1.12u AS=0.2198p
+ AD=0.2128p PS=1.53u PD=1.5u rfmode=0
M$110 \$1885 \$1887 VPWR VPWR sg13_lv_pmos L=0.13u W=1.12u AS=0.2128p
+ AD=0.2128p PS=1.5u PD=1.5u rfmode=0
M$111 VPWR \$I24114 \$1885 VPWR sg13_lv_pmos L=0.13u W=1.12u AS=0.2128p
+ AD=0.3808p PS=1.5u PD=2.92u rfmode=0
M$112 VGND \$1780 \$1687 VGND sg13_lv_nmos L=0.13u W=0.74u AS=0.2516p
+ AD=0.1406p PS=2.16u PD=1.12u rfmode=0
M$113 \$1687 \$2226 VGND VGND sg13_lv_nmos L=0.13u W=0.74u AS=0.1406p
+ AD=0.1406p PS=1.12u PD=1.12u rfmode=0
M$114 VGND \$2115 \$1687 VGND sg13_lv_nmos L=0.13u W=0.74u AS=0.1406p
+ AD=0.1406p PS=1.12u PD=1.12u rfmode=0
M$115 \$1687 \$2437 VGND VGND sg13_lv_nmos L=0.13u W=0.74u AS=0.1406p
+ AD=0.237575p PS=1.12u PD=2.16u rfmode=0
M$116 VPWR \$1780 \$I24118 VPWR sg13_lv_pmos L=0.13u W=1.12u AS=0.3808p
+ AD=0.2128p PS=2.92u PD=1.5u rfmode=0
M$117 \$I24118 \$2226 \$I24117 VPWR sg13_lv_pmos L=0.13u W=1.12u AS=0.2128p
+ AD=0.2128p PS=1.5u PD=1.5u rfmode=0
M$118 \$I24117 \$2115 \$I24119 VPWR sg13_lv_pmos L=0.13u W=1.12u AS=0.2128p
+ AD=0.2128p PS=1.5u PD=1.5u rfmode=0
M$119 \$I24119 \$2437 \$1687 VPWR sg13_lv_pmos L=0.13u W=1.12u AS=0.2128p
+ AD=0.4368p PS=1.5u PD=3.02u rfmode=0
M$120 VGND \$1782 \$2159 VGND sg13_lv_nmos L=0.13u W=0.74u AS=0.2516p
+ AD=0.1406p PS=2.16u PD=1.12u rfmode=0
M$121 \$2159 \$2220 \$I24121 VGND sg13_lv_nmos L=0.13u W=0.74u AS=0.1406p
+ AD=0.1406p PS=1.12u PD=1.12u rfmode=0
M$122 \$I24121 \$2170 VGND VGND sg13_lv_nmos L=0.13u W=0.74u AS=0.1406p
+ AD=0.2516p PS=1.12u PD=2.16u rfmode=0
M$123 \$2159 \$1782 \$I24120 VPWR sg13_lv_pmos L=0.13u W=1.12u AS=0.3808p
+ AD=0.2128p PS=2.92u PD=1.5u rfmode=0
M$124 \$I24120 \$2220 VPWR VPWR sg13_lv_pmos L=0.13u W=1.12u AS=0.2128p
+ AD=0.2128p PS=1.5u PD=1.5u rfmode=0
M$125 VPWR \$2170 \$I24120 VPWR sg13_lv_pmos L=0.13u W=1.12u AS=0.2128p
+ AD=0.3808p PS=1.5u PD=2.92u rfmode=0
M$126 VGND \$2280 \$2221 VGND sg13_lv_nmos L=0.13u W=0.74u AS=0.2516p
+ AD=0.1406p PS=2.16u PD=1.12u rfmode=0
M$127 \$2221 \$1778 \$I24123 VGND sg13_lv_nmos L=0.13u W=0.74u AS=0.1406p
+ AD=0.1406p PS=1.12u PD=1.12u rfmode=0
M$128 \$I24123 \$1779 VGND VGND sg13_lv_nmos L=0.13u W=0.74u AS=0.1406p
+ AD=0.2516p PS=1.12u PD=2.16u rfmode=0
M$129 \$2221 \$2280 \$I24122 VPWR sg13_lv_pmos L=0.13u W=1.12u AS=0.3808p
+ AD=0.2128p PS=2.92u PD=1.5u rfmode=0
M$130 \$I24122 \$1778 VPWR VPWR sg13_lv_pmos L=0.13u W=1.12u AS=0.2128p
+ AD=0.2128p PS=1.5u PD=1.5u rfmode=0
M$131 VPWR \$1779 \$I24122 VPWR sg13_lv_pmos L=0.13u W=1.12u AS=0.2128p
+ AD=0.3808p PS=1.5u PD=2.92u rfmode=0
M$132 VGND \$1686 \$1824 VGND sg13_lv_nmos L=0.13u W=0.74u AS=0.2516p
+ AD=0.1406p PS=2.16u PD=1.12u rfmode=0
M$133 \$1824 \$1684 \$I24125 VGND sg13_lv_nmos L=0.13u W=0.74u AS=0.1406p
+ AD=0.1406p PS=1.12u PD=1.12u rfmode=0
M$134 \$I24125 \$1687 VGND VGND sg13_lv_nmos L=0.13u W=0.74u AS=0.1406p
+ AD=0.2516p PS=1.12u PD=2.16u rfmode=0
M$135 \$1824 \$1686 \$I24124 VPWR sg13_lv_pmos L=0.13u W=1.12u AS=0.3808p
+ AD=0.2128p PS=2.92u PD=1.5u rfmode=0
M$136 \$I24124 \$1684 VPWR VPWR sg13_lv_pmos L=0.13u W=1.12u AS=0.2128p
+ AD=0.2128p PS=1.5u PD=1.5u rfmode=0
M$137 VPWR \$1687 \$I24124 VPWR sg13_lv_pmos L=0.13u W=1.12u AS=0.2128p
+ AD=0.3808p PS=1.5u PD=2.92u rfmode=0
M$138 VGND \$1887 \$I24127 VGND sg13_lv_nmos L=0.13u W=0.74u AS=0.2886p
+ AD=0.1406p PS=2.26u PD=1.12u rfmode=0
M$139 \$I24127 \$2118 \$I24126 VGND sg13_lv_nmos L=0.13u W=0.74u AS=0.1406p
+ AD=0.1406p PS=1.12u PD=1.12u rfmode=0
M$140 \$I24126 \$2112 \$2170 VGND sg13_lv_nmos L=0.13u W=0.74u AS=0.1406p
+ AD=0.2516p PS=1.12u PD=2.16u rfmode=0
M$141 VPWR \$1887 \$2170 VPWR sg13_lv_pmos L=0.13u W=1.12u AS=0.3808p
+ AD=0.2128p PS=2.92u PD=1.5u rfmode=0
M$142 \$2170 \$2118 VPWR VPWR sg13_lv_pmos L=0.13u W=1.12u AS=0.2128p
+ AD=0.2128p PS=1.5u PD=1.5u rfmode=0
M$143 VPWR \$2112 \$2170 VPWR sg13_lv_pmos L=0.13u W=1.12u AS=0.2128p
+ AD=0.3808p PS=1.5u PD=2.92u rfmode=0
M$144 VGND \$1779 \$I24128 VGND sg13_lv_nmos L=0.13u W=0.55u AS=0.187p
+ AD=0.1045p PS=1.78u PD=0.93u rfmode=0
M$145 \$I24128 \$1784 VGND VGND sg13_lv_nmos L=0.13u W=0.55u AS=0.1045p
+ AD=0.1469p PS=0.93u PD=1.155u rfmode=0
M$146 VGND \$I24128 \$1782 VGND sg13_lv_nmos L=0.13u W=0.74u AS=0.1469p
+ AD=0.2516p PS=1.155u PD=2.16u rfmode=0
M$147 \$I24128 \$1779 \$I24129 VPWR sg13_lv_pmos L=0.13u W=0.84u AS=0.2856p
+ AD=0.1596p PS=2.36u PD=1.22u rfmode=0
M$148 VPWR \$1784 \$I24129 VPWR sg13_lv_pmos L=0.13u W=0.84u AS=0.2226p
+ AD=0.1596p PS=1.535u PD=1.22u rfmode=0
M$149 VPWR \$I24128 \$1782 VPWR sg13_lv_pmos L=0.13u W=1.12u AS=0.2226p
+ AD=0.3976p PS=1.535u PD=2.95u rfmode=0
M$150 \$I24130 \$1689 VGND VGND sg13_lv_nmos L=0.15u W=0.74u AS=0.2516p
+ AD=0.1406p PS=2.16u PD=1.12u rfmode=0
M$151 VGND \$1788 \$I24130 VGND sg13_lv_nmos L=0.15u W=0.74u AS=0.1406p
+ AD=0.1406p PS=1.12u PD=1.12u rfmode=0
M$152 \$I24130 \$1879 \$1779 VGND sg13_lv_nmos L=0.15u W=0.74u AS=0.1406p
+ AD=0.2516p PS=1.12u PD=2.16u rfmode=0
M$153 VPWR \$1689 \$I24131 VPWR sg13_lv_pmos L=0.15u W=1.12u AS=0.3808p
+ AD=0.2128p PS=2.92u PD=1.5u rfmode=0
M$154 \$I24131 \$1788 \$1779 VPWR sg13_lv_pmos L=0.15u W=1.12u AS=0.2128p
+ AD=0.2128p PS=1.5u PD=1.5u rfmode=0
M$155 \$1779 \$1879 VPWR VPWR sg13_lv_pmos L=0.15u W=1.12u AS=0.2128p
+ AD=0.3808p PS=1.5u PD=2.92u rfmode=0
M$156 \$I24132 \$2023 VGND VGND sg13_lv_nmos L=0.15u W=0.74u AS=0.2516p
+ AD=0.1406p PS=2.16u PD=1.12u rfmode=0
M$157 VGND \$1689 \$I24132 VGND sg13_lv_nmos L=0.15u W=0.74u AS=0.1406p
+ AD=0.1406p PS=1.12u PD=1.12u rfmode=0
M$158 \$I24132 \$1685 \$2121 VGND sg13_lv_nmos L=0.15u W=0.74u AS=0.1406p
+ AD=0.2516p PS=1.12u PD=2.16u rfmode=0
M$159 VPWR \$2023 \$I24133 VPWR sg13_lv_pmos L=0.15u W=1.12u AS=0.3808p
+ AD=0.2128p PS=2.92u PD=1.5u rfmode=0
M$160 \$I24133 \$1689 \$2121 VPWR sg13_lv_pmos L=0.15u W=1.12u AS=0.2128p
+ AD=0.2128p PS=1.5u PD=1.5u rfmode=0
M$161 \$2121 \$1685 VPWR VPWR sg13_lv_pmos L=0.15u W=1.12u AS=0.2128p
+ AD=0.3808p PS=1.5u PD=2.92u rfmode=0
M$162 \$I24134 \$1689 VGND VGND sg13_lv_nmos L=0.15u W=0.74u AS=0.2516p
+ AD=0.1406p PS=2.16u PD=1.12u rfmode=0
M$163 VGND \$1788 \$I24134 VGND sg13_lv_nmos L=0.15u W=0.74u AS=0.1406p
+ AD=0.1406p PS=1.12u PD=1.12u rfmode=0
M$164 \$I24134 \$1685 \$1883 VGND sg13_lv_nmos L=0.15u W=0.74u AS=0.1406p
+ AD=0.2516p PS=1.12u PD=2.16u rfmode=0
M$165 VPWR \$1689 \$I24135 VPWR sg13_lv_pmos L=0.15u W=1.12u AS=0.3808p
+ AD=0.2128p PS=2.92u PD=1.5u rfmode=0
M$166 \$I24135 \$1788 \$1883 VPWR sg13_lv_pmos L=0.15u W=1.12u AS=0.2128p
+ AD=0.2128p PS=1.5u PD=1.5u rfmode=0
M$167 \$1883 \$1685 VPWR VPWR sg13_lv_pmos L=0.15u W=1.12u AS=0.2128p
+ AD=0.3808p PS=1.5u PD=2.92u rfmode=0
M$168 \$I24136 \$1785 VGND VGND sg13_lv_nmos L=0.15u W=0.74u AS=0.2516p
+ AD=0.1406p PS=2.16u PD=1.12u rfmode=0
M$169 VGND \$1687 \$I24136 VGND sg13_lv_nmos L=0.15u W=0.74u AS=0.1406p
+ AD=0.1406p PS=1.12u PD=1.12u rfmode=0
M$170 \$I24136 \$1685 \$1686 VGND sg13_lv_nmos L=0.15u W=0.74u AS=0.1406p
+ AD=0.2516p PS=1.12u PD=2.16u rfmode=0
M$171 VPWR \$1785 \$I24137 VPWR sg13_lv_pmos L=0.15u W=1.12u AS=0.3808p
+ AD=0.2128p PS=2.92u PD=1.5u rfmode=0
M$172 \$I24137 \$1687 \$1686 VPWR sg13_lv_pmos L=0.15u W=1.12u AS=0.2128p
+ AD=0.2128p PS=1.5u PD=1.5u rfmode=0
M$173 \$1686 \$1685 VPWR VPWR sg13_lv_pmos L=0.15u W=1.12u AS=0.2128p
+ AD=0.3808p PS=1.5u PD=2.92u rfmode=0
M$174 VGND \$1785 \$520 VGND sg13_lv_nmos L=0.13u W=0.74u AS=0.2516p AD=0.1406p
+ PS=2.16u PD=1.12u rfmode=0
M$175 \$520 \$1689 VGND VGND sg13_lv_nmos L=0.13u W=0.74u AS=0.1406p AD=0.2516p
+ PS=1.12u PD=2.16u rfmode=0
M$176 VPWR \$1785 \$I24138 VPWR sg13_lv_pmos L=0.13u W=1.12u AS=0.4032p
+ AD=0.1176p PS=2.96u PD=1.33u rfmode=0
M$177 \$I24138 \$1689 \$520 VPWR sg13_lv_pmos L=0.13u W=1.12u AS=0.1176p
+ AD=0.3808p PS=1.33u PD=2.92u rfmode=0
M$178 VGND \$1885 \$I24139 VGND sg13_lv_nmos L=0.13u W=0.55u AS=0.17255p
+ AD=0.187p PS=1.25u PD=1.78u rfmode=0
M$179 VGND \$I24139 \$2169 VGND sg13_lv_nmos L=0.13u W=0.74u AS=0.17255p
+ AD=0.1406p PS=1.25u PD=1.12u rfmode=0
M$180 \$2169 \$2120 VGND VGND sg13_lv_nmos L=0.13u W=0.74u AS=0.1406p
+ AD=0.2516p PS=1.12u PD=2.16u rfmode=0
M$181 \$I24139 \$1885 VPWR VPWR sg13_lv_pmos L=0.13u W=0.84u AS=0.2856p
+ AD=0.2618p PS=2.36u PD=1.63u rfmode=0
M$182 VPWR \$I24139 \$I24140 VPWR sg13_lv_pmos L=0.13u W=1.12u AS=0.2618p
+ AD=0.1176p PS=1.63u PD=1.33u rfmode=0
M$183 \$I24140 \$2120 \$2169 VPWR sg13_lv_pmos L=0.13u W=1.12u AS=0.1176p
+ AD=0.3808p PS=1.33u PD=2.92u rfmode=0
M$184 VGND \$1887 \$I24141 VGND sg13_lv_nmos L=0.13u W=0.55u AS=0.17255p
+ AD=0.187p PS=1.25u PD=1.78u rfmode=0
M$185 VGND \$I24141 \$1888 VGND sg13_lv_nmos L=0.13u W=0.74u AS=0.17255p
+ AD=0.1406p PS=1.25u PD=1.12u rfmode=0
M$186 \$1888 \$1687 VGND VGND sg13_lv_nmos L=0.13u W=0.74u AS=0.1406p
+ AD=0.2516p PS=1.12u PD=2.16u rfmode=0
M$187 \$I24141 \$1887 VPWR VPWR sg13_lv_pmos L=0.13u W=0.84u AS=0.2856p
+ AD=0.2618p PS=2.36u PD=1.63u rfmode=0
M$188 VPWR \$I24141 \$I24142 VPWR sg13_lv_pmos L=0.13u W=1.12u AS=0.2618p
+ AD=0.1176p PS=1.63u PD=1.33u rfmode=0
M$189 \$I24142 \$1687 \$1888 VPWR sg13_lv_pmos L=0.13u W=1.12u AS=0.1176p
+ AD=0.3808p PS=1.33u PD=2.92u rfmode=0
M$190 VGND \$1785 \$I24143 VGND sg13_lv_nmos L=0.13u W=0.55u AS=0.17255p
+ AD=0.187p PS=1.25u PD=1.78u rfmode=0
M$191 VGND \$I24143 \$768 VGND sg13_lv_nmos L=0.13u W=0.74u AS=0.17255p
+ AD=0.1406p PS=1.25u PD=1.12u rfmode=0
M$192 \$768 \$1689 VGND VGND sg13_lv_nmos L=0.13u W=0.74u AS=0.1406p AD=0.2516p
+ PS=1.12u PD=2.16u rfmode=0
M$193 \$I24143 \$1785 VPWR VPWR sg13_lv_pmos L=0.13u W=0.84u AS=0.2856p
+ AD=0.2618p PS=2.36u PD=1.63u rfmode=0
M$194 VPWR \$I24143 \$I24144 VPWR sg13_lv_pmos L=0.13u W=1.12u AS=0.2618p
+ AD=0.1176p PS=1.63u PD=1.33u rfmode=0
M$195 \$I24144 \$1689 \$768 VPWR sg13_lv_pmos L=0.13u W=1.12u AS=0.1176p
+ AD=0.3808p PS=1.33u PD=2.92u rfmode=0
M$196 \$I24145 \$2115 \$I24146 VGND sg13_lv_nmos L=0.13u W=0.64u AS=0.2176p
+ AD=0.1216p PS=1.96u PD=1.02u rfmode=0
M$197 VGND \$2118 \$I24146 VGND sg13_lv_nmos L=0.13u W=0.64u AS=0.1331p
+ AD=0.1216p PS=1.12u PD=1.02u rfmode=0
M$198 VGND \$I24145 \$2021 VGND sg13_lv_nmos L=0.13u W=0.74u AS=0.1331p
+ AD=0.2516p PS=1.12u PD=2.16u rfmode=0
M$199 VPWR \$2115 \$I24145 VPWR sg13_lv_pmos L=0.13u W=0.84u AS=0.2856p
+ AD=0.1596p PS=2.36u PD=1.22u rfmode=0
M$200 VPWR \$2118 \$I24145 VPWR sg13_lv_pmos L=0.13u W=0.84u AS=0.1918p
+ AD=0.1596p PS=1.5u PD=1.22u rfmode=0
M$201 VPWR \$I24145 \$2021 VPWR sg13_lv_pmos L=0.13u W=1.12u AS=0.1918p
+ AD=0.3808p PS=1.5u PD=2.92u rfmode=0
M$202 \$I24147 \$1685 \$I24148 VGND sg13_lv_nmos L=0.13u W=0.64u AS=0.2176p
+ AD=0.1216p PS=1.96u PD=1.02u rfmode=0
M$203 VGND \$2896 \$I24148 VGND sg13_lv_nmos L=0.13u W=0.64u AS=0.1331p
+ AD=0.1216p PS=1.12u PD=1.02u rfmode=0
M$204 VGND \$I24147 \$1929 VGND sg13_lv_nmos L=0.13u W=0.74u AS=0.1331p
+ AD=0.2516p PS=1.12u PD=2.16u rfmode=0
M$205 VPWR \$1685 \$I24147 VPWR sg13_lv_pmos L=0.13u W=0.84u AS=0.2856p
+ AD=0.1596p PS=2.36u PD=1.22u rfmode=0
M$206 VPWR \$2896 \$I24147 VPWR sg13_lv_pmos L=0.13u W=0.84u AS=0.1918p
+ AD=0.1596p PS=1.5u PD=1.22u rfmode=0
M$207 VPWR \$I24147 \$1929 VPWR sg13_lv_pmos L=0.13u W=1.12u AS=0.1918p
+ AD=0.3808p PS=1.5u PD=2.92u rfmode=0
M$208 \$I24149 \$1685 \$I24150 VGND sg13_lv_nmos L=0.13u W=0.64u AS=0.2176p
+ AD=0.1216p PS=1.96u PD=1.02u rfmode=0
M$209 VGND \$3803 \$I24150 VGND sg13_lv_nmos L=0.13u W=0.64u AS=0.1331p
+ AD=0.1216p PS=1.12u PD=1.02u rfmode=0
M$210 VGND \$I24149 \$3527 VGND sg13_lv_nmos L=0.13u W=0.74u AS=0.1331p
+ AD=0.2516p PS=1.12u PD=2.16u rfmode=0
M$211 VPWR \$1685 \$I24149 VPWR sg13_lv_pmos L=0.13u W=0.84u AS=0.2856p
+ AD=0.1596p PS=2.36u PD=1.22u rfmode=0
M$212 VPWR \$3803 \$I24149 VPWR sg13_lv_pmos L=0.13u W=0.84u AS=0.1918p
+ AD=0.1596p PS=1.5u PD=1.22u rfmode=0
M$213 VPWR \$I24149 \$3527 VPWR sg13_lv_pmos L=0.13u W=1.12u AS=0.1918p
+ AD=0.3808p PS=1.5u PD=2.92u rfmode=0
M$214 \$I24151 \$1685 \$I24152 VGND sg13_lv_nmos L=0.13u W=0.64u AS=0.2176p
+ AD=0.1216p PS=1.96u PD=1.02u rfmode=0
M$215 VGND \$1888 \$I24152 VGND sg13_lv_nmos L=0.13u W=0.64u AS=0.1331p
+ AD=0.1216p PS=1.12u PD=1.02u rfmode=0
M$216 VGND \$I24151 \$1886 VGND sg13_lv_nmos L=0.13u W=0.74u AS=0.1331p
+ AD=0.2516p PS=1.12u PD=2.16u rfmode=0
M$217 VPWR \$1685 \$I24151 VPWR sg13_lv_pmos L=0.13u W=0.84u AS=0.2856p
+ AD=0.1596p PS=2.36u PD=1.22u rfmode=0
M$218 VPWR \$1888 \$I24151 VPWR sg13_lv_pmos L=0.13u W=0.84u AS=0.1918p
+ AD=0.1596p PS=1.5u PD=1.22u rfmode=0
M$219 VPWR \$I24151 \$1886 VPWR sg13_lv_pmos L=0.13u W=1.12u AS=0.1918p
+ AD=0.3808p PS=1.5u PD=2.92u rfmode=0
M$220 \$I24153 \$3012 VGND VGND sg13_lv_nmos L=0.13u W=2.22u AS=0.5365p
+ AD=0.4218p PS=4.41u PD=3.36u rfmode=0
M$223 VGND \$I24153 \$2018 VGND sg13_lv_nmos L=0.13u W=5.92u AS=1.1248p
+ AD=1.2358p PS=8.96u PD=10u rfmode=0
M$231 \$I24153 \$3012 VPWR VPWR sg13_lv_pmos L=0.13u W=3.36u AS=0.8064p
+ AD=0.6384p PS=5.92u PD=4.5u rfmode=0
M$234 VPWR \$I24153 \$2018 VPWR sg13_lv_pmos L=0.13u W=8.96u AS=1.7024p
+ AD=1.876p PS=12u PD=13.43u rfmode=0
M$242 \$I24154 clk VGND VGND sg13_lv_nmos L=0.13u W=2.22u AS=0.5365p AD=0.4218p
+ PS=4.41u PD=3.36u rfmode=0
M$245 VGND \$I24154 \$3012 VGND sg13_lv_nmos L=0.13u W=5.92u AS=1.1248p
+ AD=1.2358p PS=8.96u PD=10u rfmode=0
M$253 \$I24154 clk VPWR VPWR sg13_lv_pmos L=0.13u W=3.36u AS=0.8064p AD=0.6384p
+ PS=5.92u PD=4.5u rfmode=0
M$256 VPWR \$I24154 \$3012 VPWR sg13_lv_pmos L=0.13u W=8.96u AS=1.7024p
+ AD=1.876p PS=12u PD=13.43u rfmode=0
M$264 \$I24155 clk VGND VGND sg13_lv_nmos L=0.13u W=2.22u AS=0.5365p AD=0.4218p
+ PS=4.41u PD=3.36u rfmode=0
M$267 VGND \$I24155 \$1586 VGND sg13_lv_nmos L=0.13u W=5.92u AS=1.1248p
+ AD=1.2358p PS=8.96u PD=10u rfmode=0
M$275 \$I24155 clk VPWR VPWR sg13_lv_pmos L=0.13u W=3.36u AS=0.8064p AD=0.6384p
+ PS=5.92u PD=4.5u rfmode=0
M$278 VPWR \$I24155 \$1586 VPWR sg13_lv_pmos L=0.13u W=8.96u AS=1.7024p
+ AD=1.876p PS=12u PD=13.43u rfmode=0
M$286 \$I24156 \$2018 VGND VGND sg13_lv_nmos L=0.13u W=2.22u AS=0.5365p
+ AD=0.4218p PS=4.41u PD=3.36u rfmode=0
M$289 VGND \$I24156 \$1790 VGND sg13_lv_nmos L=0.13u W=5.92u AS=1.1248p
+ AD=1.2358p PS=8.96u PD=10u rfmode=0
M$297 \$I24156 \$2018 VPWR VPWR sg13_lv_pmos L=0.13u W=3.36u AS=0.8064p
+ AD=0.6384p PS=5.92u PD=4.5u rfmode=0
M$300 VPWR \$I24156 \$1790 VPWR sg13_lv_pmos L=0.13u W=8.96u AS=1.7024p
+ AD=1.876p PS=12u PD=13.43u rfmode=0
M$308 \$I24157 \$2018 VGND VGND sg13_lv_nmos L=0.13u W=2.22u AS=0.5365p
+ AD=0.4218p PS=4.41u PD=3.36u rfmode=0
M$311 VGND \$I24157 \$1878 VGND sg13_lv_nmos L=0.13u W=5.92u AS=1.1248p
+ AD=1.2358p PS=8.96u PD=10u rfmode=0
M$319 \$I24157 \$2018 VPWR VPWR sg13_lv_pmos L=0.13u W=3.36u AS=0.8064p
+ AD=0.6384p PS=5.92u PD=4.5u rfmode=0
M$322 VPWR \$I24157 \$1878 VPWR sg13_lv_pmos L=0.13u W=8.96u AS=1.7024p
+ AD=1.876p PS=12u PD=13.43u rfmode=0
M$330 \$I24158 \$2018 VGND VGND sg13_lv_nmos L=0.13u W=2.22u AS=0.5365p
+ AD=0.4218p PS=4.41u PD=3.36u rfmode=0
M$333 VGND \$I24158 \$3356 VGND sg13_lv_nmos L=0.13u W=5.92u AS=1.1248p
+ AD=1.2358p PS=8.96u PD=10u rfmode=0
M$341 \$I24158 \$2018 VPWR VPWR sg13_lv_pmos L=0.13u W=3.36u AS=0.8064p
+ AD=0.6384p PS=5.92u PD=4.5u rfmode=0
M$344 VPWR \$I24158 \$3356 VPWR sg13_lv_pmos L=0.13u W=8.96u AS=1.7024p
+ AD=1.876p PS=12u PD=13.43u rfmode=0
M$352 \$I24159 \$2018 VGND VGND sg13_lv_nmos L=0.13u W=2.22u AS=0.5365p
+ AD=0.4218p PS=4.41u PD=3.36u rfmode=0
M$355 VGND \$I24159 \$2375 VGND sg13_lv_nmos L=0.13u W=5.92u AS=1.1248p
+ AD=1.2358p PS=8.96u PD=10u rfmode=0
M$363 \$I24159 \$2018 VPWR VPWR sg13_lv_pmos L=0.13u W=3.36u AS=0.8064p
+ AD=0.6384p PS=5.92u PD=4.5u rfmode=0
M$366 VPWR \$I24159 \$2375 VPWR sg13_lv_pmos L=0.13u W=8.96u AS=1.7024p
+ AD=1.876p PS=12u PD=13.43u rfmode=0
M$374 \$I24160 \$1586 VGND VGND sg13_lv_nmos L=0.13u W=2.22u AS=0.5365p
+ AD=0.4218p PS=4.41u PD=3.36u rfmode=0
M$377 VGND \$I24160 \$1722 VGND sg13_lv_nmos L=0.13u W=5.92u AS=1.1248p
+ AD=1.2358p PS=8.96u PD=10u rfmode=0
M$385 \$I24160 \$1586 VPWR VPWR sg13_lv_pmos L=0.13u W=3.36u AS=0.8064p
+ AD=0.6384p PS=5.92u PD=4.5u rfmode=0
M$388 VPWR \$I24160 \$1722 VPWR sg13_lv_pmos L=0.13u W=8.96u AS=1.7024p
+ AD=1.876p PS=12u PD=13.43u rfmode=0
M$396 VGND \$I24162 \$I24173 VGND sg13_lv_nmos L=0.13u W=0.74u AS=0.317325p
+ AD=0.2516p PS=1.805u PD=2.16u rfmode=0
M$397 VGND \$3356 \$I24162 VGND sg13_lv_nmos L=0.13u W=0.74u AS=0.317325p
+ AD=0.2516p PS=1.805u PD=2.16u rfmode=0
M$398 \$I24169 \$I24162 \$I24165 VGND sg13_lv_nmos L=0.13u W=0.42u AS=0.12665p
+ AD=0.1428p PS=1.145u PD=1.52u rfmode=0
M$399 \$I24161 \$I24173 \$I24169 VGND sg13_lv_nmos L=0.13u W=0.74u AS=0.3473p
+ AD=0.12665p PS=2.71u PD=1.145u rfmode=0
M$400 \$I24163 \$4125 \$I24170 VGND sg13_lv_nmos L=0.13u W=0.42u AS=0.1428p
+ AD=0.0609p PS=1.52u PD=0.71u rfmode=0
M$401 \$I24170 \$4124 VGND VGND sg13_lv_nmos L=0.13u W=0.42u AS=0.0609p
+ AD=0.1626p PS=0.71u PD=1.415u rfmode=0
M$402 VGND \$I24168 \$I24161 VGND sg13_lv_nmos L=0.13u W=0.74u AS=0.1626p
+ AD=0.2516p PS=1.415u PD=2.16u rfmode=0
M$403 \$I24167 \$I24169 VGND VGND sg13_lv_nmos L=0.13u W=0.74u AS=0.2516p
+ AD=0.1406p PS=2.16u PD=1.12u rfmode=0
M$404 VGND \$I24167 \$2429 VGND sg13_lv_nmos L=0.13u W=0.74u AS=0.1406p
+ AD=0.2516p PS=1.12u PD=2.16u rfmode=0
M$405 \$I24163 \$I24162 \$I24168 VGND sg13_lv_nmos L=0.13u W=0.42u AS=0.1296p
+ AD=0.0798p PS=1.52u PD=0.8u rfmode=0
M$406 \$I24168 \$I24173 \$I24164 VGND sg13_lv_nmos L=0.13u W=0.42u AS=0.0798p
+ AD=0.2373p PS=0.8u PD=1.97u rfmode=0
M$407 \$I24165 \$I24166 VGND VGND sg13_lv_nmos L=0.13u W=0.42u AS=0.1428p
+ AD=0.0798p PS=1.52u PD=0.8u rfmode=0
M$408 VGND \$4124 \$I24172 VGND sg13_lv_nmos L=0.13u W=0.42u AS=0.0798p
+ AD=0.0378p PS=0.8u PD=0.6u rfmode=0
M$409 \$I24172 \$I24169 \$I24166 VGND sg13_lv_nmos L=0.13u W=0.42u AS=0.0378p
+ AD=0.1428p PS=0.6u PD=1.52u rfmode=0
M$410 VGND \$4124 \$I24171 VGND sg13_lv_nmos L=0.13u W=0.42u AS=0.1701p
+ AD=0.0378p PS=1.65u PD=0.6u rfmode=0
M$411 \$I24171 \$I24161 \$I24164 VGND sg13_lv_nmos L=0.13u W=0.42u AS=0.0378p
+ AD=0.1428p PS=0.6u PD=1.52u rfmode=0
M$412 \$I24169 \$I24173 \$I24175 VPWR sg13_lv_pmos L=0.13u W=0.42u AS=0.2048p
+ AD=0.09345p PS=1.63u PD=0.865u rfmode=0
M$413 \$I24175 \$I24166 VPWR VPWR sg13_lv_pmos L=0.13u W=0.42u AS=0.09345p
+ AD=0.204p PS=0.865u PD=1.835u rfmode=0
M$414 VPWR \$4124 \$I24166 VPWR sg13_lv_pmos L=0.13u W=0.42u AS=0.204p
+ AD=0.0798p PS=1.835u PD=0.8u rfmode=0
M$415 \$I24166 \$I24169 VPWR VPWR sg13_lv_pmos L=0.13u W=0.42u AS=0.0798p
+ AD=0.4659p PS=0.8u PD=3.65u rfmode=0
M$416 \$I24161 \$I24162 \$I24169 VPWR sg13_lv_pmos L=0.13u W=1u AS=0.34p
+ AD=0.2048p PS=2.68u PD=1.63u rfmode=0
M$417 \$I24167 \$I24169 VPWR VPWR sg13_lv_pmos L=0.13u W=1.12u AS=0.3864p
+ AD=0.2128p PS=2.93u PD=1.5u rfmode=0
M$418 VPWR \$I24167 \$2429 VPWR sg13_lv_pmos L=0.13u W=1.12u AS=0.2128p
+ AD=0.3808p PS=1.5u PD=2.92u rfmode=0
M$419 VPWR \$4125 \$I24163 VPWR sg13_lv_pmos L=0.13u W=0.42u AS=0.1428p
+ AD=0.0798p PS=1.52u PD=0.8u rfmode=0
M$420 VPWR \$4124 \$I24163 VPWR sg13_lv_pmos L=0.13u W=0.42u AS=0.3623875p
+ AD=0.0798p PS=2.605u PD=0.8u rfmode=0
M$421 VPWR \$I24168 \$I24161 VPWR sg13_lv_pmos L=0.13u W=1u AS=0.3623875p
+ AD=0.34p PS=2.605u PD=2.68u rfmode=0
M$422 \$I24173 \$I24162 VPWR VPWR sg13_lv_pmos L=0.13u W=1.12u AS=0.3864p
+ AD=0.41165p PS=2.93u PD=2.12u rfmode=0
M$423 VPWR \$3356 \$I24162 VPWR sg13_lv_pmos L=0.13u W=1.12u AS=0.41165p
+ AD=0.4088p PS=2.12u PD=2.97u rfmode=0
M$424 \$I24168 \$4124 VPWR VPWR sg13_lv_pmos L=0.13u W=0.42u AS=0.147p
+ AD=0.1563p PS=1.54u PD=1.22u rfmode=0
M$425 VPWR \$I24161 \$I24174 VPWR sg13_lv_pmos L=0.13u W=0.42u AS=0.1563p
+ AD=0.063p PS=1.22u PD=0.72u rfmode=0
M$426 \$I24174 \$I24162 \$I24168 VPWR sg13_lv_pmos L=0.13u W=0.42u AS=0.063p
+ AD=0.0798p PS=0.72u PD=0.8u rfmode=0
M$427 \$I24168 \$I24173 \$I24163 VPWR sg13_lv_pmos L=0.13u W=0.42u AS=0.0798p
+ AD=0.1428p PS=0.8u PD=1.52u rfmode=0
M$428 VGND \$I24177 \$I24188 VGND sg13_lv_nmos L=0.13u W=0.74u AS=0.317325p
+ AD=0.2516p PS=1.805u PD=2.16u rfmode=0
M$429 VGND \$2375 \$I24177 VGND sg13_lv_nmos L=0.13u W=0.74u AS=0.317325p
+ AD=0.2516p PS=1.805u PD=2.16u rfmode=0
M$430 \$I24184 \$I24177 \$I24180 VGND sg13_lv_nmos L=0.13u W=0.42u AS=0.12665p
+ AD=0.1428p PS=1.145u PD=1.52u rfmode=0
M$431 \$I24176 \$I24188 \$I24184 VGND sg13_lv_nmos L=0.13u W=0.74u AS=0.3473p
+ AD=0.12665p PS=2.71u PD=1.145u rfmode=0
M$432 \$I24178 \$2581 \$I24185 VGND sg13_lv_nmos L=0.13u W=0.42u AS=0.1428p
+ AD=0.0609p PS=1.52u PD=0.71u rfmode=0
M$433 \$I24185 \$2760 VGND VGND sg13_lv_nmos L=0.13u W=0.42u AS=0.0609p
+ AD=0.1626p PS=0.71u PD=1.415u rfmode=0
M$434 VGND \$I24183 \$I24176 VGND sg13_lv_nmos L=0.13u W=0.74u AS=0.1626p
+ AD=0.2516p PS=1.415u PD=2.16u rfmode=0
M$435 \$I24182 \$I24184 VGND VGND sg13_lv_nmos L=0.13u W=0.74u AS=0.2516p
+ AD=0.1406p PS=2.16u PD=1.12u rfmode=0
M$436 VGND \$I24182 \$725 VGND sg13_lv_nmos L=0.13u W=0.74u AS=0.1406p
+ AD=0.2516p PS=1.12u PD=2.16u rfmode=0
M$437 \$I24178 \$I24177 \$I24183 VGND sg13_lv_nmos L=0.13u W=0.42u AS=0.1296p
+ AD=0.0798p PS=1.52u PD=0.8u rfmode=0
M$438 \$I24183 \$I24188 \$I24179 VGND sg13_lv_nmos L=0.13u W=0.42u AS=0.0798p
+ AD=0.2373p PS=0.8u PD=1.97u rfmode=0
M$439 \$I24180 \$I24181 VGND VGND sg13_lv_nmos L=0.13u W=0.42u AS=0.1428p
+ AD=0.0798p PS=1.52u PD=0.8u rfmode=0
M$440 VGND \$2760 \$I24187 VGND sg13_lv_nmos L=0.13u W=0.42u AS=0.0798p
+ AD=0.0378p PS=0.8u PD=0.6u rfmode=0
M$441 \$I24187 \$I24184 \$I24181 VGND sg13_lv_nmos L=0.13u W=0.42u AS=0.0378p
+ AD=0.1428p PS=0.6u PD=1.52u rfmode=0
M$442 VGND \$2760 \$I24186 VGND sg13_lv_nmos L=0.13u W=0.42u AS=0.1701p
+ AD=0.0378p PS=1.65u PD=0.6u rfmode=0
M$443 \$I24186 \$I24176 \$I24179 VGND sg13_lv_nmos L=0.13u W=0.42u AS=0.0378p
+ AD=0.1428p PS=0.6u PD=1.52u rfmode=0
M$444 \$I24184 \$I24188 \$I24190 VPWR sg13_lv_pmos L=0.13u W=0.42u AS=0.2048p
+ AD=0.09345p PS=1.63u PD=0.865u rfmode=0
M$445 \$I24190 \$I24181 VPWR VPWR sg13_lv_pmos L=0.13u W=0.42u AS=0.09345p
+ AD=0.204p PS=0.865u PD=1.835u rfmode=0
M$446 VPWR \$2760 \$I24181 VPWR sg13_lv_pmos L=0.13u W=0.42u AS=0.204p
+ AD=0.0798p PS=1.835u PD=0.8u rfmode=0
M$447 \$I24181 \$I24184 VPWR VPWR sg13_lv_pmos L=0.13u W=0.42u AS=0.0798p
+ AD=0.4659p PS=0.8u PD=3.65u rfmode=0
M$448 \$I24176 \$I24177 \$I24184 VPWR sg13_lv_pmos L=0.13u W=1u AS=0.34p
+ AD=0.2048p PS=2.68u PD=1.63u rfmode=0
M$449 \$I24182 \$I24184 VPWR VPWR sg13_lv_pmos L=0.13u W=1.12u AS=0.3864p
+ AD=0.2128p PS=2.93u PD=1.5u rfmode=0
M$450 VPWR \$I24182 \$725 VPWR sg13_lv_pmos L=0.13u W=1.12u AS=0.2128p
+ AD=0.3808p PS=1.5u PD=2.92u rfmode=0
M$451 VPWR \$2581 \$I24178 VPWR sg13_lv_pmos L=0.13u W=0.42u AS=0.1428p
+ AD=0.0798p PS=1.52u PD=0.8u rfmode=0
M$452 VPWR \$2760 \$I24178 VPWR sg13_lv_pmos L=0.13u W=0.42u AS=0.3623875p
+ AD=0.0798p PS=2.605u PD=0.8u rfmode=0
M$453 VPWR \$I24183 \$I24176 VPWR sg13_lv_pmos L=0.13u W=1u AS=0.3623875p
+ AD=0.34p PS=2.605u PD=2.68u rfmode=0
M$454 \$I24188 \$I24177 VPWR VPWR sg13_lv_pmos L=0.13u W=1.12u AS=0.3864p
+ AD=0.41165p PS=2.93u PD=2.12u rfmode=0
M$455 VPWR \$2375 \$I24177 VPWR sg13_lv_pmos L=0.13u W=1.12u AS=0.41165p
+ AD=0.4088p PS=2.12u PD=2.97u rfmode=0
M$456 \$I24183 \$2760 VPWR VPWR sg13_lv_pmos L=0.13u W=0.42u AS=0.147p
+ AD=0.1563p PS=1.54u PD=1.22u rfmode=0
M$457 VPWR \$I24176 \$I24189 VPWR sg13_lv_pmos L=0.13u W=0.42u AS=0.1563p
+ AD=0.063p PS=1.22u PD=0.72u rfmode=0
M$458 \$I24189 \$I24177 \$I24183 VPWR sg13_lv_pmos L=0.13u W=0.42u AS=0.063p
+ AD=0.0798p PS=0.72u PD=0.8u rfmode=0
M$459 \$I24183 \$I24188 \$I24178 VPWR sg13_lv_pmos L=0.13u W=0.42u AS=0.0798p
+ AD=0.1428p PS=0.8u PD=1.52u rfmode=0
M$460 VGND \$I24192 \$I24203 VGND sg13_lv_nmos L=0.13u W=0.74u AS=0.317325p
+ AD=0.2516p PS=1.805u PD=2.16u rfmode=0
M$461 VGND \$1790 \$I24192 VGND sg13_lv_nmos L=0.13u W=0.74u AS=0.317325p
+ AD=0.2516p PS=1.805u PD=2.16u rfmode=0
M$462 \$I24199 \$I24192 \$I24195 VGND sg13_lv_nmos L=0.13u W=0.42u AS=0.12665p
+ AD=0.1428p PS=1.145u PD=1.52u rfmode=0
M$463 \$I24191 \$I24203 \$I24199 VGND sg13_lv_nmos L=0.13u W=0.74u AS=0.3473p
+ AD=0.12665p PS=2.71u PD=1.145u rfmode=0
M$464 \$I24193 \$2169 \$I24200 VGND sg13_lv_nmos L=0.13u W=0.42u AS=0.1428p
+ AD=0.0609p PS=1.52u PD=0.71u rfmode=0
M$465 \$I24200 \$2291 VGND VGND sg13_lv_nmos L=0.13u W=0.42u AS=0.0609p
+ AD=0.1626p PS=0.71u PD=1.415u rfmode=0
M$466 VGND \$I24198 \$I24191 VGND sg13_lv_nmos L=0.13u W=0.74u AS=0.1626p
+ AD=0.2516p PS=1.415u PD=2.16u rfmode=0
M$467 \$I24197 \$I24199 VGND VGND sg13_lv_nmos L=0.13u W=0.74u AS=0.2516p
+ AD=0.1406p PS=2.16u PD=1.12u rfmode=0
M$468 VGND \$I24197 \$2118 VGND sg13_lv_nmos L=0.13u W=0.74u AS=0.1406p
+ AD=0.2516p PS=1.12u PD=2.16u rfmode=0
M$469 \$I24193 \$I24192 \$I24198 VGND sg13_lv_nmos L=0.13u W=0.42u AS=0.1296p
+ AD=0.0798p PS=1.52u PD=0.8u rfmode=0
M$470 \$I24198 \$I24203 \$I24194 VGND sg13_lv_nmos L=0.13u W=0.42u AS=0.0798p
+ AD=0.2373p PS=0.8u PD=1.97u rfmode=0
M$471 \$I24195 \$I24196 VGND VGND sg13_lv_nmos L=0.13u W=0.42u AS=0.1428p
+ AD=0.0798p PS=1.52u PD=0.8u rfmode=0
M$472 VGND \$2291 \$I24202 VGND sg13_lv_nmos L=0.13u W=0.42u AS=0.0798p
+ AD=0.0378p PS=0.8u PD=0.6u rfmode=0
M$473 \$I24202 \$I24199 \$I24196 VGND sg13_lv_nmos L=0.13u W=0.42u AS=0.0378p
+ AD=0.1428p PS=0.6u PD=1.52u rfmode=0
M$474 VGND \$2291 \$I24201 VGND sg13_lv_nmos L=0.13u W=0.42u AS=0.1701p
+ AD=0.0378p PS=1.65u PD=0.6u rfmode=0
M$475 \$I24201 \$I24191 \$I24194 VGND sg13_lv_nmos L=0.13u W=0.42u AS=0.0378p
+ AD=0.1428p PS=0.6u PD=1.52u rfmode=0
M$476 \$I24199 \$I24203 \$I24205 VPWR sg13_lv_pmos L=0.13u W=0.42u AS=0.2048p
+ AD=0.09345p PS=1.63u PD=0.865u rfmode=0
M$477 \$I24205 \$I24196 VPWR VPWR sg13_lv_pmos L=0.13u W=0.42u AS=0.09345p
+ AD=0.204p PS=0.865u PD=1.835u rfmode=0
M$478 VPWR \$2291 \$I24196 VPWR sg13_lv_pmos L=0.13u W=0.42u AS=0.204p
+ AD=0.0798p PS=1.835u PD=0.8u rfmode=0
M$479 \$I24196 \$I24199 VPWR VPWR sg13_lv_pmos L=0.13u W=0.42u AS=0.0798p
+ AD=0.4659p PS=0.8u PD=3.65u rfmode=0
M$480 \$I24191 \$I24192 \$I24199 VPWR sg13_lv_pmos L=0.13u W=1u AS=0.34p
+ AD=0.2048p PS=2.68u PD=1.63u rfmode=0
M$481 \$I24197 \$I24199 VPWR VPWR sg13_lv_pmos L=0.13u W=1.12u AS=0.3864p
+ AD=0.2128p PS=2.93u PD=1.5u rfmode=0
M$482 VPWR \$I24197 \$2118 VPWR sg13_lv_pmos L=0.13u W=1.12u AS=0.2128p
+ AD=0.3808p PS=1.5u PD=2.92u rfmode=0
M$483 VPWR \$2169 \$I24193 VPWR sg13_lv_pmos L=0.13u W=0.42u AS=0.1428p
+ AD=0.0798p PS=1.52u PD=0.8u rfmode=0
M$484 VPWR \$2291 \$I24193 VPWR sg13_lv_pmos L=0.13u W=0.42u AS=0.3623875p
+ AD=0.0798p PS=2.605u PD=0.8u rfmode=0
M$485 VPWR \$I24198 \$I24191 VPWR sg13_lv_pmos L=0.13u W=1u AS=0.3623875p
+ AD=0.34p PS=2.605u PD=2.68u rfmode=0
M$486 \$I24203 \$I24192 VPWR VPWR sg13_lv_pmos L=0.13u W=1.12u AS=0.3864p
+ AD=0.41165p PS=2.93u PD=2.12u rfmode=0
M$487 VPWR \$1790 \$I24192 VPWR sg13_lv_pmos L=0.13u W=1.12u AS=0.41165p
+ AD=0.4088p PS=2.12u PD=2.97u rfmode=0
M$488 \$I24198 \$2291 VPWR VPWR sg13_lv_pmos L=0.13u W=0.42u AS=0.147p
+ AD=0.1563p PS=1.54u PD=1.22u rfmode=0
M$489 VPWR \$I24191 \$I24204 VPWR sg13_lv_pmos L=0.13u W=0.42u AS=0.1563p
+ AD=0.063p PS=1.22u PD=0.72u rfmode=0
M$490 \$I24204 \$I24192 \$I24198 VPWR sg13_lv_pmos L=0.13u W=0.42u AS=0.063p
+ AD=0.0798p PS=0.72u PD=0.8u rfmode=0
M$491 \$I24198 \$I24203 \$I24193 VPWR sg13_lv_pmos L=0.13u W=0.42u AS=0.0798p
+ AD=0.1428p PS=0.8u PD=1.52u rfmode=0
M$492 VGND \$I24207 \$I24218 VGND sg13_lv_nmos L=0.13u W=0.74u AS=0.317325p
+ AD=0.2516p PS=1.805u PD=2.16u rfmode=0
M$493 VGND \$1790 \$I24207 VGND sg13_lv_nmos L=0.13u W=0.74u AS=0.317325p
+ AD=0.2516p PS=1.805u PD=2.16u rfmode=0
M$494 \$I24214 \$I24207 \$I24210 VGND sg13_lv_nmos L=0.13u W=0.42u AS=0.12665p
+ AD=0.1428p PS=1.145u PD=1.52u rfmode=0
M$495 \$I24206 \$I24218 \$I24214 VGND sg13_lv_nmos L=0.13u W=0.74u AS=0.3473p
+ AD=0.12665p PS=2.71u PD=1.145u rfmode=0
M$496 \$I24208 \$1886 \$I24215 VGND sg13_lv_nmos L=0.13u W=0.42u AS=0.1428p
+ AD=0.0609p PS=1.52u PD=0.71u rfmode=0
M$497 \$I24215 \$1944 VGND VGND sg13_lv_nmos L=0.13u W=0.42u AS=0.0609p
+ AD=0.1626p PS=0.71u PD=1.415u rfmode=0
M$498 VGND \$I24213 \$I24206 VGND sg13_lv_nmos L=0.13u W=0.74u AS=0.1626p
+ AD=0.2516p PS=1.415u PD=2.16u rfmode=0
M$499 \$I24212 \$I24214 VGND VGND sg13_lv_nmos L=0.13u W=0.74u AS=0.2516p
+ AD=0.1406p PS=2.16u PD=1.12u rfmode=0
M$500 VGND \$I24212 \$1689 VGND sg13_lv_nmos L=0.13u W=0.74u AS=0.1406p
+ AD=0.2516p PS=1.12u PD=2.16u rfmode=0
M$501 \$I24208 \$I24207 \$I24213 VGND sg13_lv_nmos L=0.13u W=0.42u AS=0.1296p
+ AD=0.0798p PS=1.52u PD=0.8u rfmode=0
M$502 \$I24213 \$I24218 \$I24209 VGND sg13_lv_nmos L=0.13u W=0.42u AS=0.0798p
+ AD=0.2373p PS=0.8u PD=1.97u rfmode=0
M$503 \$I24210 \$I24211 VGND VGND sg13_lv_nmos L=0.13u W=0.42u AS=0.1428p
+ AD=0.0798p PS=1.52u PD=0.8u rfmode=0
M$504 VGND \$1944 \$I24217 VGND sg13_lv_nmos L=0.13u W=0.42u AS=0.0798p
+ AD=0.0378p PS=0.8u PD=0.6u rfmode=0
M$505 \$I24217 \$I24214 \$I24211 VGND sg13_lv_nmos L=0.13u W=0.42u AS=0.0378p
+ AD=0.1428p PS=0.6u PD=1.52u rfmode=0
M$506 VGND \$1944 \$I24216 VGND sg13_lv_nmos L=0.13u W=0.42u AS=0.1701p
+ AD=0.0378p PS=1.65u PD=0.6u rfmode=0
M$507 \$I24216 \$I24206 \$I24209 VGND sg13_lv_nmos L=0.13u W=0.42u AS=0.0378p
+ AD=0.1428p PS=0.6u PD=1.52u rfmode=0
M$508 \$I24214 \$I24218 \$I24220 VPWR sg13_lv_pmos L=0.13u W=0.42u AS=0.2048p
+ AD=0.09345p PS=1.63u PD=0.865u rfmode=0
M$509 \$I24220 \$I24211 VPWR VPWR sg13_lv_pmos L=0.13u W=0.42u AS=0.09345p
+ AD=0.204p PS=0.865u PD=1.835u rfmode=0
M$510 VPWR \$1944 \$I24211 VPWR sg13_lv_pmos L=0.13u W=0.42u AS=0.204p
+ AD=0.0798p PS=1.835u PD=0.8u rfmode=0
M$511 \$I24211 \$I24214 VPWR VPWR sg13_lv_pmos L=0.13u W=0.42u AS=0.0798p
+ AD=0.4659p PS=0.8u PD=3.65u rfmode=0
M$512 \$I24206 \$I24207 \$I24214 VPWR sg13_lv_pmos L=0.13u W=1u AS=0.34p
+ AD=0.2048p PS=2.68u PD=1.63u rfmode=0
M$513 \$I24212 \$I24214 VPWR VPWR sg13_lv_pmos L=0.13u W=1.12u AS=0.3864p
+ AD=0.2128p PS=2.93u PD=1.5u rfmode=0
M$514 VPWR \$I24212 \$1689 VPWR sg13_lv_pmos L=0.13u W=1.12u AS=0.2128p
+ AD=0.3808p PS=1.5u PD=2.92u rfmode=0
M$515 VPWR \$1886 \$I24208 VPWR sg13_lv_pmos L=0.13u W=0.42u AS=0.1428p
+ AD=0.0798p PS=1.52u PD=0.8u rfmode=0
M$516 VPWR \$1944 \$I24208 VPWR sg13_lv_pmos L=0.13u W=0.42u AS=0.3623875p
+ AD=0.0798p PS=2.605u PD=0.8u rfmode=0
M$517 VPWR \$I24213 \$I24206 VPWR sg13_lv_pmos L=0.13u W=1u AS=0.3623875p
+ AD=0.34p PS=2.605u PD=2.68u rfmode=0
M$518 \$I24218 \$I24207 VPWR VPWR sg13_lv_pmos L=0.13u W=1.12u AS=0.3864p
+ AD=0.41165p PS=2.93u PD=2.12u rfmode=0
M$519 VPWR \$1790 \$I24207 VPWR sg13_lv_pmos L=0.13u W=1.12u AS=0.41165p
+ AD=0.4088p PS=2.12u PD=2.97u rfmode=0
M$520 \$I24213 \$1944 VPWR VPWR sg13_lv_pmos L=0.13u W=0.42u AS=0.147p
+ AD=0.1563p PS=1.54u PD=1.22u rfmode=0
M$521 VPWR \$I24206 \$I24219 VPWR sg13_lv_pmos L=0.13u W=0.42u AS=0.1563p
+ AD=0.063p PS=1.22u PD=0.72u rfmode=0
M$522 \$I24219 \$I24207 \$I24213 VPWR sg13_lv_pmos L=0.13u W=0.42u AS=0.063p
+ AD=0.0798p PS=0.72u PD=0.8u rfmode=0
M$523 \$I24213 \$I24218 \$I24208 VPWR sg13_lv_pmos L=0.13u W=0.42u AS=0.0798p
+ AD=0.1428p PS=0.8u PD=1.52u rfmode=0
M$524 VGND \$I24222 \$I24233 VGND sg13_lv_nmos L=0.13u W=0.74u AS=0.317325p
+ AD=0.2516p PS=1.805u PD=2.16u rfmode=0
M$525 VGND \$3356 \$I24222 VGND sg13_lv_nmos L=0.13u W=0.74u AS=0.317325p
+ AD=0.2516p PS=1.805u PD=2.16u rfmode=0
M$526 \$I24229 \$I24222 \$I24225 VGND sg13_lv_nmos L=0.13u W=0.42u AS=0.12665p
+ AD=0.1428p PS=1.145u PD=1.52u rfmode=0
M$527 \$I24221 \$I24233 \$I24229 VGND sg13_lv_nmos L=0.13u W=0.74u AS=0.3473p
+ AD=0.12665p PS=2.71u PD=1.145u rfmode=0
M$528 \$I24223 \$4525 \$I24230 VGND sg13_lv_nmos L=0.13u W=0.42u AS=0.1428p
+ AD=0.0609p PS=1.52u PD=0.71u rfmode=0
M$529 \$I24230 \$4229 VGND VGND sg13_lv_nmos L=0.13u W=0.42u AS=0.0609p
+ AD=0.1626p PS=0.71u PD=1.415u rfmode=0
M$530 VGND \$I24228 \$I24221 VGND sg13_lv_nmos L=0.13u W=0.74u AS=0.1626p
+ AD=0.2516p PS=1.415u PD=2.16u rfmode=0
M$531 \$I24227 \$I24229 VGND VGND sg13_lv_nmos L=0.13u W=0.74u AS=0.2516p
+ AD=0.1406p PS=2.16u PD=1.12u rfmode=0
M$532 VGND \$I24227 \$4230 VGND sg13_lv_nmos L=0.13u W=0.74u AS=0.1406p
+ AD=0.2516p PS=1.12u PD=2.16u rfmode=0
M$533 \$I24223 \$I24222 \$I24228 VGND sg13_lv_nmos L=0.13u W=0.42u AS=0.1296p
+ AD=0.0798p PS=1.52u PD=0.8u rfmode=0
M$534 \$I24228 \$I24233 \$I24224 VGND sg13_lv_nmos L=0.13u W=0.42u AS=0.0798p
+ AD=0.2373p PS=0.8u PD=1.97u rfmode=0
M$535 \$I24225 \$I24226 VGND VGND sg13_lv_nmos L=0.13u W=0.42u AS=0.1428p
+ AD=0.0798p PS=1.52u PD=0.8u rfmode=0
M$536 VGND \$4229 \$I24232 VGND sg13_lv_nmos L=0.13u W=0.42u AS=0.0798p
+ AD=0.0378p PS=0.8u PD=0.6u rfmode=0
M$537 \$I24232 \$I24229 \$I24226 VGND sg13_lv_nmos L=0.13u W=0.42u AS=0.0378p
+ AD=0.1428p PS=0.6u PD=1.52u rfmode=0
M$538 VGND \$4229 \$I24231 VGND sg13_lv_nmos L=0.13u W=0.42u AS=0.1701p
+ AD=0.0378p PS=1.65u PD=0.6u rfmode=0
M$539 \$I24231 \$I24221 \$I24224 VGND sg13_lv_nmos L=0.13u W=0.42u AS=0.0378p
+ AD=0.1428p PS=0.6u PD=1.52u rfmode=0
M$540 \$I24229 \$I24233 \$I24235 VPWR sg13_lv_pmos L=0.13u W=0.42u AS=0.2048p
+ AD=0.09345p PS=1.63u PD=0.865u rfmode=0
M$541 \$I24235 \$I24226 VPWR VPWR sg13_lv_pmos L=0.13u W=0.42u AS=0.09345p
+ AD=0.204p PS=0.865u PD=1.835u rfmode=0
M$542 VPWR \$4229 \$I24226 VPWR sg13_lv_pmos L=0.13u W=0.42u AS=0.204p
+ AD=0.0798p PS=1.835u PD=0.8u rfmode=0
M$543 \$I24226 \$I24229 VPWR VPWR sg13_lv_pmos L=0.13u W=0.42u AS=0.0798p
+ AD=0.4659p PS=0.8u PD=3.65u rfmode=0
M$544 \$I24221 \$I24222 \$I24229 VPWR sg13_lv_pmos L=0.13u W=1u AS=0.34p
+ AD=0.2048p PS=2.68u PD=1.63u rfmode=0
M$545 \$I24227 \$I24229 VPWR VPWR sg13_lv_pmos L=0.13u W=1.12u AS=0.3864p
+ AD=0.2128p PS=2.93u PD=1.5u rfmode=0
M$546 VPWR \$I24227 \$4230 VPWR sg13_lv_pmos L=0.13u W=1.12u AS=0.2128p
+ AD=0.3808p PS=1.5u PD=2.92u rfmode=0
M$547 VPWR \$4525 \$I24223 VPWR sg13_lv_pmos L=0.13u W=0.42u AS=0.1428p
+ AD=0.0798p PS=1.52u PD=0.8u rfmode=0
M$548 VPWR \$4229 \$I24223 VPWR sg13_lv_pmos L=0.13u W=0.42u AS=0.3623875p
+ AD=0.0798p PS=2.605u PD=0.8u rfmode=0
M$549 VPWR \$I24228 \$I24221 VPWR sg13_lv_pmos L=0.13u W=1u AS=0.3623875p
+ AD=0.34p PS=2.605u PD=2.68u rfmode=0
M$550 \$I24233 \$I24222 VPWR VPWR sg13_lv_pmos L=0.13u W=1.12u AS=0.3864p
+ AD=0.41165p PS=2.93u PD=2.12u rfmode=0
M$551 VPWR \$3356 \$I24222 VPWR sg13_lv_pmos L=0.13u W=1.12u AS=0.41165p
+ AD=0.4088p PS=2.12u PD=2.97u rfmode=0
M$552 \$I24228 \$4229 VPWR VPWR sg13_lv_pmos L=0.13u W=0.42u AS=0.147p
+ AD=0.1563p PS=1.54u PD=1.22u rfmode=0
M$553 VPWR \$I24221 \$I24234 VPWR sg13_lv_pmos L=0.13u W=0.42u AS=0.1563p
+ AD=0.063p PS=1.22u PD=0.72u rfmode=0
M$554 \$I24234 \$I24222 \$I24228 VPWR sg13_lv_pmos L=0.13u W=0.42u AS=0.063p
+ AD=0.0798p PS=0.72u PD=0.8u rfmode=0
M$555 \$I24228 \$I24233 \$I24223 VPWR sg13_lv_pmos L=0.13u W=0.42u AS=0.0798p
+ AD=0.1428p PS=0.8u PD=1.52u rfmode=0
M$556 VGND \$I24237 \$I24248 VGND sg13_lv_nmos L=0.13u W=0.74u AS=0.317325p
+ AD=0.2516p PS=1.805u PD=2.16u rfmode=0
M$557 VGND \$1878 \$I24237 VGND sg13_lv_nmos L=0.13u W=0.74u AS=0.317325p
+ AD=0.2516p PS=1.805u PD=2.16u rfmode=0
M$558 \$I24244 \$I24237 \$I24240 VGND sg13_lv_nmos L=0.13u W=0.42u AS=0.12665p
+ AD=0.1428p PS=1.145u PD=1.52u rfmode=0
M$559 \$I24236 \$I24248 \$I24244 VGND sg13_lv_nmos L=0.13u W=0.74u AS=0.3473p
+ AD=0.12665p PS=2.71u PD=1.145u rfmode=0
M$560 \$I24238 \$1929 \$I24245 VGND sg13_lv_nmos L=0.13u W=0.42u AS=0.1428p
+ AD=0.0609p PS=1.52u PD=0.71u rfmode=0
M$561 \$I24245 \$2014 VGND VGND sg13_lv_nmos L=0.13u W=0.42u AS=0.0609p
+ AD=0.1626p PS=0.71u PD=1.415u rfmode=0
M$562 VGND \$I24243 \$I24236 VGND sg13_lv_nmos L=0.13u W=0.74u AS=0.1626p
+ AD=0.2516p PS=1.415u PD=2.16u rfmode=0
M$563 \$I24242 \$I24244 VGND VGND sg13_lv_nmos L=0.13u W=0.74u AS=0.2516p
+ AD=0.1406p PS=2.16u PD=1.12u rfmode=0
M$564 VGND \$I24242 \$1783 VGND sg13_lv_nmos L=0.13u W=0.74u AS=0.1406p
+ AD=0.2516p PS=1.12u PD=2.16u rfmode=0
M$565 \$I24238 \$I24237 \$I24243 VGND sg13_lv_nmos L=0.13u W=0.42u AS=0.1296p
+ AD=0.0798p PS=1.52u PD=0.8u rfmode=0
M$566 \$I24243 \$I24248 \$I24239 VGND sg13_lv_nmos L=0.13u W=0.42u AS=0.0798p
+ AD=0.2373p PS=0.8u PD=1.97u rfmode=0
M$567 \$I24240 \$I24241 VGND VGND sg13_lv_nmos L=0.13u W=0.42u AS=0.1428p
+ AD=0.0798p PS=1.52u PD=0.8u rfmode=0
M$568 VGND \$2014 \$I24247 VGND sg13_lv_nmos L=0.13u W=0.42u AS=0.0798p
+ AD=0.0378p PS=0.8u PD=0.6u rfmode=0
M$569 \$I24247 \$I24244 \$I24241 VGND sg13_lv_nmos L=0.13u W=0.42u AS=0.0378p
+ AD=0.1428p PS=0.6u PD=1.52u rfmode=0
M$570 VGND \$2014 \$I24246 VGND sg13_lv_nmos L=0.13u W=0.42u AS=0.1701p
+ AD=0.0378p PS=1.65u PD=0.6u rfmode=0
M$571 \$I24246 \$I24236 \$I24239 VGND sg13_lv_nmos L=0.13u W=0.42u AS=0.0378p
+ AD=0.1428p PS=0.6u PD=1.52u rfmode=0
M$572 \$I24244 \$I24248 \$I24250 VPWR sg13_lv_pmos L=0.13u W=0.42u AS=0.2048p
+ AD=0.09345p PS=1.63u PD=0.865u rfmode=0
M$573 \$I24250 \$I24241 VPWR VPWR sg13_lv_pmos L=0.13u W=0.42u AS=0.09345p
+ AD=0.204p PS=0.865u PD=1.835u rfmode=0
M$574 VPWR \$2014 \$I24241 VPWR sg13_lv_pmos L=0.13u W=0.42u AS=0.204p
+ AD=0.0798p PS=1.835u PD=0.8u rfmode=0
M$575 \$I24241 \$I24244 VPWR VPWR sg13_lv_pmos L=0.13u W=0.42u AS=0.0798p
+ AD=0.4659p PS=0.8u PD=3.65u rfmode=0
M$576 \$I24236 \$I24237 \$I24244 VPWR sg13_lv_pmos L=0.13u W=1u AS=0.34p
+ AD=0.2048p PS=2.68u PD=1.63u rfmode=0
M$577 \$I24242 \$I24244 VPWR VPWR sg13_lv_pmos L=0.13u W=1.12u AS=0.3864p
+ AD=0.2128p PS=2.93u PD=1.5u rfmode=0
M$578 VPWR \$I24242 \$1783 VPWR sg13_lv_pmos L=0.13u W=1.12u AS=0.2128p
+ AD=0.3808p PS=1.5u PD=2.92u rfmode=0
M$579 VPWR \$1929 \$I24238 VPWR sg13_lv_pmos L=0.13u W=0.42u AS=0.1428p
+ AD=0.0798p PS=1.52u PD=0.8u rfmode=0
M$580 VPWR \$2014 \$I24238 VPWR sg13_lv_pmos L=0.13u W=0.42u AS=0.3623875p
+ AD=0.0798p PS=2.605u PD=0.8u rfmode=0
M$581 VPWR \$I24243 \$I24236 VPWR sg13_lv_pmos L=0.13u W=1u AS=0.3623875p
+ AD=0.34p PS=2.605u PD=2.68u rfmode=0
M$582 \$I24248 \$I24237 VPWR VPWR sg13_lv_pmos L=0.13u W=1.12u AS=0.3864p
+ AD=0.41165p PS=2.93u PD=2.12u rfmode=0
M$583 VPWR \$1878 \$I24237 VPWR sg13_lv_pmos L=0.13u W=1.12u AS=0.41165p
+ AD=0.4088p PS=2.12u PD=2.97u rfmode=0
M$584 \$I24243 \$2014 VPWR VPWR sg13_lv_pmos L=0.13u W=0.42u AS=0.147p
+ AD=0.1563p PS=1.54u PD=1.22u rfmode=0
M$585 VPWR \$I24236 \$I24249 VPWR sg13_lv_pmos L=0.13u W=0.42u AS=0.1563p
+ AD=0.063p PS=1.22u PD=0.72u rfmode=0
M$586 \$I24249 \$I24237 \$I24243 VPWR sg13_lv_pmos L=0.13u W=0.42u AS=0.063p
+ AD=0.0798p PS=0.72u PD=0.8u rfmode=0
M$587 \$I24243 \$I24248 \$I24238 VPWR sg13_lv_pmos L=0.13u W=0.42u AS=0.0798p
+ AD=0.1428p PS=0.8u PD=1.52u rfmode=0
M$588 VGND \$I24252 \$I24263 VGND sg13_lv_nmos L=0.13u W=0.74u AS=0.317325p
+ AD=0.2516p PS=1.805u PD=2.16u rfmode=0
M$589 VGND \$2375 \$I24252 VGND sg13_lv_nmos L=0.13u W=0.74u AS=0.317325p
+ AD=0.2516p PS=1.805u PD=2.16u rfmode=0
M$590 \$I24259 \$I24252 \$I24255 VGND sg13_lv_nmos L=0.13u W=0.42u AS=0.12665p
+ AD=0.1428p PS=1.145u PD=1.52u rfmode=0
M$591 \$I24251 \$I24263 \$I24259 VGND sg13_lv_nmos L=0.13u W=0.74u AS=0.3473p
+ AD=0.12665p PS=2.71u PD=1.145u rfmode=0
M$592 \$I24253 \$2947 \$I24260 VGND sg13_lv_nmos L=0.13u W=0.42u AS=0.1428p
+ AD=0.0609p PS=1.52u PD=0.71u rfmode=0
M$593 \$I24260 \$2759 VGND VGND sg13_lv_nmos L=0.13u W=0.42u AS=0.0609p
+ AD=0.1626p PS=0.71u PD=1.415u rfmode=0
M$594 VGND \$I24258 \$I24251 VGND sg13_lv_nmos L=0.13u W=0.74u AS=0.1626p
+ AD=0.2516p PS=1.415u PD=2.16u rfmode=0
M$595 \$I24257 \$I24259 VGND VGND sg13_lv_nmos L=0.13u W=0.74u AS=0.2516p
+ AD=0.1406p PS=2.16u PD=1.12u rfmode=0
M$596 VGND \$I24257 \$2628 VGND sg13_lv_nmos L=0.13u W=0.74u AS=0.1406p
+ AD=0.2516p PS=1.12u PD=2.16u rfmode=0
M$597 \$I24253 \$I24252 \$I24258 VGND sg13_lv_nmos L=0.13u W=0.42u AS=0.1296p
+ AD=0.0798p PS=1.52u PD=0.8u rfmode=0
M$598 \$I24258 \$I24263 \$I24254 VGND sg13_lv_nmos L=0.13u W=0.42u AS=0.0798p
+ AD=0.2373p PS=0.8u PD=1.97u rfmode=0
M$599 \$I24255 \$I24256 VGND VGND sg13_lv_nmos L=0.13u W=0.42u AS=0.1428p
+ AD=0.0798p PS=1.52u PD=0.8u rfmode=0
M$600 VGND \$2759 \$I24262 VGND sg13_lv_nmos L=0.13u W=0.42u AS=0.0798p
+ AD=0.0378p PS=0.8u PD=0.6u rfmode=0
M$601 \$I24262 \$I24259 \$I24256 VGND sg13_lv_nmos L=0.13u W=0.42u AS=0.0378p
+ AD=0.1428p PS=0.6u PD=1.52u rfmode=0
M$602 VGND \$2759 \$I24261 VGND sg13_lv_nmos L=0.13u W=0.42u AS=0.1701p
+ AD=0.0378p PS=1.65u PD=0.6u rfmode=0
M$603 \$I24261 \$I24251 \$I24254 VGND sg13_lv_nmos L=0.13u W=0.42u AS=0.0378p
+ AD=0.1428p PS=0.6u PD=1.52u rfmode=0
M$604 \$I24259 \$I24263 \$I24265 VPWR sg13_lv_pmos L=0.13u W=0.42u AS=0.2048p
+ AD=0.09345p PS=1.63u PD=0.865u rfmode=0
M$605 \$I24265 \$I24256 VPWR VPWR sg13_lv_pmos L=0.13u W=0.42u AS=0.09345p
+ AD=0.204p PS=0.865u PD=1.835u rfmode=0
M$606 VPWR \$2759 \$I24256 VPWR sg13_lv_pmos L=0.13u W=0.42u AS=0.204p
+ AD=0.0798p PS=1.835u PD=0.8u rfmode=0
M$607 \$I24256 \$I24259 VPWR VPWR sg13_lv_pmos L=0.13u W=0.42u AS=0.0798p
+ AD=0.4659p PS=0.8u PD=3.65u rfmode=0
M$608 \$I24251 \$I24252 \$I24259 VPWR sg13_lv_pmos L=0.13u W=1u AS=0.34p
+ AD=0.2048p PS=2.68u PD=1.63u rfmode=0
M$609 \$I24257 \$I24259 VPWR VPWR sg13_lv_pmos L=0.13u W=1.12u AS=0.3864p
+ AD=0.2128p PS=2.93u PD=1.5u rfmode=0
M$610 VPWR \$I24257 \$2628 VPWR sg13_lv_pmos L=0.13u W=1.12u AS=0.2128p
+ AD=0.3808p PS=1.5u PD=2.92u rfmode=0
M$611 VPWR \$2947 \$I24253 VPWR sg13_lv_pmos L=0.13u W=0.42u AS=0.1428p
+ AD=0.0798p PS=1.52u PD=0.8u rfmode=0
M$612 VPWR \$2759 \$I24253 VPWR sg13_lv_pmos L=0.13u W=0.42u AS=0.3623875p
+ AD=0.0798p PS=2.605u PD=0.8u rfmode=0
M$613 VPWR \$I24258 \$I24251 VPWR sg13_lv_pmos L=0.13u W=1u AS=0.3623875p
+ AD=0.34p PS=2.605u PD=2.68u rfmode=0
M$614 \$I24263 \$I24252 VPWR VPWR sg13_lv_pmos L=0.13u W=1.12u AS=0.3864p
+ AD=0.41165p PS=2.93u PD=2.12u rfmode=0
M$615 VPWR \$2375 \$I24252 VPWR sg13_lv_pmos L=0.13u W=1.12u AS=0.41165p
+ AD=0.4088p PS=2.12u PD=2.97u rfmode=0
M$616 \$I24258 \$2759 VPWR VPWR sg13_lv_pmos L=0.13u W=0.42u AS=0.147p
+ AD=0.1563p PS=1.54u PD=1.22u rfmode=0
M$617 VPWR \$I24251 \$I24264 VPWR sg13_lv_pmos L=0.13u W=0.42u AS=0.1563p
+ AD=0.063p PS=1.22u PD=0.72u rfmode=0
M$618 \$I24264 \$I24252 \$I24258 VPWR sg13_lv_pmos L=0.13u W=0.42u AS=0.063p
+ AD=0.0798p PS=0.72u PD=0.8u rfmode=0
M$619 \$I24258 \$I24263 \$I24253 VPWR sg13_lv_pmos L=0.13u W=0.42u AS=0.0798p
+ AD=0.1428p PS=0.8u PD=1.52u rfmode=0
M$620 VGND \$I24267 \$I24278 VGND sg13_lv_nmos L=0.13u W=0.74u AS=0.317325p
+ AD=0.2516p PS=1.805u PD=2.16u rfmode=0
M$621 VGND \$3356 \$I24267 VGND sg13_lv_nmos L=0.13u W=0.74u AS=0.317325p
+ AD=0.2516p PS=1.805u PD=2.16u rfmode=0
M$622 \$I24274 \$I24267 \$I24270 VGND sg13_lv_nmos L=0.13u W=0.42u AS=0.12665p
+ AD=0.1428p PS=1.145u PD=1.52u rfmode=0
M$623 \$I24266 \$I24278 \$I24274 VGND sg13_lv_nmos L=0.13u W=0.74u AS=0.3473p
+ AD=0.12665p PS=2.71u PD=1.145u rfmode=0
M$624 \$I24268 \$3527 \$I24275 VGND sg13_lv_nmos L=0.13u W=0.42u AS=0.1428p
+ AD=0.0609p PS=1.52u PD=0.71u rfmode=0
M$625 \$I24275 \$3470 VGND VGND sg13_lv_nmos L=0.13u W=0.42u AS=0.0609p
+ AD=0.1626p PS=0.71u PD=1.415u rfmode=0
M$626 VGND \$I24273 \$I24266 VGND sg13_lv_nmos L=0.13u W=0.74u AS=0.1626p
+ AD=0.2516p PS=1.415u PD=2.16u rfmode=0
M$627 \$I24272 \$I24274 VGND VGND sg13_lv_nmos L=0.13u W=0.74u AS=0.2516p
+ AD=0.1406p PS=2.16u PD=1.12u rfmode=0
M$628 VGND \$I24272 \$3177 VGND sg13_lv_nmos L=0.13u W=0.74u AS=0.1406p
+ AD=0.2516p PS=1.12u PD=2.16u rfmode=0
M$629 \$I24268 \$I24267 \$I24273 VGND sg13_lv_nmos L=0.13u W=0.42u AS=0.1296p
+ AD=0.0798p PS=1.52u PD=0.8u rfmode=0
M$630 \$I24273 \$I24278 \$I24269 VGND sg13_lv_nmos L=0.13u W=0.42u AS=0.0798p
+ AD=0.2373p PS=0.8u PD=1.97u rfmode=0
M$631 \$I24270 \$I24271 VGND VGND sg13_lv_nmos L=0.13u W=0.42u AS=0.1428p
+ AD=0.0798p PS=1.52u PD=0.8u rfmode=0
M$632 VGND \$3470 \$I24277 VGND sg13_lv_nmos L=0.13u W=0.42u AS=0.0798p
+ AD=0.0378p PS=0.8u PD=0.6u rfmode=0
M$633 \$I24277 \$I24274 \$I24271 VGND sg13_lv_nmos L=0.13u W=0.42u AS=0.0378p
+ AD=0.1428p PS=0.6u PD=1.52u rfmode=0
M$634 VGND \$3470 \$I24276 VGND sg13_lv_nmos L=0.13u W=0.42u AS=0.1701p
+ AD=0.0378p PS=1.65u PD=0.6u rfmode=0
M$635 \$I24276 \$I24266 \$I24269 VGND sg13_lv_nmos L=0.13u W=0.42u AS=0.0378p
+ AD=0.1428p PS=0.6u PD=1.52u rfmode=0
M$636 \$I24274 \$I24278 \$I24280 VPWR sg13_lv_pmos L=0.13u W=0.42u AS=0.2048p
+ AD=0.09345p PS=1.63u PD=0.865u rfmode=0
M$637 \$I24280 \$I24271 VPWR VPWR sg13_lv_pmos L=0.13u W=0.42u AS=0.09345p
+ AD=0.204p PS=0.865u PD=1.835u rfmode=0
M$638 VPWR \$3470 \$I24271 VPWR sg13_lv_pmos L=0.13u W=0.42u AS=0.204p
+ AD=0.0798p PS=1.835u PD=0.8u rfmode=0
M$639 \$I24271 \$I24274 VPWR VPWR sg13_lv_pmos L=0.13u W=0.42u AS=0.0798p
+ AD=0.4659p PS=0.8u PD=3.65u rfmode=0
M$640 \$I24266 \$I24267 \$I24274 VPWR sg13_lv_pmos L=0.13u W=1u AS=0.34p
+ AD=0.2048p PS=2.68u PD=1.63u rfmode=0
M$641 \$I24272 \$I24274 VPWR VPWR sg13_lv_pmos L=0.13u W=1.12u AS=0.3864p
+ AD=0.2128p PS=2.93u PD=1.5u rfmode=0
M$642 VPWR \$I24272 \$3177 VPWR sg13_lv_pmos L=0.13u W=1.12u AS=0.2128p
+ AD=0.3808p PS=1.5u PD=2.92u rfmode=0
M$643 VPWR \$3527 \$I24268 VPWR sg13_lv_pmos L=0.13u W=0.42u AS=0.1428p
+ AD=0.0798p PS=1.52u PD=0.8u rfmode=0
M$644 VPWR \$3470 \$I24268 VPWR sg13_lv_pmos L=0.13u W=0.42u AS=0.3623875p
+ AD=0.0798p PS=2.605u PD=0.8u rfmode=0
M$645 VPWR \$I24273 \$I24266 VPWR sg13_lv_pmos L=0.13u W=1u AS=0.3623875p
+ AD=0.34p PS=2.605u PD=2.68u rfmode=0
M$646 \$I24278 \$I24267 VPWR VPWR sg13_lv_pmos L=0.13u W=1.12u AS=0.3864p
+ AD=0.41165p PS=2.93u PD=2.12u rfmode=0
M$647 VPWR \$3356 \$I24267 VPWR sg13_lv_pmos L=0.13u W=1.12u AS=0.41165p
+ AD=0.4088p PS=2.12u PD=2.97u rfmode=0
M$648 \$I24273 \$3470 VPWR VPWR sg13_lv_pmos L=0.13u W=0.42u AS=0.147p
+ AD=0.1563p PS=1.54u PD=1.22u rfmode=0
M$649 VPWR \$I24266 \$I24279 VPWR sg13_lv_pmos L=0.13u W=0.42u AS=0.1563p
+ AD=0.063p PS=1.22u PD=0.72u rfmode=0
M$650 \$I24279 \$I24267 \$I24273 VPWR sg13_lv_pmos L=0.13u W=0.42u AS=0.063p
+ AD=0.0798p PS=0.72u PD=0.8u rfmode=0
M$651 \$I24273 \$I24278 \$I24268 VPWR sg13_lv_pmos L=0.13u W=0.42u AS=0.0798p
+ AD=0.1428p PS=0.8u PD=1.52u rfmode=0
M$652 VGND \$I24282 \$I24293 VGND sg13_lv_nmos L=0.13u W=0.74u AS=0.317325p
+ AD=0.2516p PS=1.805u PD=2.16u rfmode=0
M$653 VGND \$1790 \$I24282 VGND sg13_lv_nmos L=0.13u W=0.74u AS=0.317325p
+ AD=0.2516p PS=1.805u PD=2.16u rfmode=0
M$654 \$I24289 \$I24282 \$I24285 VGND sg13_lv_nmos L=0.13u W=0.42u AS=0.12665p
+ AD=0.1428p PS=1.145u PD=1.52u rfmode=0
M$655 \$I24281 \$I24293 \$I24289 VGND sg13_lv_nmos L=0.13u W=0.74u AS=0.3473p
+ AD=0.12665p PS=2.71u PD=1.145u rfmode=0
M$656 \$I24283 \$2066 \$I24290 VGND sg13_lv_nmos L=0.13u W=0.42u AS=0.1428p
+ AD=0.0609p PS=1.52u PD=0.71u rfmode=0
M$657 \$I24290 \$2022 VGND VGND sg13_lv_nmos L=0.13u W=0.42u AS=0.0609p
+ AD=0.1626p PS=0.71u PD=1.415u rfmode=0
M$658 VGND \$I24288 \$I24281 VGND sg13_lv_nmos L=0.13u W=0.74u AS=0.1626p
+ AD=0.2516p PS=1.415u PD=2.16u rfmode=0
M$659 \$I24287 \$I24289 VGND VGND sg13_lv_nmos L=0.13u W=0.74u AS=0.2516p
+ AD=0.1406p PS=2.16u PD=1.12u rfmode=0
M$660 VGND \$I24287 \$2112 VGND sg13_lv_nmos L=0.13u W=0.74u AS=0.1406p
+ AD=0.2516p PS=1.12u PD=2.16u rfmode=0
M$661 \$I24283 \$I24282 \$I24288 VGND sg13_lv_nmos L=0.13u W=0.42u AS=0.1296p
+ AD=0.0798p PS=1.52u PD=0.8u rfmode=0
M$662 \$I24288 \$I24293 \$I24284 VGND sg13_lv_nmos L=0.13u W=0.42u AS=0.0798p
+ AD=0.2373p PS=0.8u PD=1.97u rfmode=0
M$663 \$I24285 \$I24286 VGND VGND sg13_lv_nmos L=0.13u W=0.42u AS=0.1428p
+ AD=0.0798p PS=1.52u PD=0.8u rfmode=0
M$664 VGND \$2022 \$I24292 VGND sg13_lv_nmos L=0.13u W=0.42u AS=0.0798p
+ AD=0.0378p PS=0.8u PD=0.6u rfmode=0
M$665 \$I24292 \$I24289 \$I24286 VGND sg13_lv_nmos L=0.13u W=0.42u AS=0.0378p
+ AD=0.1428p PS=0.6u PD=1.52u rfmode=0
M$666 VGND \$2022 \$I24291 VGND sg13_lv_nmos L=0.13u W=0.42u AS=0.1701p
+ AD=0.0378p PS=1.65u PD=0.6u rfmode=0
M$667 \$I24291 \$I24281 \$I24284 VGND sg13_lv_nmos L=0.13u W=0.42u AS=0.0378p
+ AD=0.1428p PS=0.6u PD=1.52u rfmode=0
M$668 \$I24289 \$I24293 \$I24295 VPWR sg13_lv_pmos L=0.13u W=0.42u AS=0.2048p
+ AD=0.09345p PS=1.63u PD=0.865u rfmode=0
M$669 \$I24295 \$I24286 VPWR VPWR sg13_lv_pmos L=0.13u W=0.42u AS=0.09345p
+ AD=0.204p PS=0.865u PD=1.835u rfmode=0
M$670 VPWR \$2022 \$I24286 VPWR sg13_lv_pmos L=0.13u W=0.42u AS=0.204p
+ AD=0.0798p PS=1.835u PD=0.8u rfmode=0
M$671 \$I24286 \$I24289 VPWR VPWR sg13_lv_pmos L=0.13u W=0.42u AS=0.0798p
+ AD=0.4659p PS=0.8u PD=3.65u rfmode=0
M$672 \$I24281 \$I24282 \$I24289 VPWR sg13_lv_pmos L=0.13u W=1u AS=0.34p
+ AD=0.2048p PS=2.68u PD=1.63u rfmode=0
M$673 \$I24287 \$I24289 VPWR VPWR sg13_lv_pmos L=0.13u W=1.12u AS=0.3864p
+ AD=0.2128p PS=2.93u PD=1.5u rfmode=0
M$674 VPWR \$I24287 \$2112 VPWR sg13_lv_pmos L=0.13u W=1.12u AS=0.2128p
+ AD=0.3808p PS=1.5u PD=2.92u rfmode=0
M$675 VPWR \$2066 \$I24283 VPWR sg13_lv_pmos L=0.13u W=0.42u AS=0.1428p
+ AD=0.0798p PS=1.52u PD=0.8u rfmode=0
M$676 VPWR \$2022 \$I24283 VPWR sg13_lv_pmos L=0.13u W=0.42u AS=0.3623875p
+ AD=0.0798p PS=2.605u PD=0.8u rfmode=0
M$677 VPWR \$I24288 \$I24281 VPWR sg13_lv_pmos L=0.13u W=1u AS=0.3623875p
+ AD=0.34p PS=2.605u PD=2.68u rfmode=0
M$678 \$I24293 \$I24282 VPWR VPWR sg13_lv_pmos L=0.13u W=1.12u AS=0.3864p
+ AD=0.41165p PS=2.93u PD=2.12u rfmode=0
M$679 VPWR \$1790 \$I24282 VPWR sg13_lv_pmos L=0.13u W=1.12u AS=0.41165p
+ AD=0.4088p PS=2.12u PD=2.97u rfmode=0
M$680 \$I24288 \$2022 VPWR VPWR sg13_lv_pmos L=0.13u W=0.42u AS=0.147p
+ AD=0.1563p PS=1.54u PD=1.22u rfmode=0
M$681 VPWR \$I24281 \$I24294 VPWR sg13_lv_pmos L=0.13u W=0.42u AS=0.1563p
+ AD=0.063p PS=1.22u PD=0.72u rfmode=0
M$682 \$I24294 \$I24282 \$I24288 VPWR sg13_lv_pmos L=0.13u W=0.42u AS=0.063p
+ AD=0.0798p PS=0.72u PD=0.8u rfmode=0
M$683 \$I24288 \$I24293 \$I24283 VPWR sg13_lv_pmos L=0.13u W=0.42u AS=0.0798p
+ AD=0.1428p PS=0.8u PD=1.52u rfmode=0
M$684 VGND \$I24297 \$I24308 VGND sg13_lv_nmos L=0.13u W=0.74u AS=0.317325p
+ AD=0.2516p PS=1.805u PD=2.16u rfmode=0
M$685 VGND \$2375 \$I24297 VGND sg13_lv_nmos L=0.13u W=0.74u AS=0.317325p
+ AD=0.2516p PS=1.805u PD=2.16u rfmode=0
M$686 \$I24304 \$I24297 \$I24300 VGND sg13_lv_nmos L=0.13u W=0.42u AS=0.12665p
+ AD=0.1428p PS=1.145u PD=1.52u rfmode=0
M$687 \$I24296 \$I24308 \$I24304 VGND sg13_lv_nmos L=0.13u W=0.74u AS=0.3473p
+ AD=0.12665p PS=2.71u PD=1.145u rfmode=0
M$688 \$I24298 \$3218 \$I24305 VGND sg13_lv_nmos L=0.13u W=0.42u AS=0.1428p
+ AD=0.0609p PS=1.52u PD=0.71u rfmode=0
M$689 \$I24305 \$3406 VGND VGND sg13_lv_nmos L=0.13u W=0.42u AS=0.0609p
+ AD=0.1626p PS=0.71u PD=1.415u rfmode=0
M$690 VGND \$I24303 \$I24296 VGND sg13_lv_nmos L=0.13u W=0.74u AS=0.1626p
+ AD=0.2516p PS=1.415u PD=2.16u rfmode=0
M$691 \$I24302 \$I24304 VGND VGND sg13_lv_nmos L=0.13u W=0.74u AS=0.2516p
+ AD=0.1406p PS=2.16u PD=1.12u rfmode=0
M$692 VGND \$I24302 \$1777 VGND sg13_lv_nmos L=0.13u W=0.74u AS=0.1406p
+ AD=0.2516p PS=1.12u PD=2.16u rfmode=0
M$693 \$I24298 \$I24297 \$I24303 VGND sg13_lv_nmos L=0.13u W=0.42u AS=0.1296p
+ AD=0.0798p PS=1.52u PD=0.8u rfmode=0
M$694 \$I24303 \$I24308 \$I24299 VGND sg13_lv_nmos L=0.13u W=0.42u AS=0.0798p
+ AD=0.2373p PS=0.8u PD=1.97u rfmode=0
M$695 \$I24300 \$I24301 VGND VGND sg13_lv_nmos L=0.13u W=0.42u AS=0.1428p
+ AD=0.0798p PS=1.52u PD=0.8u rfmode=0
M$696 VGND \$3406 \$I24307 VGND sg13_lv_nmos L=0.13u W=0.42u AS=0.0798p
+ AD=0.0378p PS=0.8u PD=0.6u rfmode=0
M$697 \$I24307 \$I24304 \$I24301 VGND sg13_lv_nmos L=0.13u W=0.42u AS=0.0378p
+ AD=0.1428p PS=0.6u PD=1.52u rfmode=0
M$698 VGND \$3406 \$I24306 VGND sg13_lv_nmos L=0.13u W=0.42u AS=0.1701p
+ AD=0.0378p PS=1.65u PD=0.6u rfmode=0
M$699 \$I24306 \$I24296 \$I24299 VGND sg13_lv_nmos L=0.13u W=0.42u AS=0.0378p
+ AD=0.1428p PS=0.6u PD=1.52u rfmode=0
M$700 \$I24304 \$I24308 \$I24310 VPWR sg13_lv_pmos L=0.13u W=0.42u AS=0.2048p
+ AD=0.09345p PS=1.63u PD=0.865u rfmode=0
M$701 \$I24310 \$I24301 VPWR VPWR sg13_lv_pmos L=0.13u W=0.42u AS=0.09345p
+ AD=0.204p PS=0.865u PD=1.835u rfmode=0
M$702 VPWR \$3406 \$I24301 VPWR sg13_lv_pmos L=0.13u W=0.42u AS=0.204p
+ AD=0.0798p PS=1.835u PD=0.8u rfmode=0
M$703 \$I24301 \$I24304 VPWR VPWR sg13_lv_pmos L=0.13u W=0.42u AS=0.0798p
+ AD=0.4659p PS=0.8u PD=3.65u rfmode=0
M$704 \$I24296 \$I24297 \$I24304 VPWR sg13_lv_pmos L=0.13u W=1u AS=0.34p
+ AD=0.2048p PS=2.68u PD=1.63u rfmode=0
M$705 \$I24302 \$I24304 VPWR VPWR sg13_lv_pmos L=0.13u W=1.12u AS=0.3864p
+ AD=0.2128p PS=2.93u PD=1.5u rfmode=0
M$706 VPWR \$I24302 \$1777 VPWR sg13_lv_pmos L=0.13u W=1.12u AS=0.2128p
+ AD=0.3808p PS=1.5u PD=2.92u rfmode=0
M$707 VPWR \$3218 \$I24298 VPWR sg13_lv_pmos L=0.13u W=0.42u AS=0.1428p
+ AD=0.0798p PS=1.52u PD=0.8u rfmode=0
M$708 VPWR \$3406 \$I24298 VPWR sg13_lv_pmos L=0.13u W=0.42u AS=0.3623875p
+ AD=0.0798p PS=2.605u PD=0.8u rfmode=0
M$709 VPWR \$I24303 \$I24296 VPWR sg13_lv_pmos L=0.13u W=1u AS=0.3623875p
+ AD=0.34p PS=2.605u PD=2.68u rfmode=0
M$710 \$I24308 \$I24297 VPWR VPWR sg13_lv_pmos L=0.13u W=1.12u AS=0.3864p
+ AD=0.41165p PS=2.93u PD=2.12u rfmode=0
M$711 VPWR \$2375 \$I24297 VPWR sg13_lv_pmos L=0.13u W=1.12u AS=0.41165p
+ AD=0.4088p PS=2.12u PD=2.97u rfmode=0
M$712 \$I24303 \$3406 VPWR VPWR sg13_lv_pmos L=0.13u W=0.42u AS=0.147p
+ AD=0.1563p PS=1.54u PD=1.22u rfmode=0
M$713 VPWR \$I24296 \$I24309 VPWR sg13_lv_pmos L=0.13u W=0.42u AS=0.1563p
+ AD=0.063p PS=1.22u PD=0.72u rfmode=0
M$714 \$I24309 \$I24297 \$I24303 VPWR sg13_lv_pmos L=0.13u W=0.42u AS=0.063p
+ AD=0.0798p PS=0.72u PD=0.8u rfmode=0
M$715 \$I24303 \$I24308 \$I24298 VPWR sg13_lv_pmos L=0.13u W=0.42u AS=0.0798p
+ AD=0.1428p PS=0.8u PD=1.52u rfmode=0
M$716 VGND \$I24312 \$I24323 VGND sg13_lv_nmos L=0.13u W=0.74u AS=0.317325p
+ AD=0.2516p PS=1.805u PD=2.16u rfmode=0
M$717 VGND \$1878 \$I24312 VGND sg13_lv_nmos L=0.13u W=0.74u AS=0.317325p
+ AD=0.2516p PS=1.805u PD=2.16u rfmode=0
M$718 \$I24319 \$I24312 \$I24315 VGND sg13_lv_nmos L=0.13u W=0.42u AS=0.12665p
+ AD=0.1428p PS=1.145u PD=1.52u rfmode=0
M$719 \$I24311 \$I24323 \$I24319 VGND sg13_lv_nmos L=0.13u W=0.74u AS=0.3473p
+ AD=0.12665p PS=2.71u PD=1.145u rfmode=0
M$720 \$I24313 \$3660 \$I24320 VGND sg13_lv_nmos L=0.13u W=0.42u AS=0.1428p
+ AD=0.0609p PS=1.52u PD=0.71u rfmode=0
M$721 \$I24320 \$2012 VGND VGND sg13_lv_nmos L=0.13u W=0.42u AS=0.0609p
+ AD=0.1626p PS=0.71u PD=1.415u rfmode=0
M$722 VGND \$I24318 \$I24311 VGND sg13_lv_nmos L=0.13u W=0.74u AS=0.1626p
+ AD=0.2516p PS=1.415u PD=2.16u rfmode=0
M$723 \$I24317 \$I24319 VGND VGND sg13_lv_nmos L=0.13u W=0.74u AS=0.2516p
+ AD=0.1406p PS=2.16u PD=1.12u rfmode=0
M$724 VGND \$I24317 \$1930 VGND sg13_lv_nmos L=0.13u W=0.74u AS=0.1406p
+ AD=0.2516p PS=1.12u PD=2.16u rfmode=0
M$725 \$I24313 \$I24312 \$I24318 VGND sg13_lv_nmos L=0.13u W=0.42u AS=0.1296p
+ AD=0.0798p PS=1.52u PD=0.8u rfmode=0
M$726 \$I24318 \$I24323 \$I24314 VGND sg13_lv_nmos L=0.13u W=0.42u AS=0.0798p
+ AD=0.2373p PS=0.8u PD=1.97u rfmode=0
M$727 \$I24315 \$I24316 VGND VGND sg13_lv_nmos L=0.13u W=0.42u AS=0.1428p
+ AD=0.0798p PS=1.52u PD=0.8u rfmode=0
M$728 VGND \$2012 \$I24322 VGND sg13_lv_nmos L=0.13u W=0.42u AS=0.0798p
+ AD=0.0378p PS=0.8u PD=0.6u rfmode=0
M$729 \$I24322 \$I24319 \$I24316 VGND sg13_lv_nmos L=0.13u W=0.42u AS=0.0378p
+ AD=0.1428p PS=0.6u PD=1.52u rfmode=0
M$730 VGND \$2012 \$I24321 VGND sg13_lv_nmos L=0.13u W=0.42u AS=0.1701p
+ AD=0.0378p PS=1.65u PD=0.6u rfmode=0
M$731 \$I24321 \$I24311 \$I24314 VGND sg13_lv_nmos L=0.13u W=0.42u AS=0.0378p
+ AD=0.1428p PS=0.6u PD=1.52u rfmode=0
M$732 \$I24319 \$I24323 \$I24325 VPWR sg13_lv_pmos L=0.13u W=0.42u AS=0.2048p
+ AD=0.09345p PS=1.63u PD=0.865u rfmode=0
M$733 \$I24325 \$I24316 VPWR VPWR sg13_lv_pmos L=0.13u W=0.42u AS=0.09345p
+ AD=0.204p PS=0.865u PD=1.835u rfmode=0
M$734 VPWR \$2012 \$I24316 VPWR sg13_lv_pmos L=0.13u W=0.42u AS=0.204p
+ AD=0.0798p PS=1.835u PD=0.8u rfmode=0
M$735 \$I24316 \$I24319 VPWR VPWR sg13_lv_pmos L=0.13u W=0.42u AS=0.0798p
+ AD=0.4659p PS=0.8u PD=3.65u rfmode=0
M$736 \$I24311 \$I24312 \$I24319 VPWR sg13_lv_pmos L=0.13u W=1u AS=0.34p
+ AD=0.2048p PS=2.68u PD=1.63u rfmode=0
M$737 \$I24317 \$I24319 VPWR VPWR sg13_lv_pmos L=0.13u W=1.12u AS=0.3864p
+ AD=0.2128p PS=2.93u PD=1.5u rfmode=0
M$738 VPWR \$I24317 \$1930 VPWR sg13_lv_pmos L=0.13u W=1.12u AS=0.2128p
+ AD=0.3808p PS=1.5u PD=2.92u rfmode=0
M$739 VPWR \$3660 \$I24313 VPWR sg13_lv_pmos L=0.13u W=0.42u AS=0.1428p
+ AD=0.0798p PS=1.52u PD=0.8u rfmode=0
M$740 VPWR \$2012 \$I24313 VPWR sg13_lv_pmos L=0.13u W=0.42u AS=0.3623875p
+ AD=0.0798p PS=2.605u PD=0.8u rfmode=0
M$741 VPWR \$I24318 \$I24311 VPWR sg13_lv_pmos L=0.13u W=1u AS=0.3623875p
+ AD=0.34p PS=2.605u PD=2.68u rfmode=0
M$742 \$I24323 \$I24312 VPWR VPWR sg13_lv_pmos L=0.13u W=1.12u AS=0.3864p
+ AD=0.41165p PS=2.93u PD=2.12u rfmode=0
M$743 VPWR \$1878 \$I24312 VPWR sg13_lv_pmos L=0.13u W=1.12u AS=0.41165p
+ AD=0.4088p PS=2.12u PD=2.97u rfmode=0
M$744 \$I24318 \$2012 VPWR VPWR sg13_lv_pmos L=0.13u W=0.42u AS=0.147p
+ AD=0.1563p PS=1.54u PD=1.22u rfmode=0
M$745 VPWR \$I24311 \$I24324 VPWR sg13_lv_pmos L=0.13u W=0.42u AS=0.1563p
+ AD=0.063p PS=1.22u PD=0.72u rfmode=0
M$746 \$I24324 \$I24312 \$I24318 VPWR sg13_lv_pmos L=0.13u W=0.42u AS=0.063p
+ AD=0.0798p PS=0.72u PD=0.8u rfmode=0
M$747 \$I24318 \$I24323 \$I24313 VPWR sg13_lv_pmos L=0.13u W=0.42u AS=0.0798p
+ AD=0.1428p PS=0.8u PD=1.52u rfmode=0
M$748 VGND \$I24327 \$I24338 VGND sg13_lv_nmos L=0.13u W=0.74u AS=0.317325p
+ AD=0.2516p PS=1.805u PD=2.16u rfmode=0
M$749 VGND \$2375 \$I24327 VGND sg13_lv_nmos L=0.13u W=0.74u AS=0.317325p
+ AD=0.2516p PS=1.805u PD=2.16u rfmode=0
M$750 \$I24334 \$I24327 \$I24330 VGND sg13_lv_nmos L=0.13u W=0.42u AS=0.12665p
+ AD=0.1428p PS=1.145u PD=1.52u rfmode=0
M$751 \$I24326 \$I24338 \$I24334 VGND sg13_lv_nmos L=0.13u W=0.74u AS=0.3473p
+ AD=0.12665p PS=2.71u PD=1.145u rfmode=0
M$752 \$I24328 \$2282 \$I24335 VGND sg13_lv_nmos L=0.13u W=0.42u AS=0.1428p
+ AD=0.0609p PS=1.52u PD=0.71u rfmode=0
M$753 \$I24335 \$2225 VGND VGND sg13_lv_nmos L=0.13u W=0.42u AS=0.0609p
+ AD=0.1626p PS=0.71u PD=1.415u rfmode=0
M$754 VGND \$I24333 \$I24326 VGND sg13_lv_nmos L=0.13u W=0.74u AS=0.1626p
+ AD=0.2516p PS=1.415u PD=2.16u rfmode=0
M$755 \$I24332 \$I24334 VGND VGND sg13_lv_nmos L=0.13u W=0.74u AS=0.2516p
+ AD=0.1406p PS=2.16u PD=1.12u rfmode=0
M$756 VGND \$I24332 \$2288 VGND sg13_lv_nmos L=0.13u W=0.74u AS=0.1406p
+ AD=0.2516p PS=1.12u PD=2.16u rfmode=0
M$757 \$I24328 \$I24327 \$I24333 VGND sg13_lv_nmos L=0.13u W=0.42u AS=0.1296p
+ AD=0.0798p PS=1.52u PD=0.8u rfmode=0
M$758 \$I24333 \$I24338 \$I24329 VGND sg13_lv_nmos L=0.13u W=0.42u AS=0.0798p
+ AD=0.2373p PS=0.8u PD=1.97u rfmode=0
M$759 \$I24330 \$I24331 VGND VGND sg13_lv_nmos L=0.13u W=0.42u AS=0.1428p
+ AD=0.0798p PS=1.52u PD=0.8u rfmode=0
M$760 VGND \$2225 \$I24337 VGND sg13_lv_nmos L=0.13u W=0.42u AS=0.0798p
+ AD=0.0378p PS=0.8u PD=0.6u rfmode=0
M$761 \$I24337 \$I24334 \$I24331 VGND sg13_lv_nmos L=0.13u W=0.42u AS=0.0378p
+ AD=0.1428p PS=0.6u PD=1.52u rfmode=0
M$762 VGND \$2225 \$I24336 VGND sg13_lv_nmos L=0.13u W=0.42u AS=0.1701p
+ AD=0.0378p PS=1.65u PD=0.6u rfmode=0
M$763 \$I24336 \$I24326 \$I24329 VGND sg13_lv_nmos L=0.13u W=0.42u AS=0.0378p
+ AD=0.1428p PS=0.6u PD=1.52u rfmode=0
M$764 \$I24334 \$I24338 \$I24340 VPWR sg13_lv_pmos L=0.13u W=0.42u AS=0.2048p
+ AD=0.09345p PS=1.63u PD=0.865u rfmode=0
M$765 \$I24340 \$I24331 VPWR VPWR sg13_lv_pmos L=0.13u W=0.42u AS=0.09345p
+ AD=0.204p PS=0.865u PD=1.835u rfmode=0
M$766 VPWR \$2225 \$I24331 VPWR sg13_lv_pmos L=0.13u W=0.42u AS=0.204p
+ AD=0.0798p PS=1.835u PD=0.8u rfmode=0
M$767 \$I24331 \$I24334 VPWR VPWR sg13_lv_pmos L=0.13u W=0.42u AS=0.0798p
+ AD=0.4659p PS=0.8u PD=3.65u rfmode=0
M$768 \$I24326 \$I24327 \$I24334 VPWR sg13_lv_pmos L=0.13u W=1u AS=0.34p
+ AD=0.2048p PS=2.68u PD=1.63u rfmode=0
M$769 \$I24332 \$I24334 VPWR VPWR sg13_lv_pmos L=0.13u W=1.12u AS=0.3864p
+ AD=0.2128p PS=2.93u PD=1.5u rfmode=0
M$770 VPWR \$I24332 \$2288 VPWR sg13_lv_pmos L=0.13u W=1.12u AS=0.2128p
+ AD=0.3808p PS=1.5u PD=2.92u rfmode=0
M$771 VPWR \$2282 \$I24328 VPWR sg13_lv_pmos L=0.13u W=0.42u AS=0.1428p
+ AD=0.0798p PS=1.52u PD=0.8u rfmode=0
M$772 VPWR \$2225 \$I24328 VPWR sg13_lv_pmos L=0.13u W=0.42u AS=0.3623875p
+ AD=0.0798p PS=2.605u PD=0.8u rfmode=0
M$773 VPWR \$I24333 \$I24326 VPWR sg13_lv_pmos L=0.13u W=1u AS=0.3623875p
+ AD=0.34p PS=2.605u PD=2.68u rfmode=0
M$774 \$I24338 \$I24327 VPWR VPWR sg13_lv_pmos L=0.13u W=1.12u AS=0.3864p
+ AD=0.41165p PS=2.93u PD=2.12u rfmode=0
M$775 VPWR \$2375 \$I24327 VPWR sg13_lv_pmos L=0.13u W=1.12u AS=0.41165p
+ AD=0.4088p PS=2.12u PD=2.97u rfmode=0
M$776 \$I24333 \$2225 VPWR VPWR sg13_lv_pmos L=0.13u W=0.42u AS=0.147p
+ AD=0.1563p PS=1.54u PD=1.22u rfmode=0
M$777 VPWR \$I24326 \$I24339 VPWR sg13_lv_pmos L=0.13u W=0.42u AS=0.1563p
+ AD=0.063p PS=1.22u PD=0.72u rfmode=0
M$778 \$I24339 \$I24327 \$I24333 VPWR sg13_lv_pmos L=0.13u W=0.42u AS=0.063p
+ AD=0.0798p PS=0.72u PD=0.8u rfmode=0
M$779 \$I24333 \$I24338 \$I24328 VPWR sg13_lv_pmos L=0.13u W=0.42u AS=0.0798p
+ AD=0.1428p PS=0.8u PD=1.52u rfmode=0
M$780 VGND \$I24342 \$I24353 VGND sg13_lv_nmos L=0.13u W=0.74u AS=0.317325p
+ AD=0.2516p PS=1.805u PD=2.16u rfmode=0
M$781 VGND \$3356 \$I24342 VGND sg13_lv_nmos L=0.13u W=0.74u AS=0.317325p
+ AD=0.2516p PS=1.805u PD=2.16u rfmode=0
M$782 \$I24349 \$I24342 \$I24345 VGND sg13_lv_nmos L=0.13u W=0.42u AS=0.12665p
+ AD=0.1428p PS=1.145u PD=1.52u rfmode=0
M$783 \$I24341 \$I24353 \$I24349 VGND sg13_lv_nmos L=0.13u W=0.74u AS=0.3473p
+ AD=0.12665p PS=2.71u PD=1.145u rfmode=0
M$784 \$I24343 \$3403 \$I24350 VGND sg13_lv_nmos L=0.13u W=0.42u AS=0.1428p
+ AD=0.0609p PS=1.52u PD=0.71u rfmode=0
M$785 \$I24350 \$3355 VGND VGND sg13_lv_nmos L=0.13u W=0.42u AS=0.0609p
+ AD=0.1626p PS=0.71u PD=1.415u rfmode=0
M$786 VGND \$I24348 \$I24341 VGND sg13_lv_nmos L=0.13u W=0.74u AS=0.1626p
+ AD=0.2516p PS=1.415u PD=2.16u rfmode=0
M$787 \$I24347 \$I24349 VGND VGND sg13_lv_nmos L=0.13u W=0.74u AS=0.2516p
+ AD=0.1406p PS=2.16u PD=1.12u rfmode=0
M$788 VGND \$I24347 \$3357 VGND sg13_lv_nmos L=0.13u W=0.74u AS=0.1406p
+ AD=0.2516p PS=1.12u PD=2.16u rfmode=0
M$789 \$I24343 \$I24342 \$I24348 VGND sg13_lv_nmos L=0.13u W=0.42u AS=0.1296p
+ AD=0.0798p PS=1.52u PD=0.8u rfmode=0
M$790 \$I24348 \$I24353 \$I24344 VGND sg13_lv_nmos L=0.13u W=0.42u AS=0.0798p
+ AD=0.2373p PS=0.8u PD=1.97u rfmode=0
M$791 \$I24345 \$I24346 VGND VGND sg13_lv_nmos L=0.13u W=0.42u AS=0.1428p
+ AD=0.0798p PS=1.52u PD=0.8u rfmode=0
M$792 VGND \$3355 \$I24352 VGND sg13_lv_nmos L=0.13u W=0.42u AS=0.0798p
+ AD=0.0378p PS=0.8u PD=0.6u rfmode=0
M$793 \$I24352 \$I24349 \$I24346 VGND sg13_lv_nmos L=0.13u W=0.42u AS=0.0378p
+ AD=0.1428p PS=0.6u PD=1.52u rfmode=0
M$794 VGND \$3355 \$I24351 VGND sg13_lv_nmos L=0.13u W=0.42u AS=0.1701p
+ AD=0.0378p PS=1.65u PD=0.6u rfmode=0
M$795 \$I24351 \$I24341 \$I24344 VGND sg13_lv_nmos L=0.13u W=0.42u AS=0.0378p
+ AD=0.1428p PS=0.6u PD=1.52u rfmode=0
M$796 \$I24349 \$I24353 \$I24355 VPWR sg13_lv_pmos L=0.13u W=0.42u AS=0.2048p
+ AD=0.09345p PS=1.63u PD=0.865u rfmode=0
M$797 \$I24355 \$I24346 VPWR VPWR sg13_lv_pmos L=0.13u W=0.42u AS=0.09345p
+ AD=0.204p PS=0.865u PD=1.835u rfmode=0
M$798 VPWR \$3355 \$I24346 VPWR sg13_lv_pmos L=0.13u W=0.42u AS=0.204p
+ AD=0.0798p PS=1.835u PD=0.8u rfmode=0
M$799 \$I24346 \$I24349 VPWR VPWR sg13_lv_pmos L=0.13u W=0.42u AS=0.0798p
+ AD=0.4659p PS=0.8u PD=3.65u rfmode=0
M$800 \$I24341 \$I24342 \$I24349 VPWR sg13_lv_pmos L=0.13u W=1u AS=0.34p
+ AD=0.2048p PS=2.68u PD=1.63u rfmode=0
M$801 \$I24347 \$I24349 VPWR VPWR sg13_lv_pmos L=0.13u W=1.12u AS=0.3864p
+ AD=0.2128p PS=2.93u PD=1.5u rfmode=0
M$802 VPWR \$I24347 \$3357 VPWR sg13_lv_pmos L=0.13u W=1.12u AS=0.2128p
+ AD=0.3808p PS=1.5u PD=2.92u rfmode=0
M$803 VPWR \$3403 \$I24343 VPWR sg13_lv_pmos L=0.13u W=0.42u AS=0.1428p
+ AD=0.0798p PS=1.52u PD=0.8u rfmode=0
M$804 VPWR \$3355 \$I24343 VPWR sg13_lv_pmos L=0.13u W=0.42u AS=0.3623875p
+ AD=0.0798p PS=2.605u PD=0.8u rfmode=0
M$805 VPWR \$I24348 \$I24341 VPWR sg13_lv_pmos L=0.13u W=1u AS=0.3623875p
+ AD=0.34p PS=2.605u PD=2.68u rfmode=0
M$806 \$I24353 \$I24342 VPWR VPWR sg13_lv_pmos L=0.13u W=1.12u AS=0.3864p
+ AD=0.41165p PS=2.93u PD=2.12u rfmode=0
M$807 VPWR \$3356 \$I24342 VPWR sg13_lv_pmos L=0.13u W=1.12u AS=0.41165p
+ AD=0.4088p PS=2.12u PD=2.97u rfmode=0
M$808 \$I24348 \$3355 VPWR VPWR sg13_lv_pmos L=0.13u W=0.42u AS=0.147p
+ AD=0.1563p PS=1.54u PD=1.22u rfmode=0
M$809 VPWR \$I24341 \$I24354 VPWR sg13_lv_pmos L=0.13u W=0.42u AS=0.1563p
+ AD=0.063p PS=1.22u PD=0.72u rfmode=0
M$810 \$I24354 \$I24342 \$I24348 VPWR sg13_lv_pmos L=0.13u W=0.42u AS=0.063p
+ AD=0.0798p PS=0.72u PD=0.8u rfmode=0
M$811 \$I24348 \$I24353 \$I24343 VPWR sg13_lv_pmos L=0.13u W=0.42u AS=0.0798p
+ AD=0.1428p PS=0.8u PD=1.52u rfmode=0
M$812 VGND \$I24357 \$I24368 VGND sg13_lv_nmos L=0.13u W=0.74u AS=0.317325p
+ AD=0.2516p PS=1.805u PD=2.16u rfmode=0
M$813 VGND \$1878 \$I24357 VGND sg13_lv_nmos L=0.13u W=0.74u AS=0.317325p
+ AD=0.2516p PS=1.805u PD=2.16u rfmode=0
M$814 \$I24364 \$I24357 \$I24360 VGND sg13_lv_nmos L=0.13u W=0.42u AS=0.12665p
+ AD=0.1428p PS=1.145u PD=1.52u rfmode=0
M$815 \$I24356 \$I24368 \$I24364 VGND sg13_lv_nmos L=0.13u W=0.74u AS=0.3473p
+ AD=0.12665p PS=2.71u PD=1.145u rfmode=0
M$816 \$I24358 \$2061 \$I24365 VGND sg13_lv_nmos L=0.13u W=0.42u AS=0.1428p
+ AD=0.0609p PS=1.52u PD=0.71u rfmode=0
M$817 \$I24365 \$1877 VGND VGND sg13_lv_nmos L=0.13u W=0.42u AS=0.0609p
+ AD=0.1626p PS=0.71u PD=1.415u rfmode=0
M$818 VGND \$I24363 \$I24356 VGND sg13_lv_nmos L=0.13u W=0.74u AS=0.1626p
+ AD=0.2516p PS=1.415u PD=2.16u rfmode=0
M$819 \$I24362 \$I24364 VGND VGND sg13_lv_nmos L=0.13u W=0.74u AS=0.2516p
+ AD=0.1406p PS=2.16u PD=1.12u rfmode=0
M$820 VGND \$I24362 \$1926 VGND sg13_lv_nmos L=0.13u W=0.74u AS=0.1406p
+ AD=0.2516p PS=1.12u PD=2.16u rfmode=0
M$821 \$I24358 \$I24357 \$I24363 VGND sg13_lv_nmos L=0.13u W=0.42u AS=0.1296p
+ AD=0.0798p PS=1.52u PD=0.8u rfmode=0
M$822 \$I24363 \$I24368 \$I24359 VGND sg13_lv_nmos L=0.13u W=0.42u AS=0.0798p
+ AD=0.2373p PS=0.8u PD=1.97u rfmode=0
M$823 \$I24360 \$I24361 VGND VGND sg13_lv_nmos L=0.13u W=0.42u AS=0.1428p
+ AD=0.0798p PS=1.52u PD=0.8u rfmode=0
M$824 VGND \$1877 \$I24367 VGND sg13_lv_nmos L=0.13u W=0.42u AS=0.0798p
+ AD=0.0378p PS=0.8u PD=0.6u rfmode=0
M$825 \$I24367 \$I24364 \$I24361 VGND sg13_lv_nmos L=0.13u W=0.42u AS=0.0378p
+ AD=0.1428p PS=0.6u PD=1.52u rfmode=0
M$826 VGND \$1877 \$I24366 VGND sg13_lv_nmos L=0.13u W=0.42u AS=0.1701p
+ AD=0.0378p PS=1.65u PD=0.6u rfmode=0
M$827 \$I24366 \$I24356 \$I24359 VGND sg13_lv_nmos L=0.13u W=0.42u AS=0.0378p
+ AD=0.1428p PS=0.6u PD=1.52u rfmode=0
M$828 \$I24364 \$I24368 \$I24370 VPWR sg13_lv_pmos L=0.13u W=0.42u AS=0.2048p
+ AD=0.09345p PS=1.63u PD=0.865u rfmode=0
M$829 \$I24370 \$I24361 VPWR VPWR sg13_lv_pmos L=0.13u W=0.42u AS=0.09345p
+ AD=0.204p PS=0.865u PD=1.835u rfmode=0
M$830 VPWR \$1877 \$I24361 VPWR sg13_lv_pmos L=0.13u W=0.42u AS=0.204p
+ AD=0.0798p PS=1.835u PD=0.8u rfmode=0
M$831 \$I24361 \$I24364 VPWR VPWR sg13_lv_pmos L=0.13u W=0.42u AS=0.0798p
+ AD=0.4659p PS=0.8u PD=3.65u rfmode=0
M$832 \$I24356 \$I24357 \$I24364 VPWR sg13_lv_pmos L=0.13u W=1u AS=0.34p
+ AD=0.2048p PS=2.68u PD=1.63u rfmode=0
M$833 \$I24362 \$I24364 VPWR VPWR sg13_lv_pmos L=0.13u W=1.12u AS=0.3864p
+ AD=0.2128p PS=2.93u PD=1.5u rfmode=0
M$834 VPWR \$I24362 \$1926 VPWR sg13_lv_pmos L=0.13u W=1.12u AS=0.2128p
+ AD=0.3808p PS=1.5u PD=2.92u rfmode=0
M$835 VPWR \$2061 \$I24358 VPWR sg13_lv_pmos L=0.13u W=0.42u AS=0.1428p
+ AD=0.0798p PS=1.52u PD=0.8u rfmode=0
M$836 VPWR \$1877 \$I24358 VPWR sg13_lv_pmos L=0.13u W=0.42u AS=0.3623875p
+ AD=0.0798p PS=2.605u PD=0.8u rfmode=0
M$837 VPWR \$I24363 \$I24356 VPWR sg13_lv_pmos L=0.13u W=1u AS=0.3623875p
+ AD=0.34p PS=2.605u PD=2.68u rfmode=0
M$838 \$I24368 \$I24357 VPWR VPWR sg13_lv_pmos L=0.13u W=1.12u AS=0.3864p
+ AD=0.41165p PS=2.93u PD=2.12u rfmode=0
M$839 VPWR \$1878 \$I24357 VPWR sg13_lv_pmos L=0.13u W=1.12u AS=0.41165p
+ AD=0.4088p PS=2.12u PD=2.97u rfmode=0
M$840 \$I24363 \$1877 VPWR VPWR sg13_lv_pmos L=0.13u W=0.42u AS=0.147p
+ AD=0.1563p PS=1.54u PD=1.22u rfmode=0
M$841 VPWR \$I24356 \$I24369 VPWR sg13_lv_pmos L=0.13u W=0.42u AS=0.1563p
+ AD=0.063p PS=1.22u PD=0.72u rfmode=0
M$842 \$I24369 \$I24357 \$I24363 VPWR sg13_lv_pmos L=0.13u W=0.42u AS=0.063p
+ AD=0.0798p PS=0.72u PD=0.8u rfmode=0
M$843 \$I24363 \$I24368 \$I24358 VPWR sg13_lv_pmos L=0.13u W=0.42u AS=0.0798p
+ AD=0.1428p PS=0.8u PD=1.52u rfmode=0
M$844 VGND \$I24372 \$I24383 VGND sg13_lv_nmos L=0.13u W=0.74u AS=0.317325p
+ AD=0.2516p PS=1.805u PD=2.16u rfmode=0
M$845 VGND \$1878 \$I24372 VGND sg13_lv_nmos L=0.13u W=0.74u AS=0.317325p
+ AD=0.2516p PS=1.805u PD=2.16u rfmode=0
M$846 \$I24379 \$I24372 \$I24375 VGND sg13_lv_nmos L=0.13u W=0.42u AS=0.12665p
+ AD=0.1428p PS=1.145u PD=1.52u rfmode=0
M$847 \$I24371 \$I24383 \$I24379 VGND sg13_lv_nmos L=0.13u W=0.74u AS=0.3473p
+ AD=0.12665p PS=2.71u PD=1.145u rfmode=0
M$848 \$I24373 \$2155 \$I24380 VGND sg13_lv_nmos L=0.13u W=0.42u AS=0.1428p
+ AD=0.0609p PS=1.52u PD=0.71u rfmode=0
M$849 \$I24380 \$2110 VGND VGND sg13_lv_nmos L=0.13u W=0.42u AS=0.0609p
+ AD=0.1626p PS=0.71u PD=1.415u rfmode=0
M$850 VGND \$I24378 \$I24371 VGND sg13_lv_nmos L=0.13u W=0.74u AS=0.1626p
+ AD=0.2516p PS=1.415u PD=2.16u rfmode=0
M$851 \$I24377 \$I24379 VGND VGND sg13_lv_nmos L=0.13u W=0.74u AS=0.2516p
+ AD=0.1406p PS=2.16u PD=1.12u rfmode=0
M$852 VGND \$I24377 \$2020 VGND sg13_lv_nmos L=0.13u W=0.74u AS=0.1406p
+ AD=0.2516p PS=1.12u PD=2.16u rfmode=0
M$853 \$I24373 \$I24372 \$I24378 VGND sg13_lv_nmos L=0.13u W=0.42u AS=0.1296p
+ AD=0.0798p PS=1.52u PD=0.8u rfmode=0
M$854 \$I24378 \$I24383 \$I24374 VGND sg13_lv_nmos L=0.13u W=0.42u AS=0.0798p
+ AD=0.2373p PS=0.8u PD=1.97u rfmode=0
M$855 \$I24375 \$I24376 VGND VGND sg13_lv_nmos L=0.13u W=0.42u AS=0.1428p
+ AD=0.0798p PS=1.52u PD=0.8u rfmode=0
M$856 VGND \$2110 \$I24382 VGND sg13_lv_nmos L=0.13u W=0.42u AS=0.0798p
+ AD=0.0378p PS=0.8u PD=0.6u rfmode=0
M$857 \$I24382 \$I24379 \$I24376 VGND sg13_lv_nmos L=0.13u W=0.42u AS=0.0378p
+ AD=0.1428p PS=0.6u PD=1.52u rfmode=0
M$858 VGND \$2110 \$I24381 VGND sg13_lv_nmos L=0.13u W=0.42u AS=0.1701p
+ AD=0.0378p PS=1.65u PD=0.6u rfmode=0
M$859 \$I24381 \$I24371 \$I24374 VGND sg13_lv_nmos L=0.13u W=0.42u AS=0.0378p
+ AD=0.1428p PS=0.6u PD=1.52u rfmode=0
M$860 \$I24379 \$I24383 \$I24385 VPWR sg13_lv_pmos L=0.13u W=0.42u AS=0.2048p
+ AD=0.09345p PS=1.63u PD=0.865u rfmode=0
M$861 \$I24385 \$I24376 VPWR VPWR sg13_lv_pmos L=0.13u W=0.42u AS=0.09345p
+ AD=0.204p PS=0.865u PD=1.835u rfmode=0
M$862 VPWR \$2110 \$I24376 VPWR sg13_lv_pmos L=0.13u W=0.42u AS=0.204p
+ AD=0.0798p PS=1.835u PD=0.8u rfmode=0
M$863 \$I24376 \$I24379 VPWR VPWR sg13_lv_pmos L=0.13u W=0.42u AS=0.0798p
+ AD=0.4659p PS=0.8u PD=3.65u rfmode=0
M$864 \$I24371 \$I24372 \$I24379 VPWR sg13_lv_pmos L=0.13u W=1u AS=0.34p
+ AD=0.2048p PS=2.68u PD=1.63u rfmode=0
M$865 \$I24377 \$I24379 VPWR VPWR sg13_lv_pmos L=0.13u W=1.12u AS=0.3864p
+ AD=0.2128p PS=2.93u PD=1.5u rfmode=0
M$866 VPWR \$I24377 \$2020 VPWR sg13_lv_pmos L=0.13u W=1.12u AS=0.2128p
+ AD=0.3808p PS=1.5u PD=2.92u rfmode=0
M$867 VPWR \$2155 \$I24373 VPWR sg13_lv_pmos L=0.13u W=0.42u AS=0.1428p
+ AD=0.0798p PS=1.52u PD=0.8u rfmode=0
M$868 VPWR \$2110 \$I24373 VPWR sg13_lv_pmos L=0.13u W=0.42u AS=0.3623875p
+ AD=0.0798p PS=2.605u PD=0.8u rfmode=0
M$869 VPWR \$I24378 \$I24371 VPWR sg13_lv_pmos L=0.13u W=1u AS=0.3623875p
+ AD=0.34p PS=2.605u PD=2.68u rfmode=0
M$870 \$I24383 \$I24372 VPWR VPWR sg13_lv_pmos L=0.13u W=1.12u AS=0.3864p
+ AD=0.41165p PS=2.93u PD=2.12u rfmode=0
M$871 VPWR \$1878 \$I24372 VPWR sg13_lv_pmos L=0.13u W=1.12u AS=0.41165p
+ AD=0.4088p PS=2.12u PD=2.97u rfmode=0
M$872 \$I24378 \$2110 VPWR VPWR sg13_lv_pmos L=0.13u W=0.42u AS=0.147p
+ AD=0.1563p PS=1.54u PD=1.22u rfmode=0
M$873 VPWR \$I24371 \$I24384 VPWR sg13_lv_pmos L=0.13u W=0.42u AS=0.1563p
+ AD=0.063p PS=1.22u PD=0.72u rfmode=0
M$874 \$I24384 \$I24372 \$I24378 VPWR sg13_lv_pmos L=0.13u W=0.42u AS=0.063p
+ AD=0.0798p PS=0.72u PD=0.8u rfmode=0
M$875 \$I24378 \$I24383 \$I24373 VPWR sg13_lv_pmos L=0.13u W=0.42u AS=0.0798p
+ AD=0.1428p PS=0.8u PD=1.52u rfmode=0
M$876 VGND \$I24387 \$I24398 VGND sg13_lv_nmos L=0.13u W=0.74u AS=0.317325p
+ AD=0.2516p PS=1.805u PD=2.16u rfmode=0
M$877 VGND \$1790 \$I24387 VGND sg13_lv_nmos L=0.13u W=0.74u AS=0.317325p
+ AD=0.2516p PS=1.805u PD=2.16u rfmode=0
M$878 \$I24394 \$I24387 \$I24390 VGND sg13_lv_nmos L=0.13u W=0.42u AS=0.12665p
+ AD=0.1428p PS=1.145u PD=1.52u rfmode=0
M$879 \$I24386 \$I24398 \$I24394 VGND sg13_lv_nmos L=0.13u W=0.74u AS=0.3473p
+ AD=0.12665p PS=2.71u PD=1.145u rfmode=0
M$880 \$I24388 \$1825 \$I24395 VGND sg13_lv_nmos L=0.13u W=0.42u AS=0.1428p
+ AD=0.0609p PS=1.52u PD=0.71u rfmode=0
M$881 \$I24395 \$1791 VGND VGND sg13_lv_nmos L=0.13u W=0.42u AS=0.0609p
+ AD=0.1626p PS=0.71u PD=1.415u rfmode=0
M$882 VGND \$I24393 \$I24386 VGND sg13_lv_nmos L=0.13u W=0.74u AS=0.1626p
+ AD=0.2516p PS=1.415u PD=2.16u rfmode=0
M$883 \$I24392 \$I24394 VGND VGND sg13_lv_nmos L=0.13u W=0.74u AS=0.2516p
+ AD=0.1406p PS=2.16u PD=1.12u rfmode=0
M$884 VGND \$I24392 \$1785 VGND sg13_lv_nmos L=0.13u W=0.74u AS=0.1406p
+ AD=0.2516p PS=1.12u PD=2.16u rfmode=0
M$885 \$I24388 \$I24387 \$I24393 VGND sg13_lv_nmos L=0.13u W=0.42u AS=0.1296p
+ AD=0.0798p PS=1.52u PD=0.8u rfmode=0
M$886 \$I24393 \$I24398 \$I24389 VGND sg13_lv_nmos L=0.13u W=0.42u AS=0.0798p
+ AD=0.2373p PS=0.8u PD=1.97u rfmode=0
M$887 \$I24390 \$I24391 VGND VGND sg13_lv_nmos L=0.13u W=0.42u AS=0.1428p
+ AD=0.0798p PS=1.52u PD=0.8u rfmode=0
M$888 VGND \$1791 \$I24397 VGND sg13_lv_nmos L=0.13u W=0.42u AS=0.0798p
+ AD=0.0378p PS=0.8u PD=0.6u rfmode=0
M$889 \$I24397 \$I24394 \$I24391 VGND sg13_lv_nmos L=0.13u W=0.42u AS=0.0378p
+ AD=0.1428p PS=0.6u PD=1.52u rfmode=0
M$890 VGND \$1791 \$I24396 VGND sg13_lv_nmos L=0.13u W=0.42u AS=0.1701p
+ AD=0.0378p PS=1.65u PD=0.6u rfmode=0
M$891 \$I24396 \$I24386 \$I24389 VGND sg13_lv_nmos L=0.13u W=0.42u AS=0.0378p
+ AD=0.1428p PS=0.6u PD=1.52u rfmode=0
M$892 \$I24394 \$I24398 \$I24400 VPWR sg13_lv_pmos L=0.13u W=0.42u AS=0.2048p
+ AD=0.09345p PS=1.63u PD=0.865u rfmode=0
M$893 \$I24400 \$I24391 VPWR VPWR sg13_lv_pmos L=0.13u W=0.42u AS=0.09345p
+ AD=0.204p PS=0.865u PD=1.835u rfmode=0
M$894 VPWR \$1791 \$I24391 VPWR sg13_lv_pmos L=0.13u W=0.42u AS=0.204p
+ AD=0.0798p PS=1.835u PD=0.8u rfmode=0
M$895 \$I24391 \$I24394 VPWR VPWR sg13_lv_pmos L=0.13u W=0.42u AS=0.0798p
+ AD=0.4659p PS=0.8u PD=3.65u rfmode=0
M$896 \$I24386 \$I24387 \$I24394 VPWR sg13_lv_pmos L=0.13u W=1u AS=0.34p
+ AD=0.2048p PS=2.68u PD=1.63u rfmode=0
M$897 \$I24392 \$I24394 VPWR VPWR sg13_lv_pmos L=0.13u W=1.12u AS=0.3864p
+ AD=0.2128p PS=2.93u PD=1.5u rfmode=0
M$898 VPWR \$I24392 \$1785 VPWR sg13_lv_pmos L=0.13u W=1.12u AS=0.2128p
+ AD=0.3808p PS=1.5u PD=2.92u rfmode=0
M$899 VPWR \$1825 \$I24388 VPWR sg13_lv_pmos L=0.13u W=0.42u AS=0.1428p
+ AD=0.0798p PS=1.52u PD=0.8u rfmode=0
M$900 VPWR \$1791 \$I24388 VPWR sg13_lv_pmos L=0.13u W=0.42u AS=0.3623875p
+ AD=0.0798p PS=2.605u PD=0.8u rfmode=0
M$901 VPWR \$I24393 \$I24386 VPWR sg13_lv_pmos L=0.13u W=1u AS=0.3623875p
+ AD=0.34p PS=2.605u PD=2.68u rfmode=0
M$902 \$I24398 \$I24387 VPWR VPWR sg13_lv_pmos L=0.13u W=1.12u AS=0.3864p
+ AD=0.41165p PS=2.93u PD=2.12u rfmode=0
M$903 VPWR \$1790 \$I24387 VPWR sg13_lv_pmos L=0.13u W=1.12u AS=0.41165p
+ AD=0.4088p PS=2.12u PD=2.97u rfmode=0
M$904 \$I24393 \$1791 VPWR VPWR sg13_lv_pmos L=0.13u W=0.42u AS=0.147p
+ AD=0.1563p PS=1.54u PD=1.22u rfmode=0
M$905 VPWR \$I24386 \$I24399 VPWR sg13_lv_pmos L=0.13u W=0.42u AS=0.1563p
+ AD=0.063p PS=1.22u PD=0.72u rfmode=0
M$906 \$I24399 \$I24387 \$I24393 VPWR sg13_lv_pmos L=0.13u W=0.42u AS=0.063p
+ AD=0.0798p PS=0.72u PD=0.8u rfmode=0
M$907 \$I24393 \$I24398 \$I24388 VPWR sg13_lv_pmos L=0.13u W=0.42u AS=0.0798p
+ AD=0.1428p PS=0.8u PD=1.52u rfmode=0
M$908 \$3160 \$3160 \$3160 VAPWR sg13_hv_pmos L=0.5u W=12u AS=4.08p AD=4.08p
+ PS=26.04u PD=26.04u rfmode=0
M$909 \$2150 \$2150 \$2150 VAPWR sg13_hv_pmos L=0.5u W=4u AS=1.36p AD=1.36p
+ PS=8.68u PD=8.68u rfmode=0
M$910 \$2152 \$2152 \$2152 VAPWR sg13_hv_pmos L=0.5u W=4u AS=1.36p AD=1.36p
+ PS=8.68u PD=8.68u rfmode=0
M$913 \$3153 \$3055 \$3160 VAPWR sg13_hv_pmos L=0.5u W=16u AS=5.44p AD=5.44p
+ PS=34.72u PD=34.72u rfmode=0
M$915 \$3152 \$3152 \$3152 VAPWR sg13_hv_pmos L=0.5u W=4u AS=1.36p AD=1.36p
+ PS=8.68u PD=8.68u rfmode=0
M$916 \$3152 analog_1 \$3160 VAPWR sg13_hv_pmos L=0.5u W=16u AS=5.44p AD=5.44p
+ PS=34.72u PD=34.72u rfmode=0
M$917 \$3152 \$3152 VGND VGND sg13_hv_nmos L=0.5u W=8u AS=2.72p AD=2.72p
+ PS=18.72u PD=18.72u rfmode=0
M$918 \$3153 \$3153 \$3153 VAPWR sg13_hv_pmos L=0.5u W=4u AS=1.36p AD=1.36p
+ PS=8.68u PD=8.68u rfmode=0
M$924 \$3153 \$3152 VGND VGND sg13_hv_nmos L=0.5u W=8u AS=2.72p AD=2.72p
+ PS=18.72u PD=18.72u rfmode=0
M$930 \$3153 \$3153 \$3153 VGND sg13_hv_nmos L=0.5u W=2u AS=0.68p AD=0.68p
+ PS=4.68u PD=4.68u rfmode=0
M$933 \$3152 \$3152 \$3152 VGND sg13_hv_nmos L=0.5u W=2u AS=0.68p AD=0.68p
+ PS=4.68u PD=4.68u rfmode=0
R$934 \$2051 \$3055 VGND rhigh w=2u l=1.4u ps=0u b=0 m=1
R$935 \$1268 \$2051 VGND rhigh w=2u l=1.4u ps=0u b=0 m=1
R$936 \$247 VGND VGND rhigh w=2u l=13.71u ps=0.18u b=8 m=1
R$937 \$2048 VGND VGND rhigh w=2u l=13.71u ps=0.18u b=8 m=1
R$938 \$1265 VGND VGND rhigh w=2u l=13.71u ps=0.18u b=8 m=1
R$939 \$3052 VGND VGND rhigh w=2u l=13.71u ps=0.18u b=8 m=1
R$940 \$1601 \$1463 VGND rsil w=0.5u l=0.5u ps=0u b=0 m=1
R$941 VGND \$4253 VGND rhigh w=2u l=10u ps=0u b=0 m=1
R$942 VGND \$4162 VGND rhigh w=2u l=8u ps=0u b=0 m=1
M$943 analog_1 analog_1 \$4162 \$4162 sg13_hv_pmos L=0.5u W=20u AS=4.1p AD=4.1p
+ PS=26.1u PD=26.1u rfmode=0
R$953 \$4418 \$3526 VGND rhigh w=2u l=9.96u ps=0.18u b=3 m=1
R$954 \$2809 \$1721 VGND rhigh w=2u l=9.96u ps=0.18u b=3 m=1
R$955 \$951 analog_2 VGND rhigh w=2u l=9.96u ps=0.18u b=3 m=1
R$956 VGND \$254 VGND rhigh w=2u l=4.95u ps=0.18u b=2 m=1
R$957 VGND \$4576 VGND rhigh w=2u l=4.95u ps=0.18u b=2 m=1
R$958 VGND \$1445 VGND rhigh w=2u l=4.95u ps=0.18u b=2 m=1
R$959 VGND \$3164 VGND rhigh w=2u l=4.95u ps=0.18u b=2 m=1
R$960 VGND \$2055 VGND rhigh w=2u l=4.95u ps=0.18u b=2 m=1
R$961 VGND \$4052 VGND rhigh w=2u l=4.95u ps=0.18u b=2 m=1
R$962 VAPWR \$4053 VGND rhigh w=2u l=19.995u ps=0.18u b=9 m=1
R$963 VAPWR \$1924 VGND rhigh w=2u l=19.995u ps=0.18u b=9 m=1
R$964 VAPWR \$255 VGND rhigh w=2u l=19.995u ps=0.18u b=9 m=1
R$965 VAPWR \$3055 VGND rhigh w=2u l=28.8u ps=0u b=0 m=1
R$966 VGND \$252 VGND rhigh w=2u l=9.27u ps=0.18u b=15 m=1
R$967 VGND \$3056 VGND rhigh w=2u l=9.27u ps=0.18u b=15 m=1
R$968 VGND \$2053 VGND rhigh w=2u l=9.27u ps=0.18u b=15 m=1
R$969 VGND \$1269 VGND rhigh w=2u l=9.27u ps=0.18u b=15 m=1
M$970 VGND q2 \$I24401 VGND sg13_lv_nmos L=0.13u W=0.55u AS=0.14875p AD=0.187p
+ PS=1.16u PD=1.78u rfmode=0
M$971 VGND \$I24401 \$3660 VGND sg13_lv_nmos L=0.13u W=0.74u AS=0.14875p
+ AD=0.2886p PS=1.16u PD=2.26u rfmode=0
M$972 VPWR q2 \$I24401 VPWR sg13_lv_pmos L=0.13u W=0.84u AS=0.2114p AD=0.2856p
+ PS=1.54u PD=2.36u rfmode=0
M$973 VPWR \$I24401 \$3660 VPWR sg13_lv_pmos L=0.13u W=1.12u AS=0.2114p
+ AD=0.42p PS=1.54u PD=2.99u rfmode=0
M$974 VGND \$725 \$I24402 VGND sg13_lv_nmos L=0.13u W=0.55u AS=0.14875p
+ AD=0.187p PS=1.16u PD=1.78u rfmode=0
M$975 VGND \$I24402 q0_d VGND sg13_lv_nmos L=0.13u W=0.74u AS=0.14875p
+ AD=0.2886p PS=1.16u PD=2.26u rfmode=0
M$976 VPWR \$725 \$I24402 VPWR sg13_lv_pmos L=0.13u W=0.84u AS=0.2114p
+ AD=0.2856p PS=1.54u PD=2.36u rfmode=0
M$977 VPWR \$I24402 q0_d VPWR sg13_lv_pmos L=0.13u W=1.12u AS=0.2114p AD=0.42p
+ PS=1.54u PD=2.99u rfmode=0
M$978 VGND \$1926 \$I24403 VGND sg13_lv_nmos L=0.13u W=0.55u AS=0.14875p
+ AD=0.187p PS=1.16u PD=1.78u rfmode=0
M$979 VGND \$I24403 q2_d VGND sg13_lv_nmos L=0.13u W=0.74u AS=0.14875p
+ AD=0.2886p PS=1.16u PD=2.26u rfmode=0
M$980 VPWR \$1926 \$I24403 VPWR sg13_lv_pmos L=0.13u W=0.84u AS=0.2114p
+ AD=0.2856p PS=1.54u PD=2.36u rfmode=0
M$981 VPWR \$I24403 q2_d VPWR sg13_lv_pmos L=0.13u W=1.12u AS=0.2114p AD=0.42p
+ PS=1.54u PD=2.99u rfmode=0
M$982 VGND \$1777 \$I24404 VGND sg13_lv_nmos L=0.13u W=0.55u AS=0.14875p
+ AD=0.187p PS=1.16u PD=1.78u rfmode=0
M$983 VGND \$I24404 q1_d VGND sg13_lv_nmos L=0.13u W=0.74u AS=0.14875p
+ AD=0.2886p PS=1.16u PD=2.26u rfmode=0
M$984 VPWR \$1777 \$I24404 VPWR sg13_lv_pmos L=0.13u W=0.84u AS=0.2114p
+ AD=0.2856p PS=1.54u PD=2.36u rfmode=0
M$985 VPWR \$I24404 q1_d VPWR sg13_lv_pmos L=0.13u W=1.12u AS=0.2114p AD=0.42p
+ PS=1.54u PD=2.99u rfmode=0
M$986 VGND q3 \$I24405 VGND sg13_lv_nmos L=0.13u W=0.55u AS=0.14875p AD=0.187p
+ PS=1.16u PD=1.78u rfmode=0
M$987 VGND \$I24405 \$4525 VGND sg13_lv_nmos L=0.13u W=0.74u AS=0.14875p
+ AD=0.2886p PS=1.16u PD=2.26u rfmode=0
M$988 VPWR q3 \$I24405 VPWR sg13_lv_pmos L=0.13u W=0.84u AS=0.2114p AD=0.2856p
+ PS=1.54u PD=2.36u rfmode=0
M$989 VPWR \$I24405 \$4525 VPWR sg13_lv_pmos L=0.13u W=1.12u AS=0.2114p
+ AD=0.42p PS=1.54u PD=2.99u rfmode=0
M$990 VGND \$1722 \$I24406 VGND sg13_lv_nmos L=0.13u W=0.55u AS=0.14875p
+ AD=0.187p PS=1.16u PD=1.78u rfmode=0
M$991 VGND \$I24406 \$1661 VGND sg13_lv_nmos L=0.13u W=0.74u AS=0.14875p
+ AD=0.2886p PS=1.16u PD=2.26u rfmode=0
M$992 VPWR \$1722 \$I24406 VPWR sg13_lv_pmos L=0.13u W=0.84u AS=0.2114p
+ AD=0.2856p PS=1.54u PD=2.36u rfmode=0
M$993 VPWR \$I24406 \$1661 VPWR sg13_lv_pmos L=0.13u W=1.12u AS=0.2114p
+ AD=0.42p PS=1.54u PD=2.99u rfmode=0
M$994 VGND data_in_tx \$I24407 VGND sg13_lv_nmos L=0.13u W=0.55u AS=0.14875p
+ AD=0.187p PS=1.16u PD=1.78u rfmode=0
M$995 VGND \$I24407 \$3803 VGND sg13_lv_nmos L=0.13u W=0.74u AS=0.14875p
+ AD=0.2886p PS=1.16u PD=2.26u rfmode=0
M$996 VPWR data_in_tx \$I24407 VPWR sg13_lv_pmos L=0.13u W=0.84u AS=0.2114p
+ AD=0.2856p PS=1.54u PD=2.36u rfmode=0
M$997 VPWR \$I24407 \$3803 VPWR sg13_lv_pmos L=0.13u W=1.12u AS=0.2114p
+ AD=0.42p PS=1.54u PD=2.99u rfmode=0
M$998 VGND \$768 \$I24408 VGND sg13_lv_nmos L=0.13u W=0.55u AS=0.14875p
+ AD=0.187p PS=1.16u PD=1.78u rfmode=0
M$999 VGND \$I24408 vctrl_in VGND sg13_lv_nmos L=0.13u W=0.74u AS=0.14875p
+ AD=0.2886p PS=1.16u PD=2.26u rfmode=0
M$1000 VPWR \$768 \$I24408 VPWR sg13_lv_pmos L=0.13u W=0.84u AS=0.2114p
+ AD=0.2856p PS=1.54u PD=2.36u rfmode=0
M$1001 VPWR \$I24408 vctrl_in VPWR sg13_lv_pmos L=0.13u W=1.12u AS=0.2114p
+ AD=0.42p PS=1.54u PD=2.99u rfmode=0
M$1002 VGND \$1685 \$I24409 VGND sg13_lv_nmos L=0.13u W=0.55u AS=0.14875p
+ AD=0.187p PS=1.16u PD=1.78u rfmode=0
M$1003 VGND \$I24409 \$2074 VGND sg13_lv_nmos L=0.13u W=0.74u AS=0.14875p
+ AD=0.2886p PS=1.16u PD=2.26u rfmode=0
M$1004 VPWR \$1685 \$I24409 VPWR sg13_lv_pmos L=0.13u W=0.84u AS=0.2114p
+ AD=0.2856p PS=1.54u PD=2.36u rfmode=0
M$1005 VPWR \$I24409 \$2074 VPWR sg13_lv_pmos L=0.13u W=1.12u AS=0.2114p
+ AD=0.42p PS=1.54u PD=2.99u rfmode=0
M$1006 VGND \$2429 \$I24410 VGND sg13_lv_nmos L=0.13u W=0.55u AS=0.14875p
+ AD=0.187p PS=1.16u PD=1.78u rfmode=0
M$1007 VGND \$I24410 q3_d VGND sg13_lv_nmos L=0.13u W=0.74u AS=0.14875p
+ AD=0.2886p PS=1.16u PD=2.26u rfmode=0
M$1008 VPWR \$2429 \$I24410 VPWR sg13_lv_pmos L=0.13u W=0.84u AS=0.2114p
+ AD=0.2856p PS=1.54u PD=2.36u rfmode=0
M$1009 VPWR \$I24410 q3_d VPWR sg13_lv_pmos L=0.13u W=1.12u AS=0.2114p AD=0.42p
+ PS=1.54u PD=2.99u rfmode=0
M$1010 VGND q1 \$I24411 VGND sg13_lv_nmos L=0.13u W=0.55u AS=0.14875p AD=0.187p
+ PS=1.16u PD=1.78u rfmode=0
M$1011 VGND \$I24411 \$3403 VGND sg13_lv_nmos L=0.13u W=0.74u AS=0.14875p
+ AD=0.2886p PS=1.16u PD=2.26u rfmode=0
M$1012 VPWR q1 \$I24411 VPWR sg13_lv_pmos L=0.13u W=0.84u AS=0.2114p AD=0.2856p
+ PS=1.54u PD=2.36u rfmode=0
M$1013 VPWR \$I24411 \$3403 VPWR sg13_lv_pmos L=0.13u W=1.12u AS=0.2114p
+ AD=0.42p PS=1.54u PD=2.99u rfmode=0
M$1014 VGND q0 \$I24412 VGND sg13_lv_nmos L=0.13u W=0.55u AS=0.14875p AD=0.187p
+ PS=1.16u PD=1.78u rfmode=0
M$1015 VGND \$I24412 \$2947 VGND sg13_lv_nmos L=0.13u W=0.74u AS=0.14875p
+ AD=0.2886p PS=1.16u PD=2.26u rfmode=0
M$1016 VPWR q0 \$I24412 VPWR sg13_lv_pmos L=0.13u W=0.84u AS=0.2114p AD=0.2856p
+ PS=1.54u PD=2.36u rfmode=0
M$1017 VPWR \$I24412 \$2947 VPWR sg13_lv_pmos L=0.13u W=1.12u AS=0.2114p
+ AD=0.42p PS=1.54u PD=2.99u rfmode=0
M$1018 VGND \$1661 \$I24413 VGND sg13_lv_nmos L=0.13u W=0.55u AS=0.14875p
+ AD=0.187p PS=1.16u PD=1.78u rfmode=0
M$1019 VGND \$I24413 clk_ref VGND sg13_lv_nmos L=0.13u W=0.74u AS=0.14875p
+ AD=0.2886p PS=1.16u PD=2.26u rfmode=0
M$1020 VPWR \$1661 \$I24413 VPWR sg13_lv_pmos L=0.13u W=0.84u AS=0.2114p
+ AD=0.2856p PS=1.54u PD=2.36u rfmode=0
M$1021 VPWR \$I24413 clk_ref VPWR sg13_lv_pmos L=0.13u W=1.12u AS=0.2114p
+ AD=0.42p PS=1.54u PD=2.99u rfmode=0
M$1022 VGND rst_n_in \$I24414 VGND sg13_lv_nmos L=0.13u W=0.55u AS=0.14875p
+ AD=0.187p PS=1.16u PD=1.78u rfmode=0
M$1023 VGND \$I24414 \$1685 VGND sg13_lv_nmos L=0.13u W=0.74u AS=0.14875p
+ AD=0.2886p PS=1.16u PD=2.26u rfmode=0
M$1024 VPWR rst_n_in \$I24414 VPWR sg13_lv_pmos L=0.13u W=0.84u AS=0.2114p
+ AD=0.2856p PS=1.54u PD=2.36u rfmode=0
M$1025 VPWR \$I24414 \$1685 VPWR sg13_lv_pmos L=0.13u W=1.12u AS=0.2114p
+ AD=0.42p PS=1.54u PD=2.99u rfmode=0
M$1026 VGND \$2074 \$I24415 VGND sg13_lv_nmos L=0.13u W=0.55u AS=0.14875p
+ AD=0.187p PS=1.16u PD=1.78u rfmode=0
M$1027 VGND \$I24415 rst_n VGND sg13_lv_nmos L=0.13u W=0.74u AS=0.14875p
+ AD=0.2886p PS=1.16u PD=2.26u rfmode=0
M$1028 VPWR \$2074 \$I24415 VPWR sg13_lv_pmos L=0.13u W=0.84u AS=0.2114p
+ AD=0.2856p PS=1.54u PD=2.36u rfmode=0
M$1029 VPWR \$I24415 rst_n VPWR sg13_lv_pmos L=0.13u W=1.12u AS=0.2114p
+ AD=0.42p PS=1.54u PD=2.99u rfmode=0
M$1030 VGND \$520 \$I24416 VGND sg13_lv_nmos L=0.13u W=0.55u AS=0.14875p
+ AD=0.187p PS=1.16u PD=1.78u rfmode=0
M$1031 VGND \$I24416 vctrl_b_in VGND sg13_lv_nmos L=0.13u W=0.74u AS=0.14875p
+ AD=0.2886p PS=1.16u PD=2.26u rfmode=0
M$1032 VPWR \$520 \$I24416 VPWR sg13_lv_pmos L=0.13u W=0.84u AS=0.2114p
+ AD=0.2856p PS=1.54u PD=2.36u rfmode=0
M$1033 VPWR \$I24416 vctrl_b_in VPWR sg13_lv_pmos L=0.13u W=1.12u AS=0.2114p
+ AD=0.42p PS=1.54u PD=2.99u rfmode=0
M$1034 VGND \$I24418 \$I24417 VGND sg13_lv_nmos L=0.5u W=0.42u AS=0.1426p
+ AD=0.1428p PS=1.16u PD=1.52u rfmode=0
M$1035 VGND \$I24417 \$2120 VGND sg13_lv_nmos L=0.13u W=0.74u AS=0.1426p
+ AD=0.2516p PS=1.16u PD=2.16u rfmode=0
M$1036 \$I24419 \$2121 VGND VGND sg13_lv_nmos L=0.13u W=0.42u AS=0.1428p
+ AD=0.0798p PS=1.52u PD=0.8u rfmode=0
M$1037 VGND \$I24419 \$I24418 VGND sg13_lv_nmos L=0.5u W=0.42u AS=0.0798p
+ AD=0.1428p PS=0.8u PD=1.52u rfmode=0
M$1038 \$I24417 \$I24418 VPWR VPWR sg13_lv_pmos L=0.5u W=1u AS=0.34p AD=0.2254p
+ PS=2.68u PD=1.53u rfmode=0
M$1039 VPWR \$I24417 \$2120 VPWR sg13_lv_pmos L=0.13u W=1.12u AS=0.2254p
+ AD=0.4256p PS=1.53u PD=3u rfmode=0
M$1040 VPWR \$2121 \$I24419 VPWR sg13_lv_pmos L=0.13u W=0.42u AS=0.1523p
+ AD=0.1428p PS=1.38u PD=1.52u rfmode=0
M$1041 VPWR \$I24419 \$I24418 VPWR sg13_lv_pmos L=0.5u W=1u AS=0.1523p AD=0.34p
+ PS=1.38u PD=2.68u rfmode=0
M$1042 VGND \$I24421 \$I24420 VGND sg13_lv_nmos L=0.5u W=0.42u AS=0.1426p
+ AD=0.1428p PS=1.16u PD=1.52u rfmode=0
M$1043 VGND \$I24420 \$2115 VGND sg13_lv_nmos L=0.13u W=0.74u AS=0.1426p
+ AD=0.2516p PS=1.16u PD=2.16u rfmode=0
M$1044 \$I24422 \$2112 VGND VGND sg13_lv_nmos L=0.13u W=0.42u AS=0.1428p
+ AD=0.0798p PS=1.52u PD=0.8u rfmode=0
M$1045 VGND \$I24422 \$I24421 VGND sg13_lv_nmos L=0.5u W=0.42u AS=0.0798p
+ AD=0.1428p PS=0.8u PD=1.52u rfmode=0
M$1046 \$I24420 \$I24421 VPWR VPWR sg13_lv_pmos L=0.5u W=1u AS=0.34p AD=0.2254p
+ PS=2.68u PD=1.53u rfmode=0
M$1047 VPWR \$I24420 \$2115 VPWR sg13_lv_pmos L=0.13u W=1.12u AS=0.2254p
+ AD=0.4256p PS=1.53u PD=3u rfmode=0
M$1048 VPWR \$2112 \$I24422 VPWR sg13_lv_pmos L=0.13u W=0.42u AS=0.1523p
+ AD=0.1428p PS=1.38u PD=1.52u rfmode=0
M$1049 VPWR \$I24422 \$I24421 VPWR sg13_lv_pmos L=0.5u W=1u AS=0.1523p AD=0.34p
+ PS=1.38u PD=2.68u rfmode=0
M$1050 VGND \$I24424 \$I24423 VGND sg13_lv_nmos L=0.5u W=0.42u AS=0.1426p
+ AD=0.1428p PS=1.16u PD=1.52u rfmode=0
M$1051 VGND \$I24423 \$1787 VGND sg13_lv_nmos L=0.13u W=0.74u AS=0.1426p
+ AD=0.2516p PS=1.16u PD=2.16u rfmode=0
M$1052 \$I24425 \$1783 VGND VGND sg13_lv_nmos L=0.13u W=0.42u AS=0.1428p
+ AD=0.0798p PS=1.52u PD=0.8u rfmode=0
M$1053 VGND \$I24425 \$I24424 VGND sg13_lv_nmos L=0.5u W=0.42u AS=0.0798p
+ AD=0.1428p PS=0.8u PD=1.52u rfmode=0
M$1054 \$I24423 \$I24424 VPWR VPWR sg13_lv_pmos L=0.5u W=1u AS=0.34p AD=0.2254p
+ PS=2.68u PD=1.53u rfmode=0
M$1055 VPWR \$I24423 \$1787 VPWR sg13_lv_pmos L=0.13u W=1.12u AS=0.2254p
+ AD=0.4256p PS=1.53u PD=3u rfmode=0
M$1056 VPWR \$1783 \$I24425 VPWR sg13_lv_pmos L=0.13u W=0.42u AS=0.1523p
+ AD=0.1428p PS=1.38u PD=1.52u rfmode=0
M$1057 VPWR \$I24425 \$I24424 VPWR sg13_lv_pmos L=0.5u W=1u AS=0.1523p AD=0.34p
+ PS=1.38u PD=2.68u rfmode=0
M$1058 VGND \$I24427 \$I24426 VGND sg13_lv_nmos L=0.5u W=0.42u AS=0.1426p
+ AD=0.1428p PS=1.16u PD=1.52u rfmode=0
M$1059 VGND \$I24426 \$4125 VGND sg13_lv_nmos L=0.13u W=0.74u AS=0.1426p
+ AD=0.2516p PS=1.16u PD=2.16u rfmode=0
M$1060 \$I24428 \$4230 VGND VGND sg13_lv_nmos L=0.13u W=0.42u AS=0.1428p
+ AD=0.0798p PS=1.52u PD=0.8u rfmode=0
M$1061 VGND \$I24428 \$I24427 VGND sg13_lv_nmos L=0.5u W=0.42u AS=0.0798p
+ AD=0.1428p PS=0.8u PD=1.52u rfmode=0
M$1062 \$I24426 \$I24427 VPWR VPWR sg13_lv_pmos L=0.5u W=1u AS=0.34p AD=0.2254p
+ PS=2.68u PD=1.53u rfmode=0
M$1063 VPWR \$I24426 \$4125 VPWR sg13_lv_pmos L=0.13u W=1.12u AS=0.2254p
+ AD=0.4256p PS=1.53u PD=3u rfmode=0
M$1064 VPWR \$4230 \$I24428 VPWR sg13_lv_pmos L=0.13u W=0.42u AS=0.1523p
+ AD=0.1428p PS=1.38u PD=1.52u rfmode=0
M$1065 VPWR \$I24428 \$I24427 VPWR sg13_lv_pmos L=0.5u W=1u AS=0.1523p AD=0.34p
+ PS=1.38u PD=2.68u rfmode=0
M$1066 VGND \$I24430 \$I24429 VGND sg13_lv_nmos L=0.5u W=0.42u AS=0.1426p
+ AD=0.1428p PS=1.16u PD=1.52u rfmode=0
M$1067 VGND \$I24429 \$2155 VGND sg13_lv_nmos L=0.13u W=0.74u AS=0.1426p
+ AD=0.2516p PS=1.16u PD=2.16u rfmode=0
M$1068 \$I24431 \$2221 VGND VGND sg13_lv_nmos L=0.13u W=0.42u AS=0.1428p
+ AD=0.0798p PS=1.52u PD=0.8u rfmode=0
M$1069 VGND \$I24431 \$I24430 VGND sg13_lv_nmos L=0.5u W=0.42u AS=0.0798p
+ AD=0.1428p PS=0.8u PD=1.52u rfmode=0
M$1070 \$I24429 \$I24430 VPWR VPWR sg13_lv_pmos L=0.5u W=1u AS=0.34p AD=0.2254p
+ PS=2.68u PD=1.53u rfmode=0
M$1071 VPWR \$I24429 \$2155 VPWR sg13_lv_pmos L=0.13u W=1.12u AS=0.2254p
+ AD=0.4256p PS=1.53u PD=3u rfmode=0
M$1072 VPWR \$2221 \$I24431 VPWR sg13_lv_pmos L=0.13u W=0.42u AS=0.1523p
+ AD=0.1428p PS=1.38u PD=1.52u rfmode=0
M$1073 VPWR \$I24431 \$I24430 VPWR sg13_lv_pmos L=0.5u W=1u AS=0.1523p AD=0.34p
+ PS=1.38u PD=2.68u rfmode=0
M$1074 VGND \$I24433 \$I24432 VGND sg13_lv_nmos L=0.5u W=0.42u AS=0.1426p
+ AD=0.1428p PS=1.16u PD=1.52u rfmode=0
M$1075 VGND \$I24432 \$2066 VGND sg13_lv_nmos L=0.13u W=0.74u AS=0.1426p
+ AD=0.2516p PS=1.16u PD=2.16u rfmode=0
M$1076 \$I24434 \$1943 VGND VGND sg13_lv_nmos L=0.13u W=0.42u AS=0.1428p
+ AD=0.0798p PS=1.52u PD=0.8u rfmode=0
M$1077 VGND \$I24434 \$I24433 VGND sg13_lv_nmos L=0.5u W=0.42u AS=0.0798p
+ AD=0.1428p PS=0.8u PD=1.52u rfmode=0
M$1078 \$I24432 \$I24433 VPWR VPWR sg13_lv_pmos L=0.5u W=1u AS=0.34p AD=0.2254p
+ PS=2.68u PD=1.53u rfmode=0
M$1079 VPWR \$I24432 \$2066 VPWR sg13_lv_pmos L=0.13u W=1.12u AS=0.2254p
+ AD=0.4256p PS=1.53u PD=3u rfmode=0
M$1080 VPWR \$1943 \$I24434 VPWR sg13_lv_pmos L=0.13u W=0.42u AS=0.1523p
+ AD=0.1428p PS=1.38u PD=1.52u rfmode=0
M$1081 VPWR \$I24434 \$I24433 VPWR sg13_lv_pmos L=0.5u W=1u AS=0.1523p AD=0.34p
+ PS=1.38u PD=2.68u rfmode=0
M$1082 VGND \$I24436 \$I24435 VGND sg13_lv_nmos L=0.5u W=0.42u AS=0.1426p
+ AD=0.1428p PS=1.16u PD=1.52u rfmode=0
M$1083 VGND \$I24435 \$2226 VGND sg13_lv_nmos L=0.13u W=0.74u AS=0.1426p
+ AD=0.2516p PS=1.16u PD=2.16u rfmode=0
M$1084 \$I24437 \$2288 VGND VGND sg13_lv_nmos L=0.13u W=0.42u AS=0.1428p
+ AD=0.0798p PS=1.52u PD=0.8u rfmode=0
M$1085 VGND \$I24437 \$I24436 VGND sg13_lv_nmos L=0.5u W=0.42u AS=0.0798p
+ AD=0.1428p PS=0.8u PD=1.52u rfmode=0
M$1086 \$I24435 \$I24436 VPWR VPWR sg13_lv_pmos L=0.5u W=1u AS=0.34p AD=0.2254p
+ PS=2.68u PD=1.53u rfmode=0
M$1087 VPWR \$I24435 \$2226 VPWR sg13_lv_pmos L=0.13u W=1.12u AS=0.2254p
+ AD=0.4256p PS=1.53u PD=3u rfmode=0
M$1088 VPWR \$2288 \$I24437 VPWR sg13_lv_pmos L=0.13u W=0.42u AS=0.1523p
+ AD=0.1428p PS=1.38u PD=1.52u rfmode=0
M$1089 VPWR \$I24437 \$I24436 VPWR sg13_lv_pmos L=0.5u W=1u AS=0.1523p AD=0.34p
+ PS=1.38u PD=2.68u rfmode=0
M$1090 VGND \$I24439 \$I24438 VGND sg13_lv_nmos L=0.5u W=0.42u AS=0.1426p
+ AD=0.1428p PS=1.16u PD=1.52u rfmode=0
M$1091 VGND \$I24438 \$2581 VGND sg13_lv_nmos L=0.13u W=0.74u AS=0.1426p
+ AD=0.2516p PS=1.16u PD=2.16u rfmode=0
M$1092 \$I24440 \$2628 VGND VGND sg13_lv_nmos L=0.13u W=0.42u AS=0.1428p
+ AD=0.0798p PS=1.52u PD=0.8u rfmode=0
M$1093 VGND \$I24440 \$I24439 VGND sg13_lv_nmos L=0.5u W=0.42u AS=0.0798p
+ AD=0.1428p PS=0.8u PD=1.52u rfmode=0
M$1094 \$I24438 \$I24439 VPWR VPWR sg13_lv_pmos L=0.5u W=1u AS=0.34p AD=0.2254p
+ PS=2.68u PD=1.53u rfmode=0
M$1095 VPWR \$I24438 \$2581 VPWR sg13_lv_pmos L=0.13u W=1.12u AS=0.2254p
+ AD=0.4256p PS=1.53u PD=3u rfmode=0
M$1096 VPWR \$2628 \$I24440 VPWR sg13_lv_pmos L=0.13u W=0.42u AS=0.1523p
+ AD=0.1428p PS=1.38u PD=1.52u rfmode=0
M$1097 VPWR \$I24440 \$I24439 VPWR sg13_lv_pmos L=0.5u W=1u AS=0.1523p AD=0.34p
+ PS=1.38u PD=2.68u rfmode=0
M$1098 VGND \$I24442 \$I24441 VGND sg13_lv_nmos L=0.5u W=0.42u AS=0.1426p
+ AD=0.1428p PS=1.16u PD=1.52u rfmode=0
M$1099 VGND \$I24441 \$1778 VGND sg13_lv_nmos L=0.13u W=0.74u AS=0.1426p
+ AD=0.2516p PS=1.16u PD=2.16u rfmode=0
M$1100 \$I24443 \$2020 VGND VGND sg13_lv_nmos L=0.13u W=0.42u AS=0.1428p
+ AD=0.0798p PS=1.52u PD=0.8u rfmode=0
M$1101 VGND \$I24443 \$I24442 VGND sg13_lv_nmos L=0.5u W=0.42u AS=0.0798p
+ AD=0.1428p PS=0.8u PD=1.52u rfmode=0
M$1102 \$I24441 \$I24442 VPWR VPWR sg13_lv_pmos L=0.5u W=1u AS=0.34p AD=0.2254p
+ PS=2.68u PD=1.53u rfmode=0
M$1103 VPWR \$I24441 \$1778 VPWR sg13_lv_pmos L=0.13u W=1.12u AS=0.2254p
+ AD=0.4256p PS=1.53u PD=3u rfmode=0
M$1104 VPWR \$2020 \$I24443 VPWR sg13_lv_pmos L=0.13u W=0.42u AS=0.1523p
+ AD=0.1428p PS=1.38u PD=1.52u rfmode=0
M$1105 VPWR \$I24443 \$I24442 VPWR sg13_lv_pmos L=0.5u W=1u AS=0.1523p AD=0.34p
+ PS=1.38u PD=2.68u rfmode=0
M$1106 VGND \$I24445 \$I24444 VGND sg13_lv_nmos L=0.5u W=0.42u AS=0.1426p
+ AD=0.1428p PS=1.16u PD=1.52u rfmode=0
M$1107 VGND \$I24444 \$2282 VGND sg13_lv_nmos L=0.13u W=0.74u AS=0.1426p
+ AD=0.2516p PS=1.16u PD=2.16u rfmode=0
M$1108 \$I24446 \$2159 VGND VGND sg13_lv_nmos L=0.13u W=0.42u AS=0.1428p
+ AD=0.0798p PS=1.52u PD=0.8u rfmode=0
M$1109 VGND \$I24446 \$I24445 VGND sg13_lv_nmos L=0.5u W=0.42u AS=0.0798p
+ AD=0.1428p PS=0.8u PD=1.52u rfmode=0
M$1110 \$I24444 \$I24445 VPWR VPWR sg13_lv_pmos L=0.5u W=1u AS=0.34p AD=0.2254p
+ PS=2.68u PD=1.53u rfmode=0
M$1111 VPWR \$I24444 \$2282 VPWR sg13_lv_pmos L=0.13u W=1.12u AS=0.2254p
+ AD=0.4256p PS=1.53u PD=3u rfmode=0
M$1112 VPWR \$2159 \$I24446 VPWR sg13_lv_pmos L=0.13u W=0.42u AS=0.1523p
+ AD=0.1428p PS=1.38u PD=1.52u rfmode=0
M$1113 VPWR \$I24446 \$I24445 VPWR sg13_lv_pmos L=0.5u W=1u AS=0.1523p AD=0.34p
+ PS=1.38u PD=2.68u rfmode=0
M$1114 VGND \$I24448 \$I24447 VGND sg13_lv_nmos L=0.5u W=0.42u AS=0.1426p
+ AD=0.1428p PS=1.16u PD=1.52u rfmode=0
M$1115 VGND \$I24447 \$2061 VGND sg13_lv_nmos L=0.13u W=0.74u AS=0.1426p
+ AD=0.2516p PS=1.16u PD=2.16u rfmode=0
M$1116 \$I24449 \$1930 VGND VGND sg13_lv_nmos L=0.13u W=0.42u AS=0.1428p
+ AD=0.0798p PS=1.52u PD=0.8u rfmode=0
M$1117 VGND \$I24449 \$I24448 VGND sg13_lv_nmos L=0.5u W=0.42u AS=0.0798p
+ AD=0.1428p PS=0.8u PD=1.52u rfmode=0
M$1118 \$I24447 \$I24448 VPWR VPWR sg13_lv_pmos L=0.5u W=1u AS=0.34p AD=0.2254p
+ PS=2.68u PD=1.53u rfmode=0
M$1119 VPWR \$I24447 \$2061 VPWR sg13_lv_pmos L=0.13u W=1.12u AS=0.2254p
+ AD=0.4256p PS=1.53u PD=3u rfmode=0
M$1120 VPWR \$1930 \$I24449 VPWR sg13_lv_pmos L=0.13u W=0.42u AS=0.1523p
+ AD=0.1428p PS=1.38u PD=1.52u rfmode=0
M$1121 VPWR \$I24449 \$I24448 VPWR sg13_lv_pmos L=0.5u W=1u AS=0.1523p AD=0.34p
+ PS=1.38u PD=2.68u rfmode=0
M$1122 VGND \$I24451 \$I24450 VGND sg13_lv_nmos L=0.5u W=0.42u AS=0.1426p
+ AD=0.1428p PS=1.16u PD=1.52u rfmode=0
M$1123 VGND \$I24450 \$2896 VGND sg13_lv_nmos L=0.13u W=0.74u AS=0.1426p
+ AD=0.2516p PS=1.16u PD=2.16u rfmode=0
M$1124 \$I24452 \$3177 VGND VGND sg13_lv_nmos L=0.13u W=0.42u AS=0.1428p
+ AD=0.0798p PS=1.52u PD=0.8u rfmode=0
M$1125 VGND \$I24452 \$I24451 VGND sg13_lv_nmos L=0.5u W=0.42u AS=0.0798p
+ AD=0.1428p PS=0.8u PD=1.52u rfmode=0
M$1126 \$I24450 \$I24451 VPWR VPWR sg13_lv_pmos L=0.5u W=1u AS=0.34p AD=0.2254p
+ PS=2.68u PD=1.53u rfmode=0
M$1127 VPWR \$I24450 \$2896 VPWR sg13_lv_pmos L=0.13u W=1.12u AS=0.2254p
+ AD=0.4256p PS=1.53u PD=3u rfmode=0
M$1128 VPWR \$3177 \$I24452 VPWR sg13_lv_pmos L=0.13u W=0.42u AS=0.1523p
+ AD=0.1428p PS=1.38u PD=1.52u rfmode=0
M$1129 VPWR \$I24452 \$I24451 VPWR sg13_lv_pmos L=0.5u W=1u AS=0.1523p AD=0.34p
+ PS=1.38u PD=2.68u rfmode=0
M$1130 VGND \$I24454 \$I24453 VGND sg13_lv_nmos L=0.5u W=0.42u AS=0.1426p
+ AD=0.1428p PS=1.16u PD=1.52u rfmode=0
M$1131 VGND \$I24453 \$3218 VGND sg13_lv_nmos L=0.13u W=0.74u AS=0.1426p
+ AD=0.2516p PS=1.16u PD=2.16u rfmode=0
M$1132 \$I24455 \$3357 VGND VGND sg13_lv_nmos L=0.13u W=0.42u AS=0.1428p
+ AD=0.0798p PS=1.52u PD=0.8u rfmode=0
M$1133 VGND \$I24455 \$I24454 VGND sg13_lv_nmos L=0.5u W=0.42u AS=0.0798p
+ AD=0.1428p PS=0.8u PD=1.52u rfmode=0
M$1134 \$I24453 \$I24454 VPWR VPWR sg13_lv_pmos L=0.5u W=1u AS=0.34p AD=0.2254p
+ PS=2.68u PD=1.53u rfmode=0
M$1135 VPWR \$I24453 \$3218 VPWR sg13_lv_pmos L=0.13u W=1.12u AS=0.2254p
+ AD=0.4256p PS=1.53u PD=3u rfmode=0
M$1136 VPWR \$3357 \$I24455 VPWR sg13_lv_pmos L=0.13u W=0.42u AS=0.1523p
+ AD=0.1428p PS=1.38u PD=1.52u rfmode=0
M$1137 VPWR \$I24455 \$I24454 VPWR sg13_lv_pmos L=0.5u W=1u AS=0.1523p AD=0.34p
+ PS=1.38u PD=2.68u rfmode=0
M$1138 VGND \$I24457 \$I24456 VGND sg13_lv_nmos L=0.5u W=0.42u AS=0.1426p
+ AD=0.1428p PS=1.16u PD=1.52u rfmode=0
M$1139 VGND \$I24456 \$2023 VGND sg13_lv_nmos L=0.13u W=0.74u AS=0.1426p
+ AD=0.2516p PS=1.16u PD=2.16u rfmode=0
M$1140 \$I24458 \$2118 VGND VGND sg13_lv_nmos L=0.13u W=0.42u AS=0.1428p
+ AD=0.0798p PS=1.52u PD=0.8u rfmode=0
M$1141 VGND \$I24458 \$I24457 VGND sg13_lv_nmos L=0.5u W=0.42u AS=0.0798p
+ AD=0.1428p PS=0.8u PD=1.52u rfmode=0
M$1142 \$I24456 \$I24457 VPWR VPWR sg13_lv_pmos L=0.5u W=1u AS=0.34p AD=0.2254p
+ PS=2.68u PD=1.53u rfmode=0
M$1143 VPWR \$I24456 \$2023 VPWR sg13_lv_pmos L=0.13u W=1.12u AS=0.2254p
+ AD=0.4256p PS=1.53u PD=3u rfmode=0
M$1144 VPWR \$2118 \$I24458 VPWR sg13_lv_pmos L=0.13u W=0.42u AS=0.1523p
+ AD=0.1428p PS=1.38u PD=1.52u rfmode=0
M$1145 VPWR \$I24458 \$I24457 VPWR sg13_lv_pmos L=0.5u W=1u AS=0.1523p AD=0.34p
+ PS=1.38u PD=2.68u rfmode=0
M$1146 VGND \$I24460 \$I24459 VGND sg13_lv_nmos L=0.5u W=0.42u AS=0.1426p
+ AD=0.1428p PS=1.16u PD=1.52u rfmode=0
M$1147 VGND \$I24459 \$1825 VGND sg13_lv_nmos L=0.13u W=0.74u AS=0.1426p
+ AD=0.2516p PS=1.16u PD=2.16u rfmode=0
M$1148 \$I24461 \$1824 VGND VGND sg13_lv_nmos L=0.13u W=0.42u AS=0.1428p
+ AD=0.0798p PS=1.52u PD=0.8u rfmode=0
M$1149 VGND \$I24461 \$I24460 VGND sg13_lv_nmos L=0.5u W=0.42u AS=0.0798p
+ AD=0.1428p PS=0.8u PD=1.52u rfmode=0
M$1150 \$I24459 \$I24460 VPWR VPWR sg13_lv_pmos L=0.5u W=1u AS=0.34p AD=0.2254p
+ PS=2.68u PD=1.53u rfmode=0
M$1151 VPWR \$I24459 \$1825 VPWR sg13_lv_pmos L=0.13u W=1.12u AS=0.2254p
+ AD=0.4256p PS=1.53u PD=3u rfmode=0
M$1152 VPWR \$1824 \$I24461 VPWR sg13_lv_pmos L=0.13u W=0.42u AS=0.1523p
+ AD=0.1428p PS=1.38u PD=1.52u rfmode=0
M$1153 VPWR \$I24461 \$I24460 VPWR sg13_lv_pmos L=0.5u W=1u AS=0.1523p AD=0.34p
+ PS=1.38u PD=2.68u rfmode=0
M$1154 VGND \$1689 \$I24464 VGND sg13_lv_nmos L=0.13u W=0.74u AS=0.2516p
+ AD=0.1406p PS=2.16u PD=1.12u rfmode=0
M$1155 \$I24464 \$2118 \$I24463 VGND sg13_lv_nmos L=0.13u W=0.74u AS=0.1406p
+ AD=0.1406p PS=1.12u PD=1.12u rfmode=0
M$1156 \$I24463 \$2112 \$I24462 VGND sg13_lv_nmos L=0.13u W=0.74u AS=0.1406p
+ AD=0.1406p PS=1.12u PD=1.12u rfmode=0
M$1157 \$I24462 \$2226 \$1879 VGND sg13_lv_nmos L=0.13u W=0.74u AS=0.1406p
+ AD=0.2516p PS=1.12u PD=2.16u rfmode=0
M$1158 VPWR \$1689 \$1879 VPWR sg13_lv_pmos L=0.13u W=1.12u AS=0.3808p
+ AD=0.2128p PS=2.92u PD=1.5u rfmode=0
M$1159 \$1879 \$2118 VPWR VPWR sg13_lv_pmos L=0.13u W=1.12u AS=0.2128p
+ AD=0.2128p PS=1.5u PD=1.5u rfmode=0
M$1160 VPWR \$2112 \$1879 VPWR sg13_lv_pmos L=0.13u W=1.12u AS=0.2128p
+ AD=0.2128p PS=1.5u PD=1.5u rfmode=0
M$1161 \$1879 \$2226 VPWR VPWR sg13_lv_pmos L=0.13u W=1.12u AS=0.2128p
+ AD=0.3808p PS=1.5u PD=2.92u rfmode=0
M$1162 VGND \$1689 \$I24465 VGND sg13_lv_nmos L=0.13u W=0.74u AS=0.2516p
+ AD=0.1406p PS=2.16u PD=1.12u rfmode=0
M$1163 \$I24465 \$2118 \$2437 VGND sg13_lv_nmos L=0.13u W=0.74u AS=0.1406p
+ AD=0.2516p PS=1.12u PD=2.16u rfmode=0
M$1164 VPWR \$1689 \$2437 VPWR sg13_lv_pmos L=0.13u W=1.12u AS=0.3808p
+ AD=0.2128p PS=2.92u PD=1.5u rfmode=0
M$1165 \$2437 \$2118 VPWR VPWR sg13_lv_pmos L=0.13u W=1.12u AS=0.2128p
+ AD=0.3808p PS=1.5u PD=2.92u rfmode=0
M$1166 VGND \$1685 \$1784 VGND sg13_lv_nmos L=0.13u W=0.74u AS=0.2516p
+ AD=0.2516p PS=2.16u PD=2.16u rfmode=0
M$1167 VPWR \$1685 \$1784 VPWR sg13_lv_pmos L=0.13u W=1.12u AS=0.3808p
+ AD=0.3808p PS=2.92u PD=2.92u rfmode=0
M$1168 VGND \$2226 \$2220 VGND sg13_lv_nmos L=0.13u W=0.74u AS=0.2516p
+ AD=0.2516p PS=2.16u PD=2.16u rfmode=0
M$1169 VPWR \$2226 \$2220 VPWR sg13_lv_pmos L=0.13u W=1.12u AS=0.3808p
+ AD=0.3808p PS=2.92u PD=2.92u rfmode=0
M$1170 VGND \$1778 \$1780 VGND sg13_lv_nmos L=0.13u W=0.74u AS=0.2516p
+ AD=0.2516p PS=2.16u PD=2.16u rfmode=0
M$1171 VPWR \$1778 \$1780 VPWR sg13_lv_pmos L=0.13u W=1.12u AS=0.3808p
+ AD=0.3808p PS=2.92u PD=2.92u rfmode=0
M$1172 VGND \$2115 \$1884 VGND sg13_lv_nmos L=0.13u W=0.74u AS=0.2516p
+ AD=0.2516p PS=2.16u PD=2.16u rfmode=0
M$1173 VPWR \$2115 \$1884 VPWR sg13_lv_pmos L=0.13u W=1.12u AS=0.3808p
+ AD=0.3808p PS=2.92u PD=2.92u rfmode=0
M$1174 VGND \$1787 \$1684 VGND sg13_lv_nmos L=0.13u W=0.74u AS=0.2516p
+ AD=0.2516p PS=2.16u PD=2.16u rfmode=0
M$1175 VPWR \$1787 \$1684 VPWR sg13_lv_pmos L=0.13u W=1.12u AS=0.3808p
+ AD=0.3808p PS=2.92u PD=2.92u rfmode=0
M$1176 VGND VPWR VGND VGND sg13_lv_nmos L=1u W=2020.2u AS=536.424p AD=536.424p
+ PS=5591.84u PD=5591.84u rfmode=0
M$1177 VPWR VGND VPWR VPWR sg13_lv_pmos L=1u W=4810u AS=1277.2p AD=1277.2p
+ PS=9786.4u PD=9786.4u rfmode=0
R$10796 \$4311 \$1601 VGND rhigh w=1u l=61.395u ps=0.18u b=2 m=1
R$10797 \$3065 VAPWR VGND rhigh w=2u l=22.72u ps=0.18u b=10 m=1
R$10798 \$4520 VAPWR VGND rhigh w=2u l=22.72u ps=0.18u b=10 m=1
R$10799 \$1276 VAPWR VGND rhigh w=2u l=22.72u ps=0.18u b=10 m=1
R$10800 \$4418 VAPWR VGND rhigh w=2u l=19.995u ps=0.18u b=9 m=1
R$10801 \$2809 VAPWR VGND rhigh w=2u l=19.995u ps=0.18u b=9 m=1
R$10802 \$951 VAPWR VGND rhigh w=2u l=19.995u ps=0.18u b=9 m=1
M$10807 \$56 \$56 \$56 VPWR sg13_lv_pmos L=0.13u W=2u AS=0.68p AD=0.68p
+ PS=4.68u PD=4.68u rfmode=0
M$10808 VPWR VPWR VPWR VPWR sg13_lv_pmos L=0.13u W=10.25u AS=3.485p AD=3.485p
+ PS=26.62u PD=26.62u rfmode=0
M$10809 \$56 \$322 VPWR VPWR sg13_lv_pmos L=0.13u W=40u AS=7.9p AD=7.9p
+ PS=49.9u PD=49.9u rfmode=0
M$10829 \$462 \$462 \$462 VGND sg13_lv_nmos L=0.13u W=2.4u AS=0.816p AD=0.816p
+ PS=6.16u PD=6.16u rfmode=0
M$10830 VGND VGND VGND VGND sg13_lv_nmos L=0.13u W=11u AS=3.74p AD=3.74p
+ PS=28.12u PD=28.12u rfmode=0
M$10831 \$462 \$549 VGND VGND sg13_lv_nmos L=0.13u W=6u AS=1.32p AD=1.32p
+ PS=9.4u PD=9.4u rfmode=0
M$10836 \$462 \$462 \$462 VPWR sg13_lv_pmos L=0.13u W=2.6u AS=0.884p AD=0.884p
+ PS=6.56u PD=6.56u rfmode=0
M$10838 \$462 \$549 VPWR VPWR sg13_lv_pmos L=0.13u W=13.5u AS=2.7675p
+ AD=2.7675p PS=18.95u PD=18.95u rfmode=0
M$10848 \$1100 \$1100 \$1100 VPWR sg13_lv_pmos L=0.13u W=0.95u AS=0.323p
+ AD=0.323p PS=3.26u PD=3.26u rfmode=0
M$10849 \$947 \$947 \$947 VPWR sg13_lv_pmos L=0.13u W=0.45u AS=0.153p AD=0.153p
+ PS=1.58u PD=1.58u rfmode=0
M$10850 \$947 \$1029 \$1100 VPWR sg13_lv_pmos L=0.13u W=4.5u AS=0.9225p
+ AD=0.9225p PS=9.05u PD=9.05u rfmode=0
M$10861 \$549 \$549 \$549 VPWR sg13_lv_pmos L=0.13u W=0.45u AS=0.153p AD=0.153p
+ PS=1.58u PD=1.58u rfmode=0
M$10862 \$549 \$947 VPWR VPWR sg13_lv_pmos L=0.13u W=4.5u AS=0.9225p AD=0.9225p
+ PS=9.05u PD=9.05u rfmode=0
M$10874 \$1100 \$1122 VPWR VPWR sg13_lv_pmos L=0.13u W=5u AS=1.025p AD=1.025p
+ PS=9.6u PD=9.6u rfmode=0
M$10885 \$1102 \$1102 \$1102 VGND sg13_lv_nmos L=0.13u W=1u AS=0.34p AD=0.34p
+ PS=3.36u PD=3.36u rfmode=0
M$10886 \$1102 \$1035 VGND VGND sg13_lv_nmos L=0.13u W=3u AS=0.66p AD=0.66p
+ PS=5.8u PD=5.8u rfmode=0
M$10892 analog_0 analog_0 analog_0 VGND sg13_lv_nmos L=0.13u W=4u AS=1.36p
+ AD=1.36p PS=8.68u PD=8.68u rfmode=0
M$10893 analog_0 \$56 VGND VGND sg13_lv_nmos L=0.13u W=80u AS=15.8p AD=15.8p
+ PS=91.9u PD=91.9u rfmode=0
M$10914 \$56 \$56 \$56 VGND sg13_lv_nmos L=0.13u W=1.8u AS=0.612p AD=0.612p
+ PS=4.28u PD=4.28u rfmode=0
M$10915 \$56 \$322 VGND VGND sg13_lv_nmos L=0.13u W=18u AS=3.69p AD=3.69p
+ PS=23.9u PD=23.9u rfmode=0
M$10925 \$549 \$549 \$549 VGND sg13_lv_nmos L=0.13u W=0.4u AS=0.136p AD=0.136p
+ PS=1.48u PD=1.48u rfmode=0
M$10927 \$549 \$947 VGND VGND sg13_lv_nmos L=0.13u W=2u AS=0.44p AD=0.44p
+ PS=4.6u PD=4.6u rfmode=0
M$10932 \$947 \$947 \$947 VGND sg13_lv_nmos L=0.13u W=0.4u AS=0.136p AD=0.136p
+ PS=1.48u PD=1.48u rfmode=0
M$10934 \$947 \$1029 \$1102 VGND sg13_lv_nmos L=0.13u W=2u AS=0.44p AD=0.44p
+ PS=4.6u PD=4.6u rfmode=0
M$10939 VAPWR VAPWR VAPWR VAPWR sg13_hv_pmos L=4u W=8u AS=2.72p AD=2.72p
+ PS=18.72u PD=18.72u rfmode=0
M$10940 \$468 \$312 VAPWR VAPWR sg13_hv_pmos L=4u W=2u AS=0.68p AD=0.68p
+ PS=4.68u PD=4.68u rfmode=0
M$10941 \$468 \$468 \$468 VAPWR sg13_hv_pmos L=4u W=2u AS=0.68p AD=0.68p
+ PS=4.68u PD=4.68u rfmode=0
M$10942 \$322 \$322 \$322 VGND sg13_lv_nmos L=0.13u W=2.4u AS=0.816p AD=0.816p
+ PS=6.16u PD=6.16u rfmode=0
M$10944 \$322 \$408 VGND VGND sg13_lv_nmos L=0.13u W=6u AS=1.32p AD=1.32p
+ PS=9.4u PD=9.4u rfmode=0
M$10949 \$322 \$322 \$322 VPWR sg13_lv_pmos L=0.13u W=2.6u AS=0.884p AD=0.884p
+ PS=6.56u PD=6.56u rfmode=0
M$10950 VGND VGND VGND VPWR sg13_lv_pmos L=0.13u W=1.3u AS=0.442p AD=0.442p
+ PS=3.28u PD=3.28u rfmode=0
M$10951 \$322 \$414 VGND VPWR sg13_lv_pmos L=0.13u W=13.5u AS=2.7675p
+ AD=2.7675p PS=18.95u PD=18.95u rfmode=0
M$10963 \$322 \$414 \$462 VGND sg13_lv_nmos L=0.13u W=6u AS=1.32p AD=1.32p
+ PS=9.4u PD=9.4u rfmode=0
M$10968 VGND VGND VGND VGND sg13_hv_nmos L=4u W=8u AS=2.72p AD=2.72p PS=18.72u
+ PD=18.72u rfmode=0
M$10969 q0 \$468 VGND VGND sg13_hv_nmos L=4u W=2u AS=0.68p AD=0.68p PS=4.68u
+ PD=4.68u rfmode=0
M$10970 q0 q0 q0 VGND sg13_hv_nmos L=4u W=2u AS=0.68p AD=0.68p PS=4.68u
+ PD=4.68u rfmode=0
M$10971 VPWR VPWR VPWR VPWR sg13_hv_pmos L=4u W=8u AS=2.72p AD=2.72p PS=18.72u
+ PD=18.72u rfmode=0
M$10972 q0 \$468 VPWR VPWR sg13_hv_pmos L=4u W=2u AS=0.68p AD=0.68p PS=4.68u
+ PD=4.68u rfmode=0
M$10973 q0 q0 q0 VPWR sg13_hv_pmos L=4u W=2u AS=0.68p AD=0.68p PS=4.68u
+ PD=4.68u rfmode=0
M$10974 \$247 \$247 \$247 VGND sg13_hv_nmos L=4u W=2u AS=0.68p AD=0.68p
+ PS=4.68u PD=4.68u rfmode=0
M$10975 \$468 \$312 \$247 VGND sg13_hv_nmos L=4u W=2u AS=0.68p AD=0.68p
+ PS=4.68u PD=4.68u rfmode=0
M$10976 \$468 \$468 \$468 VGND sg13_hv_nmos L=4u W=2u AS=0.68p AD=0.68p
+ PS=4.68u PD=4.68u rfmode=0
M$10979 \$322 \$408 \$462 VPWR sg13_lv_pmos L=0.13u W=13.5u AS=2.7675p
+ AD=2.7675p PS=18.95u PD=18.95u rfmode=0
M$10989 analog_0 analog_0 analog_0 VPWR sg13_lv_pmos L=0.13u W=4u AS=1.36p
+ AD=1.36p PS=8.68u PD=8.68u rfmode=0
M$10991 analog_0 \$56 VPWR VPWR sg13_lv_pmos L=0.13u W=200u AS=38.6p AD=38.6p
+ PS=223.3u PD=223.3u rfmode=0
M$11042 \$1264 \$1264 \$1264 VGND sg13_lv_nmos L=0.13u W=1u AS=0.34p AD=0.34p
+ PS=3.36u PD=3.36u rfmode=0
M$11043 \$1264 \$1035 VGND VGND sg13_lv_nmos L=0.13u W=3u AS=0.66p AD=0.66p
+ PS=5.8u PD=5.8u rfmode=0
M$11048 \$1261 \$1261 \$1261 VPWR sg13_lv_pmos L=0.13u W=0.95u AS=0.323p
+ AD=0.323p PS=3.26u PD=3.26u rfmode=0
M$11050 \$1261 \$1122 VPWR VPWR sg13_lv_pmos L=0.13u W=5u AS=1.025p AD=1.025p
+ PS=9.6u PD=9.6u rfmode=0
M$11061 \$1122 \$1122 \$1122 VPWR sg13_lv_pmos L=0.13u W=0.5u AS=0.17p AD=0.17p
+ PS=1.68u PD=1.68u rfmode=0
M$11062 VPWR \$1122 \$1122 VPWR sg13_lv_pmos L=0.13u W=5u AS=1.025p AD=1.025p
+ PS=9.6u PD=9.6u rfmode=0
M$11073 \$1191 \$1191 \$1191 VPWR sg13_lv_pmos L=0.13u W=0.45u AS=0.153p
+ AD=0.153p PS=1.58u PD=1.58u rfmode=0
M$11074 \$1191 \$947 \$1261 VPWR sg13_lv_pmos L=0.13u W=4.5u AS=0.9225p
+ AD=0.9225p PS=9.05u PD=9.05u rfmode=0
M$11084 \$1035 \$1035 \$1035 VPWR sg13_lv_pmos L=0.13u W=0.5u AS=0.17p AD=0.17p
+ PS=1.68u PD=1.68u rfmode=0
M$11086 \$1035 \$1122 VPWR VPWR sg13_lv_pmos L=0.13u W=5u AS=1.025p AD=1.025p
+ PS=9.6u PD=9.6u rfmode=0
M$11096 \$1122 \$1122 \$1122 VGND sg13_lv_nmos L=0.13u W=2u AS=0.68p AD=0.68p
+ PS=4.68u PD=4.68u rfmode=0
M$11097 \$1193 \$1193 \$1193 VGND sg13_lv_nmos L=0.13u W=2u AS=0.68p AD=0.68p
+ PS=4.68u PD=4.68u rfmode=0
M$11098 \$1193 \$1463 \$1122 VGND sg13_lv_nmos L=0.13u W=40u AS=7.9p AD=7.9p
+ PS=49.9u PD=49.9u rfmode=0
M$11118 \$1191 \$1191 \$1191 VGND sg13_lv_nmos L=0.13u W=0.4u AS=0.136p
+ AD=0.136p PS=1.48u PD=1.48u rfmode=0
M$11120 \$1191 \$947 \$1264 VGND sg13_lv_nmos L=0.13u W=2u AS=0.44p AD=0.44p
+ PS=4.6u PD=4.6u rfmode=0
M$11126 \$1035 \$1035 \$1035 VGND sg13_lv_nmos L=0.13u W=0.6u AS=0.204p
+ AD=0.204p PS=1.88u PD=1.88u rfmode=0
M$11127 \$1035 \$1035 VGND VGND sg13_lv_nmos L=0.13u W=3u AS=0.66p AD=0.66p
+ PS=5.8u PD=5.8u rfmode=0
M$11132 \$1189 \$1189 \$1189 VPWR sg13_lv_pmos L=0.13u W=0.95u AS=0.323p
+ AD=0.323p PS=3.26u PD=3.26u rfmode=0
M$11134 \$1189 \$1122 VPWR VPWR sg13_lv_pmos L=0.13u W=5u AS=1.025p AD=1.025p
+ PS=9.6u PD=9.6u rfmode=0
M$11145 \$1029 \$1029 \$1029 VPWR sg13_lv_pmos L=0.13u W=0.45u AS=0.153p
+ AD=0.153p PS=1.58u PD=1.58u rfmode=0
M$11146 \$1029 \$1191 \$1189 VPWR sg13_lv_pmos L=0.13u W=4.5u AS=0.9225p
+ AD=0.9225p PS=9.05u PD=9.05u rfmode=0
M$11157 \$1512 \$1368 VAPWR VAPWR sg13_hv_pmos L=4u W=2u AS=0.68p AD=0.68p
+ PS=4.68u PD=4.68u rfmode=0
M$11158 \$1512 \$1512 \$1512 VAPWR sg13_hv_pmos L=4u W=2u AS=0.68p AD=0.68p
+ PS=4.68u PD=4.68u rfmode=0
M$11159 \$1265 \$1265 \$1265 VGND sg13_hv_nmos L=4u W=2u AS=0.68p AD=0.68p
+ PS=4.68u PD=4.68u rfmode=0
M$11160 \$1512 \$1368 \$1265 VGND sg13_hv_nmos L=4u W=2u AS=0.68p AD=0.68p
+ PS=4.68u PD=4.68u rfmode=0
M$11161 \$1512 \$1512 \$1512 VGND sg13_hv_nmos L=4u W=2u AS=0.68p AD=0.68p
+ PS=4.68u PD=4.68u rfmode=0
M$11163 q1 \$1512 VPWR VPWR sg13_hv_pmos L=4u W=2u AS=0.68p AD=0.68p PS=4.68u
+ PD=4.68u rfmode=0
M$11164 q1 q1 q1 VPWR sg13_hv_pmos L=4u W=2u AS=0.68p AD=0.68p PS=4.68u
+ PD=4.68u rfmode=0
M$11166 q1 \$1512 VGND VGND sg13_hv_nmos L=4u W=2u AS=0.68p AD=0.68p PS=4.68u
+ PD=4.68u rfmode=0
M$11167 q1 q1 q1 VGND sg13_hv_nmos L=4u W=2u AS=0.68p AD=0.68p PS=4.68u
+ PD=4.68u rfmode=0
M$11168 \$1029 \$1029 \$1029 VGND sg13_lv_nmos L=0.13u W=0.4u AS=0.136p
+ AD=0.136p PS=1.48u PD=1.48u rfmode=0
M$11169 \$1192 \$1192 \$1192 VGND sg13_lv_nmos L=0.13u W=1u AS=0.34p AD=0.34p
+ PS=3.36u PD=3.36u rfmode=0
M$11170 \$1029 \$1191 \$1192 VGND sg13_lv_nmos L=0.13u W=2u AS=0.44p AD=0.44p
+ PS=4.6u PD=4.6u rfmode=0
M$11177 \$1192 \$1035 VGND VGND sg13_lv_nmos L=0.13u W=3u AS=0.66p AD=0.66p
+ PS=5.8u PD=5.8u rfmode=0
M$11182 \$3056 \$3056 \$3056 VAPWR sg13_hv_pmos L=0.5u W=4u AS=1.36p AD=1.36p
+ PS=8.68u PD=8.68u rfmode=0
M$11183 \$1269 \$1269 \$1269 VAPWR sg13_hv_pmos L=0.5u W=4u AS=1.36p AD=1.36p
+ PS=8.68u PD=8.68u rfmode=0
M$11184 \$2053 \$2053 \$2053 VAPWR sg13_hv_pmos L=0.5u W=4u AS=1.36p AD=1.36p
+ PS=8.68u PD=8.68u rfmode=0
M$11185 \$252 \$252 \$252 VAPWR sg13_hv_pmos L=0.5u W=4u AS=1.36p AD=1.36p
+ PS=8.68u PD=8.68u rfmode=0
M$11186 \$3056 \$3056 VAPWR VAPWR sg13_hv_pmos L=0.5u W=4u AS=1.36p AD=1.36p
+ PS=8.68u PD=8.68u rfmode=0
M$11187 \$1269 \$1269 VAPWR VAPWR sg13_hv_pmos L=0.5u W=4u AS=1.36p AD=1.36p
+ PS=8.68u PD=8.68u rfmode=0
M$11188 \$2053 \$2053 VAPWR VAPWR sg13_hv_pmos L=0.5u W=4u AS=1.36p AD=1.36p
+ PS=8.68u PD=8.68u rfmode=0
M$11189 \$252 \$252 VAPWR VAPWR sg13_hv_pmos L=0.5u W=4u AS=1.36p AD=1.36p
+ PS=8.68u PD=8.68u rfmode=0
M$11190 VAPWR VAPWR VAPWR VAPWR sg13_hv_pmos L=0.5u W=60u AS=20.4p AD=20.4p
+ PS=134.96u PD=134.96u rfmode=0
M$11195 q3 \$3271 VPWR VPWR sg13_hv_pmos L=4u W=2u AS=0.68p AD=0.68p PS=4.68u
+ PD=4.68u rfmode=0
M$11196 q3 q3 q3 VPWR sg13_hv_pmos L=4u W=2u AS=0.68p AD=0.68p PS=4.68u
+ PD=4.68u rfmode=0
M$11198 q3 \$3271 VGND VGND sg13_hv_nmos L=4u W=2u AS=0.68p AD=0.68p PS=4.68u
+ PD=4.68u rfmode=0
M$11199 q3 q3 q3 VGND sg13_hv_nmos L=4u W=2u AS=0.68p AD=0.68p PS=4.68u
+ PD=4.68u rfmode=0
M$11201 \$3271 \$3153 VAPWR VAPWR sg13_hv_pmos L=4u W=2u AS=0.68p AD=0.68p
+ PS=4.68u PD=4.68u rfmode=0
M$11202 \$3271 \$3271 \$3271 VAPWR sg13_hv_pmos L=4u W=2u AS=0.68p AD=0.68p
+ PS=4.68u PD=4.68u rfmode=0
M$11203 \$3052 \$3052 \$3052 VGND sg13_hv_nmos L=4u W=2u AS=0.68p AD=0.68p
+ PS=4.68u PD=4.68u rfmode=0
M$11204 \$3271 \$3153 \$3052 VGND sg13_hv_nmos L=4u W=2u AS=0.68p AD=0.68p
+ PS=4.68u PD=4.68u rfmode=0
M$11205 \$3271 \$3271 \$3271 VGND sg13_hv_nmos L=4u W=2u AS=0.68p AD=0.68p
+ PS=4.68u PD=4.68u rfmode=0
M$11206 \$4253 \$4253 \$4253 VAPWR sg13_hv_pmos L=0.5u W=2u AS=0.68p AD=0.68p
+ PS=4.68u PD=4.68u rfmode=0
M$11208 \$4253 \$4253 VAPWR VAPWR sg13_hv_pmos L=0.5u W=14u AS=2.96p AD=2.96p
+ PS=18.96u PD=18.96u rfmode=0
M$11215 \$4162 \$4162 \$4162 VAPWR sg13_hv_pmos L=0.5u W=2u AS=0.68p AD=0.68p
+ PS=4.68u PD=4.68u rfmode=0
M$11217 \$4162 \$4253 VAPWR VAPWR sg13_hv_pmos L=0.5u W=14u AS=2.96p AD=2.96p
+ PS=18.96u PD=18.96u rfmode=0
M$11224 \$1276 \$1276 \$1276 VGND sg13_hv_nmos L=0.5u W=0.5u AS=0.17p AD=0.17p
+ PS=1.68u PD=1.68u rfmode=0
M$11225 \$3065 \$3065 \$3065 VGND sg13_hv_nmos L=0.5u W=0.5u AS=0.17p AD=0.17p
+ PS=1.68u PD=1.68u rfmode=0
M$11226 \$4520 \$4520 \$4520 VGND sg13_hv_nmos L=0.5u W=0.5u AS=0.17p AD=0.17p
+ PS=1.68u PD=1.68u rfmode=0
M$11227 \$1276 \$1276 VGND VGND sg13_hv_nmos L=0.5u W=0.5u AS=0.17p AD=0.17p
+ PS=1.68u PD=1.68u rfmode=0
M$11228 \$3065 \$3065 VGND VGND sg13_hv_nmos L=0.5u W=0.5u AS=0.17p AD=0.17p
+ PS=1.68u PD=1.68u rfmode=0
M$11229 \$4520 \$4520 VGND VGND sg13_hv_nmos L=0.5u W=0.5u AS=0.17p AD=0.17p
+ PS=1.68u PD=1.68u rfmode=0
M$11233 \$3164 \$3164 \$3164 VAPWR sg13_hv_pmos L=0.5u W=2u AS=0.68p AD=0.68p
+ PS=4.68u PD=4.68u rfmode=0
M$11234 \$4576 \$4576 \$4576 VAPWR sg13_hv_pmos L=0.5u W=2u AS=0.68p AD=0.68p
+ PS=4.68u PD=4.68u rfmode=0
M$11235 \$1445 \$1445 \$1445 VAPWR sg13_hv_pmos L=0.5u W=2u AS=0.68p AD=0.68p
+ PS=4.68u PD=4.68u rfmode=0
M$11239 \$3164 \$3164 VAPWR VAPWR sg13_hv_pmos L=0.5u W=14u AS=2.96p AD=2.96p
+ PS=18.96u PD=18.96u rfmode=0
M$11246 \$4576 \$4576 VAPWR VAPWR sg13_hv_pmos L=0.5u W=14u AS=2.96p AD=2.96p
+ PS=18.96u PD=18.96u rfmode=0
M$11253 \$1445 \$1445 VAPWR VAPWR sg13_hv_pmos L=0.5u W=14u AS=2.96p AD=2.96p
+ PS=18.96u PD=18.96u rfmode=0
M$11260 \$1104 \$1104 \$1104 VGND sg13_hv_nmos L=0.5u W=1.5u AS=0.51p AD=0.51p
+ PS=4.36u PD=4.36u rfmode=0
M$11261 \$2945 \$2945 \$2945 VGND sg13_hv_nmos L=0.5u W=1.5u AS=0.51p AD=0.51p
+ PS=4.36u PD=4.36u rfmode=0
M$11262 \$4322 \$4322 \$4322 VGND sg13_hv_nmos L=0.5u W=1.5u AS=0.51p AD=0.51p
+ PS=4.36u PD=4.36u rfmode=0
M$11263 \$1104 \$1276 VGND VGND sg13_hv_nmos L=0.5u W=0.5u AS=0.17p AD=0.17p
+ PS=1.68u PD=1.68u rfmode=0
M$11264 \$2945 \$3065 VGND VGND sg13_hv_nmos L=0.5u W=0.5u AS=0.17p AD=0.17p
+ PS=1.68u PD=1.68u rfmode=0
M$11265 \$4322 \$4520 VGND VGND sg13_hv_nmos L=0.5u W=0.5u AS=0.17p AD=0.17p
+ PS=1.68u PD=1.68u rfmode=0
M$11269 \$4322 \$4322 \$4322 VAPWR sg13_hv_pmos L=0.5u W=2.7u AS=0.918p
+ AD=0.918p PS=6.76u PD=6.76u rfmode=0
M$11270 \$2945 \$2945 \$2945 VAPWR sg13_hv_pmos L=0.5u W=2.7u AS=0.918p
+ AD=0.918p PS=6.76u PD=6.76u rfmode=0
M$11271 \$1104 \$1104 \$1104 VAPWR sg13_hv_pmos L=0.5u W=2.7u AS=0.918p
+ AD=0.918p PS=6.76u PD=6.76u rfmode=0
M$11275 \$4322 \$4576 VAPWR VAPWR sg13_hv_pmos L=0.5u W=14u AS=2.96p AD=2.96p
+ PS=18.96u PD=18.96u rfmode=0
M$11282 \$2945 \$3164 VAPWR VAPWR sg13_hv_pmos L=0.5u W=14u AS=2.96p AD=2.96p
+ PS=18.96u PD=18.96u rfmode=0
M$11289 \$1104 \$1445 VAPWR VAPWR sg13_hv_pmos L=0.5u W=14u AS=2.96p AD=2.96p
+ PS=18.96u PD=18.96u rfmode=0
M$11296 \$800 \$800 \$800 VGND sg13_hv_nmos L=0.5u W=0.5u AS=0.17p AD=0.17p
+ PS=1.68u PD=1.68u rfmode=0
M$11297 \$2575 \$2575 \$2575 VGND sg13_hv_nmos L=0.5u W=0.5u AS=0.17p AD=0.17p
+ PS=1.68u PD=1.68u rfmode=0
M$11298 \$4328 \$4328 \$4328 VGND sg13_hv_nmos L=0.5u W=0.5u AS=0.17p AD=0.17p
+ PS=1.68u PD=1.68u rfmode=0
M$11299 \$800 \$1104 VGND VGND sg13_hv_nmos L=0.5u W=0.5u AS=0.17p AD=0.17p
+ PS=1.68u PD=1.68u rfmode=0
M$11300 \$2575 \$2945 VGND VGND sg13_hv_nmos L=0.5u W=0.5u AS=0.17p AD=0.17p
+ PS=1.68u PD=1.68u rfmode=0
M$11301 \$4328 \$4322 VGND VGND sg13_hv_nmos L=0.5u W=0.5u AS=0.17p AD=0.17p
+ PS=1.68u PD=1.68u rfmode=0
M$11305 VGND VGND VGND VAPWR sg13_hv_pmos L=0.5u W=2.1u AS=0.714p AD=0.714p
+ PS=6.24u PD=6.24u rfmode=0
M$11308 VGND \$398 \$1104 VAPWR sg13_hv_pmos L=0.5u W=0.7u AS=0.238p AD=0.238p
+ PS=2.08u PD=2.08u rfmode=0
M$11309 VGND \$4166 \$4322 VAPWR sg13_hv_pmos L=0.5u W=0.7u AS=0.238p AD=0.238p
+ PS=2.08u PD=2.08u rfmode=0
M$11310 VGND \$2058 \$2945 VAPWR sg13_hv_pmos L=0.5u W=0.7u AS=0.238p AD=0.238p
+ PS=2.08u PD=2.08u rfmode=0
M$11314 \$3059 \$3059 \$3059 VGND sg13_hv_nmos L=0.5u W=2u AS=0.68p AD=0.68p
+ PS=5.36u PD=5.36u rfmode=0
M$11315 \$4515 \$4515 \$4515 VGND sg13_hv_nmos L=0.5u W=2u AS=0.68p AD=0.68p
+ PS=5.36u PD=5.36u rfmode=0
M$11316 \$1273 \$1273 \$1273 VGND sg13_hv_nmos L=0.5u W=2u AS=0.68p AD=0.68p
+ PS=5.36u PD=5.36u rfmode=0
M$11320 \$2945 VAPWR \$3059 VGND sg13_hv_nmos L=0.5u W=2u AS=0.53p AD=0.53p
+ PS=4.06u PD=4.06u rfmode=0
M$11322 \$4322 VAPWR \$4515 VGND sg13_hv_nmos L=0.5u W=2u AS=0.53p AD=0.53p
+ PS=4.06u PD=4.06u rfmode=0
M$11324 \$1104 VAPWR \$1273 VGND sg13_hv_nmos L=0.5u W=2u AS=0.53p AD=0.53p
+ PS=4.06u PD=4.06u rfmode=0
M$11332 \$1273 analog_2 VGND VGND sg13_hv_nmos L=0.5u W=18u AS=3.57p AD=3.57p
+ PS=26.14u PD=26.14u rfmode=0
M$11350 \$3059 \$1721 VGND VGND sg13_hv_nmos L=0.5u W=18u AS=3.57p AD=3.57p
+ PS=26.14u PD=26.14u rfmode=0
M$11368 \$4515 \$3526 VGND VGND sg13_hv_nmos L=0.5u W=18u AS=3.57p AD=3.57p
+ PS=26.14u PD=26.14u rfmode=0
M$11386 \$951 \$951 \$951 VGND sg13_hv_nmos L=0.5u W=1u AS=0.34p AD=0.34p
+ PS=2.68u PD=2.68u rfmode=0
M$11387 \$2809 \$2809 \$2809 VGND sg13_hv_nmos L=0.5u W=1u AS=0.34p AD=0.34p
+ PS=2.68u PD=2.68u rfmode=0
M$11388 \$4418 \$4418 \$4418 VGND sg13_hv_nmos L=0.5u W=1u AS=0.34p AD=0.34p
+ PS=2.68u PD=2.68u rfmode=0
M$11392 \$951 \$951 VGND VGND sg13_hv_nmos L=0.5u W=2u AS=0.53p AD=0.53p
+ PS=4.06u PD=4.06u rfmode=0
M$11394 \$2809 \$2809 VGND VGND sg13_hv_nmos L=0.5u W=2u AS=0.53p AD=0.53p
+ PS=4.06u PD=4.06u rfmode=0
M$11396 \$4418 \$4418 VGND VGND sg13_hv_nmos L=0.5u W=2u AS=0.53p AD=0.53p
+ PS=4.06u PD=4.06u rfmode=0
M$11398 VAPWR VAPWR VAPWR VGND sg13_hv_nmos L=0.5u W=4.5u AS=1.53p AD=1.53p
+ PS=11.04u PD=11.04u rfmode=0
M$11401 VAPWR \$2575 \$2058 VGND sg13_hv_nmos L=0.5u W=1.5u AS=0.51p AD=0.51p
+ PS=3.68u PD=3.68u rfmode=0
M$11402 VAPWR \$4328 \$4166 VGND sg13_hv_nmos L=0.5u W=1.5u AS=0.51p AD=0.51p
+ PS=3.68u PD=3.68u rfmode=0
M$11403 VAPWR \$800 \$398 VGND sg13_hv_nmos L=0.5u W=1.5u AS=0.51p AD=0.51p
+ PS=3.68u PD=3.68u rfmode=0
M$11404 \$2058 \$2058 \$2058 VGND sg13_hv_nmos L=0.5u W=3.5u AS=1.19p AD=1.19p
+ PS=8.36u PD=8.36u rfmode=0
M$11405 \$4166 \$4166 \$4166 VGND sg13_hv_nmos L=0.5u W=3.5u AS=1.19p AD=1.19p
+ PS=8.36u PD=8.36u rfmode=0
M$11406 \$398 \$398 \$398 VGND sg13_hv_nmos L=0.5u W=3.5u AS=1.19p AD=1.19p
+ PS=8.36u PD=8.36u rfmode=0
M$11410 \$255 \$255 \$255 VGND sg13_hv_nmos L=0.5u W=2u AS=0.68p AD=0.68p
+ PS=4.68u PD=4.68u rfmode=0
M$11411 \$1924 \$1924 \$1924 VGND sg13_hv_nmos L=0.5u W=2u AS=0.68p AD=0.68p
+ PS=4.68u PD=4.68u rfmode=0
M$11412 \$4053 \$4053 \$4053 VGND sg13_hv_nmos L=0.5u W=2u AS=0.68p AD=0.68p
+ PS=4.68u PD=4.68u rfmode=0
M$11413 \$255 \$255 VGND VGND sg13_hv_nmos L=0.5u W=10u AS=2.2p AD=2.2p
+ PS=14.2u PD=14.2u rfmode=0
M$11418 \$1924 \$1924 VGND VGND sg13_hv_nmos L=0.5u W=10u AS=2.2p AD=2.2p
+ PS=14.2u PD=14.2u rfmode=0
M$11423 \$4053 \$4053 VGND VGND sg13_hv_nmos L=0.5u W=10u AS=2.2p AD=2.2p
+ PS=14.2u PD=14.2u rfmode=0
M$11434 \$398 \$255 VGND VGND sg13_hv_nmos L=0.5u W=10u AS=2.2p AD=2.2p
+ PS=14.2u PD=14.2u rfmode=0
M$11439 \$2058 \$1924 VGND VGND sg13_hv_nmos L=0.5u W=10u AS=2.2p AD=2.2p
+ PS=14.2u PD=14.2u rfmode=0
M$11444 \$4166 \$4053 VGND VGND sg13_hv_nmos L=0.5u W=10u AS=2.2p AD=2.2p
+ PS=14.2u PD=14.2u rfmode=0
M$11450 \$2266 \$2150 VAPWR VAPWR sg13_hv_pmos L=4u W=2u AS=0.68p AD=0.68p
+ PS=4.68u PD=4.68u rfmode=0
M$11451 \$2266 \$2266 \$2266 VAPWR sg13_hv_pmos L=4u W=2u AS=0.68p AD=0.68p
+ PS=4.68u PD=4.68u rfmode=0
M$11455 \$2575 \$2575 \$2575 VAPWR sg13_hv_pmos L=0.5u W=2u AS=0.68p AD=0.68p
+ PS=4.68u PD=4.68u rfmode=0
M$11456 \$4328 \$4328 \$4328 VAPWR sg13_hv_pmos L=0.5u W=2u AS=0.68p AD=0.68p
+ PS=4.68u PD=4.68u rfmode=0
M$11457 \$800 \$800 \$800 VAPWR sg13_hv_pmos L=0.5u W=2u AS=0.68p AD=0.68p
+ PS=4.68u PD=4.68u rfmode=0
M$11458 \$2575 \$2055 VAPWR VAPWR sg13_hv_pmos L=0.5u W=14u AS=2.96p AD=2.96p
+ PS=18.96u PD=18.96u rfmode=0
M$11465 \$4328 \$4052 VAPWR VAPWR sg13_hv_pmos L=0.5u W=14u AS=2.96p AD=2.96p
+ PS=18.96u PD=18.96u rfmode=0
M$11472 \$800 \$254 VAPWR VAPWR sg13_hv_pmos L=0.5u W=14u AS=2.96p AD=2.96p
+ PS=18.96u PD=18.96u rfmode=0
M$11479 \$2055 \$2055 \$2055 VAPWR sg13_hv_pmos L=0.5u W=2u AS=0.68p AD=0.68p
+ PS=4.68u PD=4.68u rfmode=0
M$11480 \$4052 \$4052 \$4052 VAPWR sg13_hv_pmos L=0.5u W=2u AS=0.68p AD=0.68p
+ PS=4.68u PD=4.68u rfmode=0
M$11481 \$254 \$254 \$254 VAPWR sg13_hv_pmos L=0.5u W=2u AS=0.68p AD=0.68p
+ PS=4.68u PD=4.68u rfmode=0
M$11485 \$2055 \$2055 VAPWR VAPWR sg13_hv_pmos L=0.5u W=14u AS=2.96p AD=2.96p
+ PS=18.96u PD=18.96u rfmode=0
M$11492 \$4052 \$4052 VAPWR VAPWR sg13_hv_pmos L=0.5u W=14u AS=2.96p AD=2.96p
+ PS=18.96u PD=18.96u rfmode=0
M$11499 \$254 \$254 VAPWR VAPWR sg13_hv_pmos L=0.5u W=14u AS=2.96p AD=2.96p
+ PS=18.96u PD=18.96u rfmode=0
M$11507 q2 \$2266 VGND VGND sg13_hv_nmos L=4u W=2u AS=0.68p AD=0.68p PS=4.68u
+ PD=4.68u rfmode=0
M$11508 q2 q2 q2 VGND sg13_hv_nmos L=4u W=2u AS=0.68p AD=0.68p PS=4.68u
+ PD=4.68u rfmode=0
M$11509 \$2048 \$2048 \$2048 VGND sg13_hv_nmos L=4u W=2u AS=0.68p AD=0.68p
+ PS=4.68u PD=4.68u rfmode=0
M$11510 \$2266 \$2150 \$2048 VGND sg13_hv_nmos L=4u W=2u AS=0.68p AD=0.68p
+ PS=4.68u PD=4.68u rfmode=0
M$11511 \$2266 \$2266 \$2266 VGND sg13_hv_nmos L=4u W=2u AS=0.68p AD=0.68p
+ PS=4.68u PD=4.68u rfmode=0
M$11513 q2 \$2266 VPWR VPWR sg13_hv_pmos L=4u W=2u AS=0.68p AD=0.68p PS=4.68u
+ PD=4.68u rfmode=0
M$11514 q2 q2 q2 VPWR sg13_hv_pmos L=4u W=2u AS=0.68p AD=0.68p PS=4.68u
+ PD=4.68u rfmode=0
M$11519 \$3160 \$3056 VAPWR VAPWR sg13_hv_pmos L=0.5u W=4u AS=1.36p AD=1.36p
+ PS=8.68u PD=8.68u rfmode=0
M$11520 \$2153 \$2053 VAPWR VAPWR sg13_hv_pmos L=0.5u W=4u AS=1.36p AD=1.36p
+ PS=8.68u PD=8.68u rfmode=0
M$11521 \$1369 \$1269 VAPWR VAPWR sg13_hv_pmos L=0.5u W=4u AS=1.36p AD=1.36p
+ PS=8.68u PD=8.68u rfmode=0
M$11522 \$313 \$252 VAPWR VAPWR sg13_hv_pmos L=0.5u W=4u AS=1.36p AD=1.36p
+ PS=8.68u PD=8.68u rfmode=0
.ENDS heichips26_ook_top

.SUBCKT sg13cmos5l_or4_1 VDD VSS B D A C X
M$1 VSS D \$7 VSS sg13_lv_nmos L=0.13u W=0.55u AS=0.187p AD=0.1045p PS=1.78u
+ PD=0.93u rfmode=0
M$2 VSS C \$7 VSS sg13_lv_nmos L=0.13u W=0.55u AS=0.16755p AD=0.1045p PS=1.165u
+ PD=0.93u rfmode=0
M$3 VSS B \$7 VSS sg13_lv_nmos L=0.13u W=0.55u AS=0.16755p AD=0.1045p PS=1.165u
+ PD=0.93u rfmode=0
M$4 VSS A \$7 VSS sg13_lv_nmos L=0.13u W=0.55u AS=0.14135p AD=0.1045p PS=1.14u
+ PD=0.93u rfmode=0
M$5 VSS \$7 X VSS sg13_lv_nmos L=0.13u W=0.74u AS=0.14135p AD=0.2516p PS=1.14u
+ PD=2.16u rfmode=0
M$6 \$7 D \$11 VDD sg13_lv_pmos L=0.13u W=1u AS=0.34p AD=0.19p PS=2.68u
+ PD=1.38u rfmode=0
M$7 \$11 C \$10 VDD sg13_lv_pmos L=0.13u W=1u AS=0.19p AD=0.2925p PS=1.38u
+ PD=1.585u rfmode=0
M$8 \$10 B \$9 VDD sg13_lv_pmos L=0.13u W=1u AS=0.2925p AD=0.19p PS=1.585u
+ PD=1.38u rfmode=0
M$9 VDD A \$9 VDD sg13_lv_pmos L=0.13u W=1u AS=0.2144p AD=0.19p PS=1.52u
+ PD=1.38u rfmode=0
M$10 VDD \$7 X VDD sg13_lv_pmos L=0.13u W=1.12u AS=0.2144p AD=0.3808p PS=1.52u
+ PD=2.92u rfmode=0
.ENDS sg13cmos5l_or4_1

.SUBCKT sg13cmos5l_tielo VSS L_LO VDD
M$1 VSS \$6 \$5 VSS sg13_lv_nmos L=0.13u W=0.385u AS=0.305425p AD=0.1309p
+ PS=2.07u PD=1.45u rfmode=0
M$2 VSS \$2 L_LO VSS sg13_lv_nmos L=0.13u W=0.88u AS=0.305425p AD=0.2992p
+ PS=2.07u PD=2.44u rfmode=0
M$3 VDD \$6 \$6 VDD sg13_lv_pmos L=0.13u W=0.3u AS=0.326925p AD=0.102p
+ PS=2.255u PD=1.28u rfmode=0
M$4 VDD \$5 \$2 VDD sg13_lv_pmos L=0.13u W=1.045u AS=0.326925p AD=0.3553p
+ PS=2.255u PD=2.77u rfmode=0
.ENDS sg13cmos5l_tielo

.SUBCKT sg13cmos5l_nand4_1 VDD A VSS Y B C D
M$1 VSS D \$10 VSS sg13_lv_nmos L=0.13u W=0.74u AS=0.2516p AD=0.1406p PS=2.16u
+ PD=1.12u rfmode=0
M$2 \$10 C \$9 VSS sg13_lv_nmos L=0.13u W=0.74u AS=0.1406p AD=0.1406p PS=1.12u
+ PD=1.12u rfmode=0
M$3 \$9 B \$8 VSS sg13_lv_nmos L=0.13u W=0.74u AS=0.1406p AD=0.1406p PS=1.12u
+ PD=1.12u rfmode=0
M$4 \$8 A Y VSS sg13_lv_nmos L=0.13u W=0.74u AS=0.1406p AD=0.2516p PS=1.12u
+ PD=2.16u rfmode=0
M$5 VDD D Y VDD sg13_lv_pmos L=0.13u W=1.12u AS=0.3808p AD=0.2128p PS=2.92u
+ PD=1.5u rfmode=0
M$6 Y C VDD VDD sg13_lv_pmos L=0.13u W=1.12u AS=0.2128p AD=0.2128p PS=1.5u
+ PD=1.5u rfmode=0
M$7 VDD B Y VDD sg13_lv_pmos L=0.13u W=1.12u AS=0.2128p AD=0.2128p PS=1.5u
+ PD=1.5u rfmode=0
M$8 Y A VDD VDD sg13_lv_pmos L=0.13u W=1.12u AS=0.2128p AD=0.3808p PS=1.5u
+ PD=2.92u rfmode=0
.ENDS sg13cmos5l_nand4_1

.SUBCKT sg13cmos5l_mux2_1 VSS X S A1 A0 VDD
M$1 VSS S \$2 VSS sg13_lv_nmos L=0.13u W=0.55u AS=0.18945p AD=0.187p PS=1.27u
+ PD=1.78u rfmode=0
M$2 VSS S \$8 VSS sg13_lv_nmos L=0.13u W=0.74u AS=0.18945p AD=0.13135p PS=1.27u
+ PD=1.095u rfmode=0
M$3 \$8 A1 \$3 VSS sg13_lv_nmos L=0.13u W=0.74u AS=0.13135p AD=0.1628p
+ PS=1.095u PD=1.18u rfmode=0
M$4 \$3 A0 \$9 VSS sg13_lv_nmos L=0.13u W=0.74u AS=0.1628p AD=0.3367p PS=1.18u
+ PD=1.65u rfmode=0
M$5 \$9 \$2 VSS VSS sg13_lv_nmos L=0.13u W=0.74u AS=0.3367p AD=0.148p PS=1.65u
+ PD=1.14u rfmode=0
M$6 VSS \$3 X VSS sg13_lv_nmos L=0.13u W=0.74u AS=0.148p AD=0.4033p PS=1.14u
+ PD=2.57u rfmode=0
M$7 \$2 S VDD VDD sg13_lv_pmos L=0.13u W=0.84u AS=0.2856p AD=0.253p PS=2.36u
+ PD=1.53u rfmode=0
M$8 VDD S \$10 VDD sg13_lv_pmos L=0.13u W=1u AS=0.253p AD=0.3325p PS=1.53u
+ PD=1.665u rfmode=0
M$9 \$10 A0 \$3 VDD sg13_lv_pmos L=0.13u W=1u AS=0.3325p AD=0.2225p PS=1.665u
+ PD=1.445u rfmode=0
M$10 \$3 A1 \$11 VDD sg13_lv_pmos L=0.13u W=1u AS=0.2225p AD=0.2975p PS=1.445u
+ PD=1.595u rfmode=0
M$11 \$11 \$2 VDD VDD sg13_lv_pmos L=0.13u W=1u AS=0.2975p AD=0.2198p PS=1.595u
+ PD=1.52u rfmode=0
M$12 VDD \$3 X VDD sg13_lv_pmos L=0.13u W=1.12u AS=0.2198p AD=0.6048p PS=1.52u
+ PD=3.32u rfmode=0
.ENDS sg13cmos5l_mux2_1

.SUBCKT sg13cmos5l_nand3_1 VSS VDD Y B C A
M$1 VSS C \$8 VSS sg13_lv_nmos L=0.13u W=0.74u AS=0.2886p AD=0.1406p PS=2.26u
+ PD=1.12u rfmode=0
M$2 \$8 B \$7 VSS sg13_lv_nmos L=0.13u W=0.74u AS=0.1406p AD=0.1406p PS=1.12u
+ PD=1.12u rfmode=0
M$3 \$7 A Y VSS sg13_lv_nmos L=0.13u W=0.74u AS=0.1406p AD=0.2516p PS=1.12u
+ PD=2.16u rfmode=0
M$4 VDD C Y VDD sg13_lv_pmos L=0.13u W=1.12u AS=0.3808p AD=0.2128p PS=2.92u
+ PD=1.5u rfmode=0
M$5 Y B VDD VDD sg13_lv_pmos L=0.13u W=1.12u AS=0.2128p AD=0.2128p PS=1.5u
+ PD=1.5u rfmode=0
M$6 VDD A Y VDD sg13_lv_pmos L=0.13u W=1.12u AS=0.2128p AD=0.3808p PS=1.5u
+ PD=2.92u rfmode=0
.ENDS sg13cmos5l_nand3_1

.SUBCKT sg13cmos5l_nor4_1 VDD VSS B A C D Y
M$1 VSS A Y VSS sg13_lv_nmos L=0.13u W=0.74u AS=0.2516p AD=0.1406p PS=2.16u
+ PD=1.12u rfmode=0
M$2 Y B VSS VSS sg13_lv_nmos L=0.13u W=0.74u AS=0.1406p AD=0.1406p PS=1.12u
+ PD=1.12u rfmode=0
M$3 VSS C Y VSS sg13_lv_nmos L=0.13u W=0.74u AS=0.1406p AD=0.1406p PS=1.12u
+ PD=1.12u rfmode=0
M$4 Y D VSS VSS sg13_lv_nmos L=0.13u W=0.74u AS=0.1406p AD=0.237575p PS=1.12u
+ PD=2.16u rfmode=0
M$5 VDD A \$9 VDD sg13_lv_pmos L=0.13u W=1.12u AS=0.3808p AD=0.2128p PS=2.92u
+ PD=1.5u rfmode=0
M$6 \$9 B \$8 VDD sg13_lv_pmos L=0.13u W=1.12u AS=0.2128p AD=0.2128p PS=1.5u
+ PD=1.5u rfmode=0
M$7 \$8 C \$10 VDD sg13_lv_pmos L=0.13u W=1.12u AS=0.2128p AD=0.2128p PS=1.5u
+ PD=1.5u rfmode=0
M$8 \$10 D Y VDD sg13_lv_pmos L=0.13u W=1.12u AS=0.2128p AD=0.4368p PS=1.5u
+ PD=3.02u rfmode=0
.ENDS sg13cmos5l_nor4_1

.SUBCKT sg13cmos5l_or2_1 A X B VDD VSS
M$1 VSS B \$6 VSS sg13_lv_nmos L=0.13u W=0.55u AS=0.187p AD=0.1045p PS=1.78u
+ PD=0.93u rfmode=0
M$2 \$6 A VSS VSS sg13_lv_nmos L=0.13u W=0.55u AS=0.1045p AD=0.1469p PS=0.93u
+ PD=1.155u rfmode=0
M$3 VSS \$6 X VSS sg13_lv_nmos L=0.13u W=0.74u AS=0.1469p AD=0.2516p PS=1.155u
+ PD=2.16u rfmode=0
M$4 \$6 B \$7 VDD sg13_lv_pmos L=0.13u W=0.84u AS=0.2856p AD=0.1596p PS=2.36u
+ PD=1.22u rfmode=0
M$5 VDD A \$7 VDD sg13_lv_pmos L=0.13u W=0.84u AS=0.2226p AD=0.1596p PS=1.535u
+ PD=1.22u rfmode=0
M$6 VDD \$6 X VDD sg13_lv_pmos L=0.13u W=1.12u AS=0.2226p AD=0.3976p PS=1.535u
+ PD=2.95u rfmode=0
.ENDS sg13cmos5l_or2_1

.SUBCKT sg13cmos5l_nor2b_1 VSS VDD Y A B_N
M$1 VSS B_N \$5 VSS sg13_lv_nmos L=0.13u W=0.55u AS=0.17255p AD=0.187p PS=1.25u
+ PD=1.78u rfmode=0
M$2 VSS \$5 Y VSS sg13_lv_nmos L=0.13u W=0.74u AS=0.17255p AD=0.1406p PS=1.25u
+ PD=1.12u rfmode=0
M$3 Y A VSS VSS sg13_lv_nmos L=0.13u W=0.74u AS=0.1406p AD=0.2516p PS=1.12u
+ PD=2.16u rfmode=0
M$4 \$5 B_N VDD VDD sg13_lv_pmos L=0.13u W=0.84u AS=0.2856p AD=0.2618p PS=2.36u
+ PD=1.63u rfmode=0
M$5 VDD \$5 \$7 VDD sg13_lv_pmos L=0.13u W=1.12u AS=0.2618p AD=0.1176p PS=1.63u
+ PD=1.33u rfmode=0
M$6 \$7 A Y VDD sg13_lv_pmos L=0.13u W=1.12u AS=0.1176p AD=0.3808p PS=1.33u
+ PD=2.92u rfmode=0
.ENDS sg13cmos5l_nor2b_1

.SUBCKT sg13cmos5l_and2_1 VDD VSS X A B
M$1 \$4 A \$7 VSS sg13_lv_nmos L=0.13u W=0.64u AS=0.2176p AD=0.1216p PS=1.96u
+ PD=1.02u rfmode=0
M$2 VSS B \$7 VSS sg13_lv_nmos L=0.13u W=0.64u AS=0.1331p AD=0.1216p PS=1.12u
+ PD=1.02u rfmode=0
M$3 VSS \$4 X VSS sg13_lv_nmos L=0.13u W=0.74u AS=0.1331p AD=0.2516p PS=1.12u
+ PD=2.16u rfmode=0
M$4 VDD A \$4 VDD sg13_lv_pmos L=0.13u W=0.84u AS=0.2856p AD=0.1596p PS=2.36u
+ PD=1.22u rfmode=0
M$5 VDD B \$4 VDD sg13_lv_pmos L=0.13u W=0.84u AS=0.1918p AD=0.1596p PS=1.5u
+ PD=1.22u rfmode=0
M$6 VDD \$4 X VDD sg13_lv_pmos L=0.13u W=1.12u AS=0.1918p AD=0.3808p PS=1.5u
+ PD=2.92u rfmode=0
.ENDS sg13cmos5l_and2_1

.SUBCKT sg13cmos5l_nor3_1 VDD VSS C Y B A
M$1 VSS A Y VSS sg13_lv_nmos L=0.13u W=0.77u AS=0.2618p AD=0.1694p PS=2.22u
+ PD=1.21u rfmode=0
M$2 Y B VSS VSS sg13_lv_nmos L=0.13u W=0.77u AS=0.1694p AD=0.1463p PS=1.21u
+ PD=1.15u rfmode=0
M$3 VSS C Y VSS sg13_lv_nmos L=0.13u W=0.77u AS=0.1463p AD=0.2618p PS=1.15u
+ PD=2.22u rfmode=0
M$4 VDD A \$8 VDD sg13_lv_pmos L=0.13u W=1.12u AS=0.3808p AD=0.2464p PS=2.92u
+ PD=1.56u rfmode=0
M$5 \$8 B \$7 VDD sg13_lv_pmos L=0.13u W=1.12u AS=0.2464p AD=0.2128p PS=1.56u
+ PD=1.5u rfmode=0
M$6 \$7 C Y VDD sg13_lv_pmos L=0.13u W=1.12u AS=0.2128p AD=0.3808p PS=1.5u
+ PD=2.92u rfmode=0
.ENDS sg13cmos5l_nor3_1

.SUBCKT sg13cmos5l_buf_8 VSS A X VDD
M$1 \$2 A VSS VSS sg13_lv_nmos L=0.13u W=2.22u AS=0.5365p AD=0.4218p PS=4.41u
+ PD=3.36u rfmode=0
M$4 VSS \$2 X VSS sg13_lv_nmos L=0.13u W=5.92u AS=1.1248p AD=1.2358p PS=8.96u
+ PD=10u rfmode=0
M$12 \$2 A VDD VDD sg13_lv_pmos L=0.13u W=3.36u AS=0.8064p AD=0.6384p PS=5.92u
+ PD=4.5u rfmode=0
M$15 VDD \$2 X VDD sg13_lv_pmos L=0.13u W=8.96u AS=1.7024p AD=1.876p PS=12u
+ PD=13.43u rfmode=0
.ENDS sg13cmos5l_buf_8

.SUBCKT sg13cmos5l_a22oi_1 Y VSS VDD A2 B2 B1 A1
M$1 VSS B1 \$10 VSS sg13_lv_nmos L=0.13u W=0.74u AS=0.2553p AD=0.13875p
+ PS=2.17u PD=1.115u rfmode=0
M$2 \$10 B2 Y VSS sg13_lv_nmos L=0.13u W=0.74u AS=0.13875p AD=0.2664p PS=1.115u
+ PD=1.46u rfmode=0
M$3 Y A1 \$9 VSS sg13_lv_nmos L=0.13u W=0.74u AS=0.2664p AD=0.0962p PS=1.46u
+ PD=1u rfmode=0
M$4 \$9 A2 VSS VSS sg13_lv_nmos L=0.13u W=0.74u AS=0.0962p AD=0.2516p PS=1u
+ PD=2.16u rfmode=0
M$5 VDD A1 \$5 VDD sg13_lv_pmos L=0.13u W=1.12u AS=0.3808p AD=0.2716p PS=2.92u
+ PD=1.605u rfmode=0
M$6 \$5 B1 Y VDD sg13_lv_pmos L=0.13u W=1.12u AS=0.2716p AD=0.2128p PS=1.605u
+ PD=1.5u rfmode=0
M$7 Y B2 \$5 VDD sg13_lv_pmos L=0.13u W=1.12u AS=0.2128p AD=0.2744p PS=1.5u
+ PD=1.61u rfmode=0
M$8 \$5 A2 VDD VDD sg13_lv_pmos L=0.13u W=1.12u AS=0.2744p AD=0.3808p PS=1.61u
+ PD=2.92u rfmode=0
.ENDS sg13cmos5l_a22oi_1

.SUBCKT sg13cmos5l_decap_4 VDD VSS
M$1 VSS VDD VSS VSS sg13_lv_nmos L=1u W=0.42u AS=0.1428p AD=0.1428p PS=1.52u
+ PD=1.52u rfmode=0
M$2 VDD VSS VDD VDD sg13_lv_pmos L=1u W=1u AS=0.34p AD=0.34p PS=2.68u PD=2.68u
+ rfmode=0
.ENDS sg13cmos5l_decap_4

.SUBCKT sg13cmos5l_xnor2_1 VDD VSS Y B A
M$1 VSS A \$8 VSS sg13_lv_nmos L=0.13u W=0.64u AS=0.2272p AD=0.0784p PS=1.99u
+ PD=0.885u rfmode=0
M$2 \$8 B \$7 VSS sg13_lv_nmos L=0.13u W=0.64u AS=0.0784p AD=0.2176p PS=0.885u
+ PD=1.96u rfmode=0
M$3 VSS A \$3 VSS sg13_lv_nmos L=0.13u W=0.74u AS=0.1898p AD=0.2516p PS=1.36u
+ PD=2.16u rfmode=0
M$4 VSS B \$3 VSS sg13_lv_nmos L=0.13u W=0.74u AS=0.1898p AD=0.1406p PS=1.36u
+ PD=1.12u rfmode=0
M$5 \$3 \$7 Y VSS sg13_lv_nmos L=0.13u W=0.74u AS=0.1406p AD=0.2516p PS=1.12u
+ PD=2.16u rfmode=0
M$6 VDD A \$7 VDD sg13_lv_pmos L=0.13u W=0.84u AS=0.4536p AD=0.1596p PS=2.76u
+ PD=1.22u rfmode=0
M$7 VDD B \$7 VDD sg13_lv_pmos L=0.13u W=0.84u AS=0.2891p AD=0.1596p PS=1.695u
+ PD=1.22u rfmode=0
M$8 VDD A \$9 VDD sg13_lv_pmos L=0.13u W=1.12u AS=0.2891p AD=0.1428p PS=1.695u
+ PD=1.375u rfmode=0
M$9 \$9 B Y VDD sg13_lv_pmos L=0.13u W=1.12u AS=0.1428p AD=0.2408p PS=1.375u
+ PD=1.55u rfmode=0
M$10 Y \$7 VDD VDD sg13_lv_pmos L=0.13u W=1.12u AS=0.2408p AD=0.3808p PS=1.55u
+ PD=2.92u rfmode=0
.ENDS sg13cmos5l_xnor2_1

.SUBCKT sg13cmos5l_a221oi_1 VSS B1 VDD Y B2 C1 A1 A2
M$1 Y A1 \$11 VSS sg13_lv_nmos L=0.13u W=0.74u AS=0.2516p AD=0.1406p PS=2.16u
+ PD=1.12u rfmode=0
M$2 \$11 A2 VSS VSS sg13_lv_nmos L=0.13u W=0.74u AS=0.1406p AD=0.2516p PS=1.12u
+ PD=2.16u rfmode=0
M$3 Y C1 VSS VSS sg13_lv_nmos L=0.13u W=0.74u AS=0.2516p AD=0.1406p PS=2.16u
+ PD=1.12u rfmode=0
M$4 VSS B2 \$12 VSS sg13_lv_nmos L=0.13u W=0.74u AS=0.1406p AD=0.1406p PS=1.12u
+ PD=1.12u rfmode=0
M$5 \$12 B1 Y VSS sg13_lv_nmos L=0.13u W=0.74u AS=0.1406p AD=0.2516p PS=1.12u
+ PD=2.16u rfmode=0
M$6 VDD A1 \$9 VDD sg13_lv_pmos L=0.13u W=1.12u AS=0.3808p AD=0.2128p PS=2.92u
+ PD=1.5u rfmode=0
M$7 \$9 A2 VDD VDD sg13_lv_pmos L=0.13u W=1.12u AS=0.2128p AD=0.3808p PS=1.5u
+ PD=2.92u rfmode=0
M$8 Y C1 \$6 VDD sg13_lv_pmos L=0.13u W=1.12u AS=0.3808p AD=0.2128p PS=2.92u
+ PD=1.5u rfmode=0
M$9 \$6 B2 \$9 VDD sg13_lv_pmos L=0.13u W=1.12u AS=0.2128p AD=0.2128p PS=1.5u
+ PD=1.5u rfmode=0
M$10 \$9 B1 \$6 VDD sg13_lv_pmos L=0.13u W=1.12u AS=0.2128p AD=0.3808p PS=1.5u
+ PD=2.92u rfmode=0
.ENDS sg13cmos5l_a221oi_1

.SUBCKT sg13cmos5l_or3_1 VDD VSS C A B X
M$1 \$6 C VSS VSS sg13_lv_nmos L=0.13u W=0.55u AS=0.187p AD=0.1045p PS=1.78u
+ PD=0.93u rfmode=0
M$2 VSS B \$6 VSS sg13_lv_nmos L=0.13u W=0.55u AS=0.1045p AD=0.198p PS=0.93u
+ PD=1.27u rfmode=0
M$3 \$6 A VSS VSS sg13_lv_nmos L=0.13u W=0.55u AS=0.198p AD=0.13395p PS=1.27u
+ PD=1.12u rfmode=0
M$4 VSS \$6 X VSS sg13_lv_nmos L=0.13u W=0.74u AS=0.13395p AD=0.2516p PS=1.12u
+ PD=2.16u rfmode=0
M$5 \$6 C \$9 VDD sg13_lv_pmos L=0.13u W=1u AS=0.34p AD=0.19p PS=2.68u PD=1.38u
+ rfmode=0
M$6 \$9 B \$8 VDD sg13_lv_pmos L=0.13u W=1u AS=0.19p AD=0.1575p PS=1.38u
+ PD=1.315u rfmode=0
M$7 \$8 A VDD VDD sg13_lv_pmos L=0.13u W=1u AS=0.1575p AD=0.3822p PS=1.315u
+ PD=1.84u rfmode=0
M$8 VDD \$6 X VDD sg13_lv_pmos L=0.13u W=1.12u AS=0.3822p AD=0.3808p PS=1.84u
+ PD=2.92u rfmode=0
.ENDS sg13cmos5l_or3_1

.SUBCKT sg13cmos5l_decap_8 VDD VSS
M$1 VSS VDD VSS VSS sg13_lv_nmos L=1u W=0.84u AS=0.2226p AD=0.2226p PS=2.32u
+ PD=2.32u rfmode=0
M$3 VDD VSS VDD VDD sg13_lv_pmos L=1u W=2u AS=0.53p AD=0.53p PS=4.06u PD=4.06u
+ rfmode=0
.ENDS sg13cmos5l_decap_8

.SUBCKT sg13cmos5l_nand2_1 VDD VSS Y A B
M$1 VSS B \$6 VSS sg13_lv_nmos L=0.13u W=0.74u AS=0.2516p AD=0.1406p PS=2.16u
+ PD=1.12u rfmode=0
M$2 \$6 A Y VSS sg13_lv_nmos L=0.13u W=0.74u AS=0.1406p AD=0.2516p PS=1.12u
+ PD=2.16u rfmode=0
M$3 VDD B Y VDD sg13_lv_pmos L=0.13u W=1.12u AS=0.3808p AD=0.2128p PS=2.92u
+ PD=1.5u rfmode=0
M$4 Y A VDD VDD sg13_lv_pmos L=0.13u W=1.12u AS=0.2128p AD=0.3808p PS=1.5u
+ PD=2.92u rfmode=0
.ENDS sg13cmos5l_nand2_1

.SUBCKT sg13cmos5l_tiehi L_HI VDD VSS
M$1 VSS \$5 \$5 VSS sg13_lv_nmos L=0.13u W=0.3u AS=0.2043375p AD=0.111p
+ PS=1.585u PD=1.34u rfmode=0
M$2 VSS \$3 \$1 VSS sg13_lv_nmos L=0.13u W=0.795u AS=0.2043375p AD=0.274275p
+ PS=1.585u PD=2.28u rfmode=0
M$3 \$3 \$5 VDD VDD sg13_lv_pmos L=0.13u W=0.66u AS=0.2442p AD=0.4657125p
+ PS=2.06u PD=2.54u rfmode=0
M$4 VDD \$1 L_HI VDD sg13_lv_pmos L=0.13u W=1.155u AS=0.4657125p AD=0.3927p
+ PS=2.54u PD=2.99u rfmode=0
.ENDS sg13cmos5l_tiehi

.SUBCKT sg13cmos5l_dfrbpq_1 VSS RESET_B Q D CLK VDD
M$1 VSS \$4 \$19 VSS sg13_lv_nmos L=0.13u W=0.74u AS=0.317325p AD=0.2516p
+ PS=1.805u PD=2.16u rfmode=0
M$2 VSS CLK \$4 VSS sg13_lv_nmos L=0.13u W=0.74u AS=0.317325p AD=0.2516p
+ PS=1.805u PD=2.16u rfmode=0
M$3 \$14 \$4 \$7 VSS sg13_lv_nmos L=0.13u W=0.42u AS=0.12665p AD=0.1428p
+ PS=1.145u PD=1.52u rfmode=0
M$4 \$3 \$19 \$14 VSS sg13_lv_nmos L=0.13u W=0.74u AS=0.3473p AD=0.12665p
+ PS=2.71u PD=1.145u rfmode=0
M$5 \$5 D \$15 VSS sg13_lv_nmos L=0.13u W=0.42u AS=0.1428p AD=0.0609p PS=1.52u
+ PD=0.71u rfmode=0
M$6 \$15 RESET_B VSS VSS sg13_lv_nmos L=0.13u W=0.42u AS=0.0609p AD=0.1626p
+ PS=0.71u PD=1.415u rfmode=0
M$7 VSS \$12 \$3 VSS sg13_lv_nmos L=0.13u W=0.74u AS=0.1626p AD=0.2516p
+ PS=1.415u PD=2.16u rfmode=0
M$8 \$9 \$14 VSS VSS sg13_lv_nmos L=0.13u W=0.74u AS=0.2516p AD=0.1406p
+ PS=2.16u PD=1.12u rfmode=0
M$9 VSS \$9 Q VSS sg13_lv_nmos L=0.13u W=0.74u AS=0.1406p AD=0.2516p PS=1.12u
+ PD=2.16u rfmode=0
M$10 \$5 \$4 \$12 VSS sg13_lv_nmos L=0.13u W=0.42u AS=0.1296p AD=0.0798p
+ PS=1.52u PD=0.8u rfmode=0
M$11 \$12 \$19 \$6 VSS sg13_lv_nmos L=0.13u W=0.42u AS=0.0798p AD=0.2373p
+ PS=0.8u PD=1.97u rfmode=0
M$12 \$7 \$8 VSS VSS sg13_lv_nmos L=0.13u W=0.42u AS=0.1428p AD=0.0798p
+ PS=1.52u PD=0.8u rfmode=0
M$13 VSS RESET_B \$17 VSS sg13_lv_nmos L=0.13u W=0.42u AS=0.0798p AD=0.0378p
+ PS=0.8u PD=0.6u rfmode=0
M$14 \$17 \$14 \$8 VSS sg13_lv_nmos L=0.13u W=0.42u AS=0.0378p AD=0.1428p
+ PS=0.6u PD=1.52u rfmode=0
M$15 VSS RESET_B \$16 VSS sg13_lv_nmos L=0.13u W=0.42u AS=0.1701p AD=0.0378p
+ PS=1.65u PD=0.6u rfmode=0
M$16 \$16 \$3 \$6 VSS sg13_lv_nmos L=0.13u W=0.42u AS=0.0378p AD=0.1428p
+ PS=0.6u PD=1.52u rfmode=0
M$17 \$14 \$19 \$21 VDD sg13_lv_pmos L=0.13u W=0.42u AS=0.2048p AD=0.09345p
+ PS=1.63u PD=0.865u rfmode=0
M$18 \$21 \$8 VDD VDD sg13_lv_pmos L=0.13u W=0.42u AS=0.09345p AD=0.204p
+ PS=0.865u PD=1.835u rfmode=0
M$19 VDD RESET_B \$8 VDD sg13_lv_pmos L=0.13u W=0.42u AS=0.204p AD=0.0798p
+ PS=1.835u PD=0.8u rfmode=0
M$20 \$8 \$14 VDD VDD sg13_lv_pmos L=0.13u W=0.42u AS=0.0798p AD=0.4659p
+ PS=0.8u PD=3.65u rfmode=0
M$21 \$3 \$4 \$14 VDD sg13_lv_pmos L=0.13u W=1u AS=0.34p AD=0.2048p PS=2.68u
+ PD=1.63u rfmode=0
M$22 \$9 \$14 VDD VDD sg13_lv_pmos L=0.13u W=1.12u AS=0.3864p AD=0.2128p
+ PS=2.93u PD=1.5u rfmode=0
M$23 VDD \$9 Q VDD sg13_lv_pmos L=0.13u W=1.12u AS=0.2128p AD=0.3808p PS=1.5u
+ PD=2.92u rfmode=0
M$24 VDD D \$5 VDD sg13_lv_pmos L=0.13u W=0.42u AS=0.1428p AD=0.0798p PS=1.52u
+ PD=0.8u rfmode=0
M$25 VDD RESET_B \$5 VDD sg13_lv_pmos L=0.13u W=0.42u AS=0.3623875p AD=0.0798p
+ PS=2.605u PD=0.8u rfmode=0
M$26 VDD \$12 \$3 VDD sg13_lv_pmos L=0.13u W=1u AS=0.3623875p AD=0.34p
+ PS=2.605u PD=2.68u rfmode=0
M$27 \$19 \$4 VDD VDD sg13_lv_pmos L=0.13u W=1.12u AS=0.3864p AD=0.41165p
+ PS=2.93u PD=2.12u rfmode=0
M$28 VDD CLK \$4 VDD sg13_lv_pmos L=0.13u W=1.12u AS=0.41165p AD=0.4088p
+ PS=2.12u PD=2.97u rfmode=0
M$29 \$12 RESET_B VDD VDD sg13_lv_pmos L=0.13u W=0.42u AS=0.147p AD=0.1563p
+ PS=1.54u PD=1.22u rfmode=0
M$30 VDD \$3 \$20 VDD sg13_lv_pmos L=0.13u W=0.42u AS=0.1563p AD=0.063p
+ PS=1.22u PD=0.72u rfmode=0
M$31 \$20 \$4 \$12 VDD sg13_lv_pmos L=0.13u W=0.42u AS=0.063p AD=0.0798p
+ PS=0.72u PD=0.8u rfmode=0
M$32 \$12 \$19 \$5 VDD sg13_lv_pmos L=0.13u W=0.42u AS=0.0798p AD=0.1428p
+ PS=0.8u PD=1.52u rfmode=0
.ENDS sg13cmos5l_dfrbpq_1

.SUBCKT sg13cmos5l_o21ai_1 VSS Y VDD B1 A2 A1
M$1 \$2 A1 VSS VSS sg13_lv_nmos L=0.15u W=0.74u AS=0.2516p AD=0.1406p PS=2.16u
+ PD=1.12u rfmode=0
M$2 VSS A2 \$2 VSS sg13_lv_nmos L=0.15u W=0.74u AS=0.1406p AD=0.1406p PS=1.12u
+ PD=1.12u rfmode=0
M$3 \$2 B1 Y VSS sg13_lv_nmos L=0.15u W=0.74u AS=0.1406p AD=0.2516p PS=1.12u
+ PD=2.16u rfmode=0
M$4 VDD A1 \$8 VDD sg13_lv_pmos L=0.15u W=1.12u AS=0.3808p AD=0.2128p PS=2.92u
+ PD=1.5u rfmode=0
M$5 \$8 A2 Y VDD sg13_lv_pmos L=0.15u W=1.12u AS=0.2128p AD=0.2128p PS=1.5u
+ PD=1.5u rfmode=0
M$6 Y B1 VDD VDD sg13_lv_pmos L=0.15u W=1.12u AS=0.2128p AD=0.3808p PS=1.5u
+ PD=2.92u rfmode=0
.ENDS sg13cmos5l_o21ai_1

.SUBCKT sg13cmos5l_nand3b_1 VDD VSS Y B C A_N
M$1 VSS A_N \$6 VSS sg13_lv_nmos L=0.13u W=0.55u AS=0.18575p AD=0.187p PS=1.26u
+ PD=1.78u rfmode=0
M$2 VSS C \$9 VSS sg13_lv_nmos L=0.13u W=0.74u AS=0.18575p AD=0.1406p PS=1.26u
+ PD=1.12u rfmode=0
M$3 \$9 B \$8 VSS sg13_lv_nmos L=0.13u W=0.74u AS=0.1406p AD=0.1406p PS=1.12u
+ PD=1.12u rfmode=0
M$4 \$8 \$6 Y VSS sg13_lv_nmos L=0.13u W=0.74u AS=0.1406p AD=0.3404p PS=1.12u
+ PD=2.4u rfmode=0
M$5 \$6 A_N VDD VDD sg13_lv_pmos L=0.13u W=0.84u AS=0.2856p AD=0.2198p PS=2.36u
+ PD=1.53u rfmode=0
M$6 VDD C Y VDD sg13_lv_pmos L=0.13u W=1.12u AS=0.2198p AD=0.2128p PS=1.53u
+ PD=1.5u rfmode=0
M$7 Y B VDD VDD sg13_lv_pmos L=0.13u W=1.12u AS=0.2128p AD=0.2128p PS=1.5u
+ PD=1.5u rfmode=0
M$8 VDD \$6 Y VDD sg13_lv_pmos L=0.13u W=1.12u AS=0.2128p AD=0.3808p PS=1.5u
+ PD=2.92u rfmode=0
.ENDS sg13cmos5l_nand3b_1

.SUBCKT sg13cmos5l_inv_1 VDD VSS A Y
M$1 VSS A Y VSS sg13_lv_nmos L=0.13u W=0.74u AS=0.2516p AD=0.2516p PS=2.16u
+ PD=2.16u rfmode=0
M$2 VDD A Y VDD sg13_lv_pmos L=0.13u W=1.12u AS=0.3808p AD=0.3808p PS=2.92u
+ PD=2.92u rfmode=0
.ENDS sg13cmos5l_inv_1

.SUBCKT sg13cmos5l_nor2_1 VDD VSS B A Y
M$1 VSS A Y VSS sg13_lv_nmos L=0.13u W=0.74u AS=0.2516p AD=0.1406p PS=2.16u
+ PD=1.12u rfmode=0
M$2 Y B VSS VSS sg13_lv_nmos L=0.13u W=0.74u AS=0.1406p AD=0.2516p PS=1.12u
+ PD=2.16u rfmode=0
M$3 VDD A \$6 VDD sg13_lv_pmos L=0.13u W=1.12u AS=0.4032p AD=0.1176p PS=2.96u
+ PD=1.33u rfmode=0
M$4 \$6 B Y VDD sg13_lv_pmos L=0.13u W=1.12u AS=0.1176p AD=0.3808p PS=1.33u
+ PD=2.92u rfmode=0
.ENDS sg13cmos5l_nor2_1

.SUBCKT sg13cmos5l_dlygate4sd3_1 VDD VSS X A
M$1 VSS \$5 \$4 VSS sg13_lv_nmos L=0.5u W=0.42u AS=0.1426p AD=0.1428p PS=1.16u
+ PD=1.52u rfmode=0
M$2 VSS \$4 X VSS sg13_lv_nmos L=0.13u W=0.74u AS=0.1426p AD=0.2516p PS=1.16u
+ PD=2.16u rfmode=0
M$3 \$6 A VSS VSS sg13_lv_nmos L=0.13u W=0.42u AS=0.1428p AD=0.0798p PS=1.52u
+ PD=0.8u rfmode=0
M$4 VSS \$6 \$5 VSS sg13_lv_nmos L=0.5u W=0.42u AS=0.0798p AD=0.1428p PS=0.8u
+ PD=1.52u rfmode=0
M$5 \$4 \$5 VDD VDD sg13_lv_pmos L=0.5u W=1u AS=0.34p AD=0.2254p PS=2.68u
+ PD=1.53u rfmode=0
M$6 VDD \$4 X VDD sg13_lv_pmos L=0.13u W=1.12u AS=0.2254p AD=0.4256p PS=1.53u
+ PD=3u rfmode=0
M$7 VDD A \$6 VDD sg13_lv_pmos L=0.13u W=0.42u AS=0.1523p AD=0.1428p PS=1.38u
+ PD=1.52u rfmode=0
M$8 VDD \$6 \$5 VDD sg13_lv_pmos L=0.5u W=1u AS=0.1523p AD=0.34p PS=1.38u
+ PD=2.68u rfmode=0
.ENDS sg13cmos5l_dlygate4sd3_1

.SUBCKT sg13cmos5l_and3_1 VDD VSS A C B X
M$1 \$7 A \$9 VSS sg13_lv_nmos L=0.13u W=0.64u AS=0.2176p AD=0.1216p PS=1.96u
+ PD=1.02u rfmode=0
M$2 \$9 B \$8 VSS sg13_lv_nmos L=0.13u W=0.64u AS=0.1216p AD=0.1216p PS=1.02u
+ PD=1.02u rfmode=0
M$3 VSS C \$8 VSS sg13_lv_nmos L=0.13u W=0.64u AS=0.1371p AD=0.1216p PS=1.12u
+ PD=1.02u rfmode=0
M$4 VSS \$7 X VSS sg13_lv_nmos L=0.13u W=0.74u AS=0.1371p AD=0.2516p PS=1.12u
+ PD=2.16u rfmode=0
M$5 \$7 A VDD VDD sg13_lv_pmos L=0.13u W=0.84u AS=0.2856p AD=0.1596p PS=2.36u
+ PD=1.22u rfmode=0
M$6 VDD B \$7 VDD sg13_lv_pmos L=0.13u W=0.84u AS=0.1596p AD=0.1596p PS=1.22u
+ PD=1.22u rfmode=0
M$7 VDD C \$7 VDD sg13_lv_pmos L=0.13u W=0.84u AS=0.36195p AD=0.1596p PS=1.84u
+ PD=1.22u rfmode=0
M$8 VDD \$7 X VDD sg13_lv_pmos L=0.13u W=1.12u AS=0.36195p AD=0.3808p PS=1.84u
+ PD=2.92u rfmode=0
.ENDS sg13cmos5l_and3_1

.SUBCKT sg13cmos5l_a21oi_1 Y VSS A2 VDD A1 B1
M$1 VSS B1 Y VSS sg13_lv_nmos L=0.13u W=0.74u AS=0.2516p AD=0.1406p PS=2.16u
+ PD=1.12u rfmode=0
M$2 Y A1 \$8 VSS sg13_lv_nmos L=0.13u W=0.74u AS=0.1406p AD=0.1406p PS=1.12u
+ PD=1.12u rfmode=0
M$3 \$8 A2 VSS VSS sg13_lv_nmos L=0.13u W=0.74u AS=0.1406p AD=0.2516p PS=1.12u
+ PD=2.16u rfmode=0
M$4 Y B1 \$3 VDD sg13_lv_pmos L=0.13u W=1.12u AS=0.3808p AD=0.2128p PS=2.92u
+ PD=1.5u rfmode=0
M$5 \$3 A1 VDD VDD sg13_lv_pmos L=0.13u W=1.12u AS=0.2128p AD=0.2128p PS=1.5u
+ PD=1.5u rfmode=0
M$6 VDD A2 \$3 VDD sg13_lv_pmos L=0.13u W=1.12u AS=0.2128p AD=0.3808p PS=1.5u
+ PD=2.92u rfmode=0
.ENDS sg13cmos5l_a21oi_1

.SUBCKT sg13cmos5l_buf_1 VSS X VDD A
M$1 VSS A \$1 VSS sg13_lv_nmos L=0.13u W=0.55u AS=0.14875p AD=0.187p PS=1.16u
+ PD=1.78u rfmode=0
M$2 VSS \$1 X VSS sg13_lv_nmos L=0.13u W=0.74u AS=0.14875p AD=0.2886p PS=1.16u
+ PD=2.26u rfmode=0
M$3 VDD A \$1 VDD sg13_lv_pmos L=0.13u W=0.84u AS=0.2114p AD=0.2856p PS=1.54u
+ PD=2.36u rfmode=0
M$4 VDD \$1 X VDD sg13_lv_pmos L=0.13u W=1.12u AS=0.2114p AD=0.42p PS=1.54u
+ PD=2.99u rfmode=0
.ENDS sg13cmos5l_buf_1

.SUBCKT sg13cmos5l_a21o_1 VDD VSS X B1 A1 A2
M$1 X \$6 VSS VSS sg13_lv_nmos L=0.13u W=0.74u AS=0.2351p AD=0.15745p PS=2.16u
+ PD=1.175u rfmode=0
M$2 VSS B1 \$6 VSS sg13_lv_nmos L=0.13u W=0.64u AS=0.15745p AD=0.1216p
+ PS=1.175u PD=1.02u rfmode=0
M$3 \$6 A1 \$9 VSS sg13_lv_nmos L=0.13u W=0.64u AS=0.1216p AD=0.0816p PS=1.02u
+ PD=0.895u rfmode=0
M$4 \$9 A2 VSS VSS sg13_lv_nmos L=0.13u W=0.64u AS=0.0816p AD=0.2176p PS=0.895u
+ PD=1.96u rfmode=0
M$5 \$6 B1 \$5 VDD sg13_lv_pmos L=0.13u W=1u AS=0.35p AD=0.2125p PS=2.7u
+ PD=1.425u rfmode=0
M$6 \$5 A1 VDD VDD sg13_lv_pmos L=0.13u W=1u AS=0.2125p AD=0.19p PS=1.425u
+ PD=1.38u rfmode=0
M$7 VDD A2 \$5 VDD sg13_lv_pmos L=0.13u W=1u AS=0.19p AD=0.34p PS=1.38u
+ PD=2.68u rfmode=0
M$8 X \$6 VDD VDD sg13_lv_pmos L=0.13u W=1.12u AS=0.3808p AD=0.3808p PS=2.92u
+ PD=2.92u rfmode=0
.ENDS sg13cmos5l_a21o_1

.SUBCKT sg13cmos5l_nand2b_1 VDD VSS B A_N Y
M$1 VSS A_N \$6 VSS sg13_lv_nmos L=0.13u W=0.55u AS=0.14505p AD=0.187p PS=1.15u
+ PD=1.78u rfmode=0
M$2 VSS B \$7 VSS sg13_lv_nmos L=0.13u W=0.74u AS=0.14505p AD=0.1406p PS=1.15u
+ PD=1.12u rfmode=0
M$3 \$7 \$6 Y VSS sg13_lv_nmos L=0.13u W=0.74u AS=0.1406p AD=0.333p PS=1.12u
+ PD=2.38u rfmode=0
M$4 \$6 A_N VDD VDD sg13_lv_pmos L=0.13u W=0.84u AS=0.2856p AD=0.2198p PS=2.36u
+ PD=1.53u rfmode=0
M$5 VDD B Y VDD sg13_lv_pmos L=0.13u W=1.12u AS=0.2198p AD=0.2128p PS=1.53u
+ PD=1.5u rfmode=0
M$6 Y \$6 VDD VDD sg13_lv_pmos L=0.13u W=1.12u AS=0.2128p AD=0.3808p PS=1.5u
+ PD=2.92u rfmode=0
.ENDS sg13cmos5l_nand2b_1

.SUBCKT sg13cmos5l_xor2_1 VSS X VDD B A
M$1 VSS A \$1 VSS sg13_lv_nmos L=0.13u W=0.55u AS=0.374p AD=0.174625p PS=2.46u
+ PD=1.185u rfmode=0
M$2 VSS B \$1 VSS sg13_lv_nmos L=0.13u W=0.55u AS=0.15245p AD=0.174625p
+ PS=1.17u PD=1.185u rfmode=0
M$3 VSS A \$8 VSS sg13_lv_nmos L=0.13u W=0.74u AS=0.15245p AD=0.0888p PS=1.17u
+ PD=0.98u rfmode=0
M$4 \$8 B X VSS sg13_lv_nmos L=0.13u W=0.74u AS=0.0888p AD=0.1628p PS=0.98u
+ PD=1.18u rfmode=0
M$5 X \$1 VSS VSS sg13_lv_nmos L=0.13u W=0.74u AS=0.1628p AD=0.3108p PS=1.18u
+ PD=2.32u rfmode=0
M$6 \$3 A VDD VDD sg13_lv_pmos L=0.13u W=1.12u AS=0.3808p AD=0.2128p PS=2.92u
+ PD=1.5u rfmode=0
M$7 VDD B \$3 VDD sg13_lv_pmos L=0.13u W=1.12u AS=0.2128p AD=0.2128p PS=1.5u
+ PD=1.5u rfmode=0
M$8 \$3 \$1 X VDD sg13_lv_pmos L=0.13u W=1.12u AS=0.2128p AD=0.3808p PS=1.5u
+ PD=2.92u rfmode=0
M$9 VDD A \$9 VDD sg13_lv_pmos L=0.13u W=1u AS=0.36p AD=0.1225p PS=2.72u
+ PD=1.245u rfmode=0
M$10 \$9 B \$1 VDD sg13_lv_pmos L=0.13u W=1u AS=0.1225p AD=0.34p PS=1.245u
+ PD=2.68u rfmode=0
.ENDS sg13cmos5l_xor2_1
