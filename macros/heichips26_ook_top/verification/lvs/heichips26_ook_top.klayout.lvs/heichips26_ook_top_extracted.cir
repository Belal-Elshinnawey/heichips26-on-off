* Extracted by KLayout with SG13CMOS5L LVS runset on : 28/09/2026 21:33

.SUBCKT heichips26_ook_top VAPWR VGND VPWR analog_0 analog_1 analog_2 clk
+ clk_ref data_in_tx in_tieoff in_tieon q0 q0_d q1 q1_d q2 q2_d q3 q3_d rst_n
+ rst_n_in vctrl_b_in vctrl_in
X$301 VPWR \$3334 VGND \$2826 \$2955 \$3581 \$3117 sg13cmos5l_nand4_1
X$303 VPWR VGND \$2830 \$2831 \$2763 \$2826 \$2777 sg13cmos5l_or4_1
X$325 VGND \$1960 VPWR \$1861 \$2164 sg13cmos5l_xor2_1
X$326 VGND \$3977 VPWR \$3453 \$3631 sg13cmos5l_xor2_1
X$327 VGND \$2166 VPWR \$2165 \$2216 sg13cmos5l_xor2_1
X$328 VGND \$1619 VPWR \$1516 \$534 sg13cmos5l_xor2_1
X$329 VGND \$3985 VPWR \$4114 \$2952 sg13cmos5l_xor2_1
X$330 VGND \$3953 VPWR \$3882 \$3352 sg13cmos5l_xor2_1
X$331 VGND \$4189 VPWR \$4398 \$4499 sg13cmos5l_xor2_1
X$332 VGND \$4487 VPWR \$3546 \$4340 sg13cmos5l_xor2_1
X$333 VGND \$4099 VPWR \$3977 \$3841 sg13cmos5l_xor2_1
X$334 VGND \$3479 VPWR \$3478 \$3480 sg13cmos5l_xor2_1
X$335 VGND \$3848 VPWR \$3642 \$3339 sg13cmos5l_xor2_1
X$336 VGND \$2890 VPWR \$2894 \$2955 sg13cmos5l_xor2_1
X$337 VGND \$3871 VPWR \$3486 \$3348 sg13cmos5l_xor2_1
X$338 VGND \$3207 VPWR \$3003 \$2954 sg13cmos5l_xor2_1
X$339 VGND \$3996 VPWR \$3883 \$3429 sg13cmos5l_xor2_1
X$340 VGND \$3682 VPWR \$3014 \$3348 sg13cmos5l_xor2_1
X$341 VGND \$3976 VPWR \$4098 \$2750 sg13cmos5l_xor2_1
X$342 VGND \$4246 VPWR \$3339 \$4030 sg13cmos5l_xor2_1
X$343 VGND \$3204 VPWR \$3058 \$3330 sg13cmos5l_xor2_1
X$344 VGND \$4499 VPWR \$3352 \$4354 sg13cmos5l_xor2_1
X$345 VGND \$3047 VPWR \$2872 \$2629 sg13cmos5l_xor2_1
X$346 VGND \$2367 VPWR \$2465 \$1906 sg13cmos5l_xor2_1
X$408 VPWR VGND \$4294 \$3081 \$4196 sg13cmos5l_xnor2_1
X$409 VPWR VGND \$4344 \$3010 \$4342 sg13cmos5l_xnor2_1
X$410 VPWR VGND \$2868 \$2449 \$2792 sg13cmos5l_xnor2_1
X$411 VPWR VGND \$3846 \$3983 \$3339 sg13cmos5l_xnor2_1
X$412 VPWR VGND \$2022 \$2023 \$2065 sg13cmos5l_xnor2_1
X$413 VPWR VGND \$3069 \$2890 \$2888 sg13cmos5l_xnor2_1
X$414 VPWR VGND \$3840 \$3488 \$3351 sg13cmos5l_xnor2_1
X$415 VPWR VGND \$3112 \$3009 \$3117 sg13cmos5l_xnor2_1
X$416 VPWR VGND \$2510 \$2430 \$2515 sg13cmos5l_xnor2_1
X$417 VPWR VGND \$2872 \$739 \$2755 sg13cmos5l_xnor2_1
X$418 VPWR VGND \$2639 \$2514 \$2515 sg13cmos5l_xnor2_1
X$419 VPWR VGND \$3798 \$3726 \$3581 sg13cmos5l_xnor2_1
X$420 VPWR VGND \$1565 \$1735 \$373 sg13cmos5l_xnor2_1
X$421 VPWR VGND \$4251 \$4212 \$4157 sg13cmos5l_xnor2_1
X$422 VPWR VGND \$3195 \$2314 \$3453 sg13cmos5l_xnor2_1
X$423 VPWR VGND \$4289 \$4359 \$4286 sg13cmos5l_xnor2_1
X$424 VPWR VGND \$4353 \$4498 \$4496 sg13cmos5l_xnor2_1
X$425 VPWR VGND \$4050 \$2952 \$4338 sg13cmos5l_xnor2_1
X$426 VPWR VGND \$534 \$1004 \$975 sg13cmos5l_xnor2_1
X$427 VPWR VGND \$2995 \$3168 \$2890 sg13cmos5l_xnor2_1
X$428 VPWR VGND \$3915 \$3922 \$3584 sg13cmos5l_xnor2_1
X$429 VPWR VGND \$3003 \$2960 \$3546 sg13cmos5l_xnor2_1
X$430 VPWR VGND \$3548 \$3112 \$3175 sg13cmos5l_xnor2_1
X$431 VPWR VGND \$3058 \$3337 \$3334 sg13cmos5l_xnor2_1
X$432 VPWR VGND \$2749 \$2577 \$2507 sg13cmos5l_xnor2_1
X$433 VPWR VGND \$4078 \$3886 \$2861 sg13cmos5l_xnor2_1
X$434 VPWR VGND \$3454 \$3195 \$3055 sg13cmos5l_xnor2_1
X$435 VPWR VGND \$2778 \$739 \$2309 sg13cmos5l_xnor2_1
X$436 VPWR VGND \$4098 \$2885 \$3894 sg13cmos5l_xnor2_1
X$437 VPWR VGND \$2071 \$2078 \$2077 sg13cmos5l_xnor2_1
X$438 VPWR VGND \$3694 \$3692 \$3480 sg13cmos5l_xnor2_1
X$439 VPWR VGND \$4195 \$3970 \$4078 sg13cmos5l_xnor2_1
X$440 VPWR VGND \$2112 \$2169 \$283 sg13cmos5l_xnor2_1
X$474 VPWR VGND \$1077 \$233 \$585 \$532 sg13cmos5l_or3_1
X$475 VPWR VGND \$3922 \$3546 \$3010 \$3883 sg13cmos5l_or3_1
X$486 VPWR VGND \$2969 \$3017 \$3014 \$3081 sg13cmos5l_nand3_1
X$487 VPWR VGND \$826 \$748 \$235 \$78 sg13cmos5l_nand3_1
X$488 VPWR VGND \$3273 \$3195 \$2927 \$2755 sg13cmos5l_nand3_1
X$489 VPWR VGND \$3346 \$3112 \$3172 \$3299 sg13cmos5l_nand3_1
X$490 VPWR VGND \$3636 \$3574 \$2799 \$3392 sg13cmos5l_nand3_1
X$491 VPWR VGND \$1988 \$934 \$1670 \$1915 sg13cmos5l_nand3_1
X$492 VPWR VGND \$3008 \$2851 \$2882 \$3010 sg13cmos5l_nand3_1
X$493 VPWR \$2533 VGND \$2831 \$3005 \$3081 \$3017 sg13cmos5l_nand4_1
X$494 VPWR VGND \$3284 \$1871 \$2882 \$3339 sg13cmos5l_nand3_1
X$495 VPWR VGND \$675 \$922 \$373 \$644 sg13cmos5l_nand3_1
X$496 VPWR VGND \$2541 \$2664 \$2670 \$2669 sg13cmos5l_nand3_1
X$497 VPWR VGND \$3073 \$3003 \$2999 \$3001 sg13cmos5l_nand3_1
X$498 VPWR VGND \$289 \$585 \$373 \$233 sg13cmos5l_nand3_1
X$499 VPWR VGND \$1496 \$1356 \$1224 \$1407 sg13cmos5l_nand3_1
X$500 VPWR VGND \$3726 \$2952 \$3642 \$3334 sg13cmos5l_nand3_1
X$501 VPWR VGND \$2989 \$3058 \$2990 \$3059 sg13cmos5l_nand3_1
X$502 VPWR VGND \$2891 \$2531 \$2358 \$2952 sg13cmos5l_nand3_1
X$515 VPWR VGND \$3063 \$3064 \$2945 \$2995 sg13cmos5l_a21o_1
X$516 VPWR VGND \$2524 \$2588 \$2459 \$1705 sg13cmos5l_a21o_1
X$517 VPWR VGND \$3055 \$2755 \$2449 \$2230 sg13cmos5l_a21o_1
X$518 VPWR VGND \$3850 \$2522 \$3726 \$3722 sg13cmos5l_a21o_1
X$519 VPWR VGND \$2382 \$2240 \$934 \$1670 sg13cmos5l_a21o_1
X$520 VPWR VGND \$2191 \$1605 \$1615 \$177 sg13cmos5l_a21o_1
X$521 VPWR VGND \$3826 \$3758 \$3833 \$3598 sg13cmos5l_a21o_1
X$522 VPWR VGND \$2670 \$2781 \$2780 \$2779 sg13cmos5l_a21o_1
X$523 VPWR VGND \$4286 \$4500 \$4499 \$4398 sg13cmos5l_a21o_1
X$524 VPWR VGND \$2287 \$2456 \$2359 \$2520 sg13cmos5l_a21o_1
X$525 VPWR VGND \$2319 \$1615 \$1995 \$2347 sg13cmos5l_a21o_1
X$526 VPWR VGND \$3172 \$3003 \$3001 \$2999 sg13cmos5l_a21o_1
X$527 VPWR VGND \$2990 \$3195 \$2755 \$2927 sg13cmos5l_a21o_1
X$528 VPWR VGND \$756 \$623 \$301 \$621 sg13cmos5l_a21o_1
X$529 VPWR VGND \$3722 \$2952 \$3334 \$3642 sg13cmos5l_a21o_1
X$530 VPWR VGND \$235 \$534 \$531 \$532 sg13cmos5l_a21o_1
X$531 VPWR VGND \$2511 \$2516 \$2359 \$2642 sg13cmos5l_a21o_1
X$532 VPWR VGND \$4016 \$4286 \$4196 \$3081 sg13cmos5l_a21o_1
X$565 VPWR VGND \$2476 \$2369 \$2193 \$2326 sg13cmos5l_nand3b_1
X$566 VPWR VGND \$484 \$1077 \$585 \$922 sg13cmos5l_nand3b_1
X$567 VPWR VGND \$2114 \$1670 \$2483 \$2321 sg13cmos5l_nand3b_1
X$568 VPWR VGND \$975 \$644 \$1004 \$1077 \$307 sg13cmos5l_nor4_1
X$569 VPWR VGND \$3352 \$3348 \$3083 \$3220 \$3225 sg13cmos5l_nor4_1
X$570 VPWR VGND \$3352 \$3429 \$3081 \$3883 \$3016 sg13cmos5l_nor4_1
X$571 VPWR VGND \$3453 \$2885 \$3339 \$3047 \$4114 sg13cmos5l_nor4_1
X$572 VPWR VGND \$1005 \$1522 \$1416 \$783 \$1356 sg13cmos5l_nor4_1
X$573 VPWR VGND \$2830 \$2763 \$2826 \$2831 \$2522 sg13cmos5l_nor4_1
X$574 VPWR VGND \$783 \$1220 \$918 \$1129 \$1175 sg13cmos5l_nor4_1
X$575 VPWR VGND \$739 \$379 \$506 \$615 \$813 sg13cmos5l_nor4_1
X$576 VPWR VGND \$1958 \$2161 \$1861 \$2358 \$2629 sg13cmos5l_nor4_1
X$577 VGND \$3024 \$2483 \$2534 \$3023 VPWR sg13cmos5l_mux2_1
X$578 VGND \$966 \$233 \$95 \$375 VPWR sg13cmos5l_mux2_1
X$579 VGND \$3045 \$2230 \$2868 \$2755 VPWR sg13cmos5l_mux2_1
X$580 VGND \$3188 \$2483 \$2718 \$3016 VPWR sg13cmos5l_mux2_1
X$581 VGND \$936 \$578 \$1249 \$704 VPWR sg13cmos5l_mux2_1
X$582 VGND \$2927 \$2629 \$2872 \$2868 VPWR sg13cmos5l_mux2_1
X$583 VGND \$614 \$83 VPWR sg13cmos5l_buf_8
X$584 VGND \$1739 \$1694 VPWR sg13cmos5l_buf_8
X$585 VGND clk_ref \$614 VPWR sg13cmos5l_buf_8
X$586 VGND \$1696 \$1426 VPWR sg13cmos5l_buf_8
X$587 VGND \$1229 \$1294 VPWR sg13cmos5l_buf_8
X$588 VGND \$614 \$2341 VPWR sg13cmos5l_buf_8
X$589 VGND \$614 \$3910 VPWR sg13cmos5l_buf_8
X$590 VGND \$1482 \$571 VPWR sg13cmos5l_buf_8
X$591 VGND \$1696 \$2088 VPWR sg13cmos5l_buf_8
X$592 VGND \$1207 \$1741 VPWR sg13cmos5l_buf_8
X$593 VGND \$1155 \$1865 VPWR sg13cmos5l_buf_8
X$594 VGND \$1338 \$1739 VPWR sg13cmos5l_buf_8
X$595 VGND \$1338 \$1231 VPWR sg13cmos5l_buf_8
X$596 VGND \$1750 \$1696 VPWR sg13cmos5l_buf_8
X$597 VGND \$1699 VPWR \$1605 \$1004 sg13cmos5l_xor2_1
X$598 VGND \$614 \$2194 VPWR sg13cmos5l_buf_8
X$599 VGND \$1336 \$1229 VPWR sg13cmos5l_buf_8
X$600 VGND \$1155 \$557 VPWR sg13cmos5l_buf_8
X$601 VGND \$1207 \$726 VPWR sg13cmos5l_buf_8
X$602 VGND \$1728 \$1155 VPWR sg13cmos5l_buf_8
X$603 VGND \$1336 \$1750 VPWR sg13cmos5l_buf_8
X$604 VGND \$1297 \$1482 VPWR sg13cmos5l_buf_8
X$605 VGND \$614 \$3943 VPWR sg13cmos5l_buf_8
X$606 VGND \$614 \$1628 VPWR sg13cmos5l_buf_8
X$607 VGND \$1231 \$1207 VPWR sg13cmos5l_buf_8
X$608 VGND \$614 \$1197 VPWR sg13cmos5l_buf_8
X$609 VGND \$1297 \$1728 VPWR sg13cmos5l_buf_8
X$610 \$2168 VGND VPWR \$2246 \$2287 \$2220 \$2221 sg13cmos5l_a22oi_1
X$611 \$238 VGND VPWR \$917 \$1004 \$704 \$578 sg13cmos5l_a22oi_1
X$612 \$926 VGND VPWR \$841 \$1077 \$1160 \$917 sg13cmos5l_a22oi_1
X$613 \$3446 VGND VPWR \$2718 \$3359 \$3240 \$2533 sg13cmos5l_a22oi_1
X$614 \$547 VGND VPWR \$704 \$578 \$980 \$922 sg13cmos5l_a22oi_1
X$615 \$447 VGND VPWR \$451 \$98 \$961 \$204 sg13cmos5l_a22oi_1
X$616 \$818 VGND VPWR \$912 \$431 \$485 \$33 sg13cmos5l_a22oi_1
X$617 \$3359 VGND VPWR \$3354 \$2861 \$2534 \$3235 sg13cmos5l_a22oi_1
X$618 \$621 VGND VPWR \$238 \$674 \$620 \$440 sg13cmos5l_a22oi_1
X$619 \$2908 VGND VPWR \$3024 \$2609 \$2980 \$2489 sg13cmos5l_a22oi_1
X$620 \$520 VGND VPWR \$626 \$431 \$706 \$33 sg13cmos5l_a22oi_1
X$621 \$958 VGND VPWR \$451 \$962 \$961 \$1027 sg13cmos5l_a22oi_1
X$622 \$545 VGND VPWR \$307 \$31 \$586 \$178 sg13cmos5l_a22oi_1
X$623 \$2504 VGND VPWR \$2319 \$2511 \$2626 \$2515 sg13cmos5l_a22oi_1
X$726 \$2347 \$2779 \$2899 VPWR VGND sg13cmos5l_or2_1
X$727 \$3392 \$3329 \$2314 VPWR VGND sg13cmos5l_or2_1
X$728 \$3222 \$4186 \$4057 VPWR VGND sg13cmos5l_or2_1
X$729 \$2755 \$2799 \$2230 VPWR VGND sg13cmos5l_or2_1
X$730 \$1005 \$1220 \$1323 VPWR VGND sg13cmos5l_or2_1
X$731 \$33 \$438 \$626 VPWR VGND sg13cmos5l_or2_1
X$732 \$2246 \$4000 \$4082 VPWR VGND sg13cmos5l_or2_1
X$733 \$2628 \$2625 \$2427 VPWR VGND sg13cmos5l_or2_1
X$734 \$975 \$1249 \$1004 VPWR VGND sg13cmos5l_or2_1
X$735 \$283 \$2357 \$484 VPWR VGND sg13cmos5l_or2_1
X$736 \$1012 \$794 \$841 VPWR VGND sg13cmos5l_or2_1
X$737 \$379 \$609 \$506 VPWR VGND sg13cmos5l_or2_1
X$738 VGND VPWR \$4337 \$4052 \$4485 sg13cmos5l_nor2b_1
X$739 VGND VPWR \$4341 \$4489 \$4343 sg13cmos5l_nor2b_1
X$740 VGND VPWR \$3427 \$3220 \$3346 sg13cmos5l_nor2b_1
X$741 VGND VPWR \$3160 \$3061 \$2989 sg13cmos5l_nor2b_1
X$742 VGND VPWR \$4498 \$4394 \$4393 sg13cmos5l_nor2b_1
X$743 VGND VPWR \$3486 \$2826 \$3642 sg13cmos5l_nor2b_1
X$744 VGND VPWR \$317 \$585 \$922 sg13cmos5l_nor2b_1
X$745 VGND VPWR \$1160 \$922 \$975 sg13cmos5l_nor2b_1
X$746 VGND VPWR \$3843 \$3983 \$4326 sg13cmos5l_nor2b_1
X$747 VGND VPWR \$1578 \$1522 \$801 sg13cmos5l_nor2b_1
X$748 VGND VPWR \$3719 \$3642 \$3636 sg13cmos5l_nor2b_1
X$749 VGND VPWR \$2465 \$2459 \$2078 sg13cmos5l_nor2b_1
X$753 VGND \$3204 VPWR \$3327 \$3198 \$3219 \$2945 \$3160 sg13cmos5l_a221oi_1
X$754 VGND \$655 VPWR \$517 \$609 \$615 \$78 \$509 sg13cmos5l_a221oi_1
X$755 VGND \$337 \$578 \$534 \$532 VPWR sg13cmos5l_mux2_1
X$756 VGND \$3207 VPWR \$3211 \$2347 \$3219 \$2945 \$3215 sg13cmos5l_a221oi_1
X$757 VGND \$3548 VPWR \$3679 \$3313 \$3219 \$2945 \$3427 sg13cmos5l_a221oi_1
X$758 VGND \$3454 VPWR \$3625 \$3198 \$3219 \$2945 \$3326 sg13cmos5l_a221oi_1
X$759 VGND \$1133 VPWR \$1670 \$891 \$177 \$1496 \$970 sg13cmos5l_a221oi_1
X$760 VGND \$3045 VPWR \$3382 \$3198 \$3219 \$2927 \$2945 sg13cmos5l_a221oi_1
X$761 VGND \$3985 VPWR \$3912 \$2518 \$2645 \$3198 \$3850 sg13cmos5l_a221oi_1
X$762 VGND \$2518 VPWR \$2516 \$2639 \$2645 \$2388 \$2522 sg13cmos5l_a221oi_1
X$763 VGND \$299 VPWR \$368 \$237 \$240 \$31 \$75 sg13cmos5l_a221oi_1
X$764 VGND \$3841 VPWR \$3978 \$3977 \$3779 \$4030 \$3339 sg13cmos5l_a221oi_1
X$765 VGND \$3953 VPWR \$4082 \$2518 \$2781 \$3313 \$3880 sg13cmos5l_a221oi_1
X$766 VGND \$452 VPWR \$804 \$1488 \$373 \$958 \$1212 sg13cmos5l_a221oi_1
X$767 VGND \$2534 VPWR \$2359 \$2533 \$2385 \$2382 \$1988 sg13cmos5l_a221oi_1
X$768 VGND \$4059 VPWR \$4057 \$2518 \$2781 \$3313 \$3924 sg13cmos5l_a221oi_1
X$769 VGND \$2354 VPWR \$2456 \$2518 \$2645 \$2347 \$2522 sg13cmos5l_a221oi_1
X$770 VGND \$3682 VPWR \$3681 \$3313 \$3219 \$3224 \$3477 sg13cmos5l_a221oi_1
X$771 VGND \$3694 VPWR \$3689 \$3313 \$3219 \$3224 \$3479 sg13cmos5l_a221oi_1
X$772 VGND \$1160 VPWR \$1212 \$1158 \$644 \$481 \$317 sg13cmos5l_a221oi_1
X$773 VGND \$961 VPWR \$1488 \$1694 \$1689 \$1294 \$1160 sg13cmos5l_a221oi_1
X$811 VPWR VGND \$994 \$578 \$534 sg13cmos5l_and2_1
X$812 VPWR VGND \$3017 \$3348 \$3352 sg13cmos5l_and2_1
X$813 VPWR VGND \$2518 \$2774 \$2899 sg13cmos5l_and2_1
X$814 VPWR VGND \$3516 \$3392 \$2314 sg13cmos5l_and2_1
X$815 VPWR VGND \$348 \$438 \$308 sg13cmos5l_and2_1
X$816 VPWR VGND \$2774 \$1670 \$1706 sg13cmos5l_and2_1
X$817 VPWR VGND \$3779 \$3631 \$3453 sg13cmos5l_and2_1
X$818 VPWR VGND \$3326 \$2990 \$3273 sg13cmos5l_and2_1
X$819 VPWR VGND \$4500 \$4282 \$3352 sg13cmos5l_and2_1
X$820 VPWR VGND \$652 \$343 \$306 sg13cmos5l_and2_1
X$821 VPWR VGND \$3488 \$3017 \$3486 sg13cmos5l_and2_1
X$822 VPWR VGND \$1613 \$1495 \$1198 sg13cmos5l_and2_1
X$823 VPWR VGND \$369 \$644 \$373 sg13cmos5l_and2_1
X$824 VPWR VGND \$3169 \$3339 \$3337 sg13cmos5l_and2_1
X$825 VPWR VGND \$3215 \$3172 \$3073 sg13cmos5l_and2_1
X$826 VPWR VGND \$4012 \$2533 \$3016 sg13cmos5l_and2_1
X$827 VPWR VGND \$451 \$585 \$922 sg13cmos5l_and2_1
X$828 VPWR VGND \$1054 \$1578 \$1576 sg13cmos5l_and2_1
X$829 VPWR VGND \$306 \$435 \$124 sg13cmos5l_and2_1
X$830 VPWR VGND \$615 \$49 \$675 sg13cmos5l_and2_1
X$831 VPWR VGND \$1516 \$1496 \$970 sg13cmos5l_and2_1
X$832 VPWR VGND \$4380 \$4338 \$2952 sg13cmos5l_and2_1
X$833 VPWR VGND \$3083 \$3010 \$3009 sg13cmos5l_and2_1
X$834 VPWR VGND \$124 \$85 \$36 sg13cmos5l_and2_1
X$835 VPWR VGND \$36 \$178 \$176 sg13cmos5l_and2_1
X$836 VPWR VGND \$1363 \$629 \$1173 sg13cmos5l_and2_1
X$837 VPWR VGND \$2641 \$2628 \$2427 sg13cmos5l_and2_1
X$838 VPWR VGND \$1706 \$848 \$1054 sg13cmos5l_and2_1
X$839 VPWR VGND \$4114 \$2952 \$3922 sg13cmos5l_nand2b_1
X$840 VPWR VGND \$2625 \$2641 \$2577 sg13cmos5l_nand2b_1
X$841 VPWR VGND \$1128 \$1089 \$1129 sg13cmos5l_nand2b_1
X$842 VPWR VGND \$1004 \$975 \$917 sg13cmos5l_nand2b_1
X$843 VPWR VGND \$77 \$1802 \$1705 sg13cmos5l_nand2b_1
X$844 VPWR VGND \$695 \$49 \$655 sg13cmos5l_nand2b_1
X$845 VPWR VGND \$585 \$922 \$980 sg13cmos5l_nand2b_1
X$846 VPWR VGND \$2575 \$2514 \$2354 sg13cmos5l_nand2b_1
X$847 VPWR VGND \$3882 \$3352 \$4008 sg13cmos5l_nand2b_1
X$848 VPWR VGND \$78 \$238 \$344 sg13cmos5l_nand2b_1
X$849 VPWR VGND \$3428 \$3478 \$3477 sg13cmos5l_nand2b_1
X$850 VPWR VGND \$2125 \$1915 \$2240 sg13cmos5l_nand2b_1
X$851 VPWR VGND \$3974 \$2533 \$3886 sg13cmos5l_nand2_1
X$852 VPWR VGND \$2894 \$2531 \$2358 sg13cmos5l_nand2_1
X$853 VPWR VGND \$2960 \$2082 \$2882 sg13cmos5l_nand2_1
X$854 VPWR VGND \$3337 \$1871 \$2882 sg13cmos5l_nand2_1
X$855 VPWR VGND \$1918 \$2091 \$1705 sg13cmos5l_nand2_1
X$856 VPWR VGND \$4162 \$3546 \$3222 sg13cmos5l_nand2_1
X$857 VPWR VGND \$3354 \$3017 \$3014 sg13cmos5l_nand2_1
X$858 VPWR VGND \$3306 \$2533 \$2534 sg13cmos5l_nand2_1
X$859 VPWR VGND \$2655 \$2589 \$1705 sg13cmos5l_nand2_1
X$860 VPWR VGND \$2723 \$2326 \$1705 sg13cmos5l_nand2_1
X$861 VPWR VGND \$912 \$748 \$977 sg13cmos5l_nand2_1
X$862 VPWR VGND \$2520 \$2354 \$2945 sg13cmos5l_nand2_1
X$863 VPWR VGND \$2964 \$2774 \$2899 sg13cmos5l_nand2_1
X$864 VPWR VGND \$3692 \$3348 \$3014 sg13cmos5l_nand2_1
X$865 VPWR VGND \$2169 \$1605 \$2351 sg13cmos5l_nand2_1
X$866 VPWR VGND \$3009 \$2851 \$2882 sg13cmos5l_nand2_1
X$867 VPWR VGND \$2352 \$1160 \$1516 sg13cmos5l_nand2_1
X$868 VPWR VGND \$2111 \$2161 \$1958 sg13cmos5l_nand2_1
X$869 VPWR VGND \$2310 \$1861 \$2246 sg13cmos5l_nand2_1
X$870 VPWR VGND \$3219 \$2781 \$3306 sg13cmos5l_nand2_1
X$871 VPWR VGND \$2980 \$2489 \$3188 sg13cmos5l_nand2_1
X$872 VPWR VGND \$2899 \$3018 \$3016 sg13cmos5l_nand2_1
X$873 VPWR VGND \$2325 \$2193 \$1705 sg13cmos5l_nand2_1
X$874 VPWR VGND \$2174 \$2078 \$1705 sg13cmos5l_nand2_1
X$875 VPWR VGND \$319 \$374 \$317 sg13cmos5l_nand2_1
X$876 VPWR VGND \$2642 \$2945 \$2639 sg13cmos5l_nand2_1
X$877 VPWR VGND \$362 \$178 \$547 sg13cmos5l_nand2_1
X$878 VPWR VGND \$1995 \$934 \$1670 sg13cmos5l_nand2_1
X$879 VPWR VGND \$354 \$440 \$235 sg13cmos5l_nand2_1
X$880 VPWR VGND \$3734 \$2952 \$3222 sg13cmos5l_nand2_1
X$881 VPWR VGND \$4302 \$4340 \$3546 sg13cmos5l_nand2_1
X$882 VPWR VGND \$4073 \$3352 \$2246 sg13cmos5l_nand2_1
X$883 VPWR VGND \$531 \$644 \$373 sg13cmos5l_nand2_1
X$884 VPWR VGND \$2388 \$1670 \$1706 sg13cmos5l_nand2_1
X$885 VPWR VGND \$3299 \$3546 \$2960 sg13cmos5l_nand2_1
X$886 VPWR VGND \$2664 \$2778 \$2359 sg13cmos5l_nand2_1
X$887 VPWR VGND \$783 \$794 \$801 sg13cmos5l_nand2_1
X$888 VPWR VGND \$1173 \$578 \$317 sg13cmos5l_nand2_1
X$889 VPWR VGND \$586 \$841 \$980 sg13cmos5l_nand2_1
X$890 VPWR VGND \$4366 \$3894 \$2885 sg13cmos5l_nand2_1
X$891 VPWR VGND \$3705 \$3334 \$3222 sg13cmos5l_nand2_1
X$892 VPWR VGND \$3301 \$3098 \$3222 sg13cmos5l_nand2_1
X$893 VPWR VGND \$4119 \$3010 \$3222 sg13cmos5l_nand2_1
X$894 VPWR VGND \$3667 \$3376 \$3222 sg13cmos5l_nand2_1
X$895 VPWR VGND \$290 \$137 \$289 sg13cmos5l_nand2_1
X$896 VPWR VGND \$4059 \$3883 \$3923 sg13cmos5l_nand2_1
X$897 VPWR VGND \$2216 \$2164 \$1861 sg13cmos5l_nand2_1
X$898 VPWR VGND \$2508 \$2065 \$2023 sg13cmos5l_nand2_1
X$899 VPWR VGND \$2387 \$2313 \$1705 sg13cmos5l_nand2_1
X$900 VPWR VGND \$841 \$531 \$532 sg13cmos5l_nand2_1
X$901 VPWR VGND \$1973 \$1906 \$1705 sg13cmos5l_nand2_1
X$902 VPWR VGND \$485 \$532 \$484 sg13cmos5l_nand2_1
X$903 VPWR VGND \$3598 \$2781 \$3446 sg13cmos5l_nand2_1
X$904 VPWR VGND \$4393 \$4351 \$3429 sg13cmos5l_nand2_1
X$905 VPWR VGND \$3059 \$3453 \$2314 sg13cmos5l_nand2_1
X$906 VPWR VGND \$3824 \$3348 \$3222 sg13cmos5l_nand2_1
X$907 VPWR VGND \$3001 \$2955 \$2894 sg13cmos5l_nand2_1
X$908 VPWR VGND \$452 \$571 \$451 sg13cmos5l_nand2_1
X$909 VPWR VGND \$3574 \$2885 \$2882 sg13cmos5l_nand2_1
X$1045 VGND \$3972 VPWR \$3974 \$3970 \$3973 sg13cmos5l_o21ai_1
X$1046 VGND \$930 VPWR \$178 \$739 \$994 sg13cmos5l_o21ai_1
X$1047 VGND \$3859 VPWR \$3731 \$3915 \$2964 sg13cmos5l_o21ai_1
X$1048 VGND \$2322 VPWR \$2476 \$2369 \$2193 sg13cmos5l_o21ai_1
X$1049 VGND \$541 VPWR \$354 \$586 \$31 sg13cmos5l_o21ai_1
X$1050 VGND \$2237 VPWR \$2325 \$2322 \$2114 sg13cmos5l_o21ai_1
X$1051 VGND \$2543 VPWR \$2310 \$2541 \$2671 sg13cmos5l_o21ai_1
X$1052 VGND \$3014 VPWR \$3008 \$3173 \$3175 sg13cmos5l_o21ai_1
X$1053 VGND \$3330 VPWR \$3329 \$3516 \$3055 sg13cmos5l_o21ai_1
X$1054 VGND \$703 VPWR \$31 \$704 \$765 sg13cmos5l_o21ai_1
X$1055 VPWR VGND \$623 \$748 \$703 \$362 sg13cmos5l_nand3_1
X$1056 VGND \$456 VPWR \$545 \$541 \$517 sg13cmos5l_o21ai_1
X$1057 VGND \$2954 VPWR \$2891 \$2890 \$2888 sg13cmos5l_o21ai_1
X$1058 VGND \$2316 VPWR \$2655 \$2715 \$2114 sg13cmos5l_o21ai_1
X$1059 VGND \$3872 VPWR \$4069 \$3996 \$2964 sg13cmos5l_o21ai_1
X$1060 VGND \$3855 VPWR \$3734 \$3651 \$3912 sg13cmos5l_o21ai_1
X$1061 VGND \$2124 VPWR \$1973 \$2188 \$2114 sg13cmos5l_o21ai_1
X$1062 VGND \$2999 VPWR \$2890 \$3061 \$3169 sg13cmos5l_o21ai_1
X$1063 VGND \$3869 VPWR \$2669 \$3872 \$2781 sg13cmos5l_o21ai_1
X$1064 VGND \$2780 VPWR \$2778 \$2777 \$2774 sg13cmos5l_o21ai_1
X$1065 VGND \$3778 VPWR \$3781 \$3843 \$2964 sg13cmos5l_o21ai_1
X$1066 VGND \$3970 VPWR \$4016 \$3081 \$4196 sg13cmos5l_o21ai_1
X$1067 VGND \$3710 VPWR \$2669 \$3778 \$2645 sg13cmos5l_o21ai_1
X$1068 VGND \$3841 VPWR \$4366 \$4098 \$2750 sg13cmos5l_o21ai_1
X$1069 VGND \$1760 VPWR \$1574 \$1613 \$1569 sg13cmos5l_o21ai_1
X$1070 VGND \$3924 VPWR \$2777 \$3735 \$3486 sg13cmos5l_o21ai_1
X$1071 VGND \$4343 VPWR \$4487 \$4052 \$4380 sg13cmos5l_o21ai_1
X$1072 VGND \$3880 VPWR \$2777 \$3747 \$3488 sg13cmos5l_o21ai_1
X$1073 VGND \$4485 VPWR \$4050 \$3978 \$4051 sg13cmos5l_o21ai_1
X$1074 VGND \$3781 VPWR \$3198 \$3719 \$2522 sg13cmos5l_o21ai_1
X$1075 VGND \$3428 VPWR \$3429 \$3220 \$3083 sg13cmos5l_o21ai_1
X$1076 VGND \$3847 VPWR \$3198 \$3848 \$2522 sg13cmos5l_o21ai_1
X$1077 VGND \$3731 VPWR \$3198 \$3798 \$2522 sg13cmos5l_o21ai_1
X$1078 VGND \$2314 VPWR \$2116 \$484 \$283 sg13cmos5l_o21ai_1
X$1079 VGND \$4069 VPWR \$3313 \$3871 \$2522 sg13cmos5l_o21ai_1
X$1080 VGND \$1002 VPWR \$629 \$917 \$531 sg13cmos5l_o21ai_1
X$1081 VGND \$1689 VPWR \$644 \$917 \$1472 sg13cmos5l_o21ai_1
X$1082 VGND \$1735 VPWR \$1605 \$1620 \$1961 sg13cmos5l_o21ai_1
X$1083 VGND \$3509 VPWR \$2669 \$3320 \$2645 sg13cmos5l_o21ai_1
X$1084 VGND \$2351 VPWR \$2352 \$1516 \$917 sg13cmos5l_o21ai_1
X$1085 VGND \$2449 VPWR \$2304 \$484 \$283 sg13cmos5l_o21ai_1
X$1086 VGND \$3384 VPWR \$3198 \$3152 \$2522 sg13cmos5l_o21ai_1
X$1087 VGND \$848 VPWR \$905 \$527 \$708 sg13cmos5l_o21ai_1
X$1088 VPWR VGND \$783 \$601 \$847 \$851 sg13cmos5l_or3_1
X$1089 VGND \$234 VPWR \$45 \$52 \$49 sg13cmos5l_o21ai_1
X$1090 VGND \$4183 VPWR \$4119 \$4186 \$3679 sg13cmos5l_o21ai_1
X$1091 VGND \$3900 VPWR \$2669 \$4036 \$2645 sg13cmos5l_o21ai_1
X$1092 VGND \$1576 VPWR \$794 \$1416 \$1363 sg13cmos5l_o21ai_1
X$1093 VGND \$3149 VPWR \$3301 \$3382 \$3509 sg13cmos5l_o21ai_1
X$1094 VGND \$2386 VPWR \$2387 \$2388 \$1802 sg13cmos5l_o21ai_1
X$1095 VGND \$3240 VPWR \$2774 \$3225 \$3235 sg13cmos5l_o21ai_1
X$1096 VGND \$3771 VPWR \$3705 \$3327 \$3900 sg13cmos5l_o21ai_1
X$1097 VGND \$299 VPWR \$169 \$298 \$279 sg13cmos5l_o21ai_1
X$1098 VGND \$2575 VPWR \$1958 \$2358 \$1861 sg13cmos5l_o21ai_1
X$1099 VGND \$840 VPWR \$826 \$926 \$674 sg13cmos5l_o21ai_1
X$1100 VGND \$1764 VPWR \$1918 \$1995 \$1802 sg13cmos5l_o21ai_1
X$1101 VGND \$4398 VPWR \$4393 \$4394 \$4497 sg13cmos5l_o21ai_1
X$1102 VGND \$847 VPWR \$935 \$936 \$87 sg13cmos5l_o21ai_1
X$1103 VGND \$3618 VPWR \$3667 \$3625 \$3710 sg13cmos5l_o21ai_1
X$1104 VGND \$969 VPWR \$721 \$966 \$484 sg13cmos5l_o21ai_1
X$1105 VGND \$1967 VPWR \$2174 \$2118 \$2114 sg13cmos5l_o21ai_1
X$1106 VGND \$3930 VPWR \$3824 \$3869 \$3681 sg13cmos5l_o21ai_1
X$1107 VGND \$3651 VPWR \$2669 \$3063 \$3219 sg13cmos5l_o21ai_1
X$1108 VGND \$4326 VPWR \$3453 \$3047 \$2885 sg13cmos5l_o21ai_1
X$1109 VGND \$4056 VPWR \$2669 \$3859 \$2645 sg13cmos5l_o21ai_1
X$1110 VGND \$4036 VPWR \$3847 \$3846 \$2964 sg13cmos5l_o21ai_1
X$1111 VGND \$3923 VPWR \$3010 \$3922 \$3546 sg13cmos5l_o21ai_1
X$1112 VGND \$4164 VPWR \$4162 \$4056 \$3211 sg13cmos5l_o21ai_1
X$1113 VGND \$301 VPWR \$344 \$298 \$279 sg13cmos5l_o21ai_1
X$1114 VGND \$1407 VPWR \$1002 \$847 \$758 sg13cmos5l_o21ai_1
X$1115 VGND \$934 VPWR \$1054 \$851 \$595 sg13cmos5l_o21ai_1
X$1116 VGND \$2507 VPWR \$2508 \$2022 \$2216 sg13cmos5l_o21ai_1
X$1117 VGND \$4002 VPWR \$4073 \$3689 \$4000 sg13cmos5l_o21ai_1
X$1118 VGND \$3320 VPWR \$3384 \$2964 \$3047 sg13cmos5l_o21ai_1
X$1119 VGND \$1128 VPWR \$87 \$936 \$739 sg13cmos5l_o21ai_1
X$1120 VGND \$1224 VPWR \$1175 \$819 \$1053 sg13cmos5l_o21ai_1
X$1121 VGND \$844 VPWR \$842 \$840 \$899 sg13cmos5l_o21ai_1
X$1122 VGND \$854 VPWR \$853 \$652 \$713 sg13cmos5l_o21ai_1
X$2130 VPWR VGND \$3978 \$4052 \$4050 \$4051 sg13cmos5l_nor3_1
X$2131 VPWR VGND \$3220 \$3478 \$3083 \$3348 sg13cmos5l_nor3_1
X$2132 VPWR VGND \$2358 \$2514 \$1861 \$1958 sg13cmos5l_nor3_1
X$2133 VPWR VGND \$1613 \$1612 \$1606 \$77 sg13cmos5l_nor3_1
X$2134 VPWR VGND \$1198 \$1181 \$1093 \$77 sg13cmos5l_nor3_1
X$2135 VPWR VGND \$1323 \$1416 \$1005 \$1128 sg13cmos5l_nor3_1
X$2136 VPWR VGND \$677 \$899 \$697 \$813 sg13cmos5l_nor3_1
X$2137 VPWR VGND \$3047 \$3983 \$3453 \$2885 sg13cmos5l_nor3_1
X$2138 VPWR VGND \$306 \$100 \$359 \$26 sg13cmos5l_nor3_1
X$2139 VPWR VGND \$652 \$427 \$583 \$26 sg13cmos5l_nor3_1
X$2140 VPWR VGND \$739 \$995 \$994 \$178 sg13cmos5l_nor3_1
X$2141 VPWR VGND \$1516 \$1961 \$917 \$283 sg13cmos5l_nor3_1
X$2142 VPWR VGND \$2183 \$2588 \$2114 \$2459 sg13cmos5l_nor3_1
X$2143 VPWR VGND \$52 \$219 \$137 \$26 sg13cmos5l_nor3_1
X$2144 VGND \$290 VPWR \$298 \$337 \$379 \$28 \$286 sg13cmos5l_a221oi_1
X$2145 VPWR VGND \$3752 \$4014 \$3885 \$2781 sg13cmos5l_nor3_1
X$2146 VPWR VGND \$307 \$443 \$369 \$178 sg13cmos5l_nor3_1
X$2147 VPWR VGND \$70 \$174 \$160 \$26 sg13cmos5l_nor3_1
X$2148 VPWR VGND \$2358 \$2430 \$1860 \$2221 sg13cmos5l_nor3_1
X$2149 VPWR VGND \$4487 \$4489 \$4052 \$4380 sg13cmos5l_nor3_1
X$2150 VPWR VGND \$176 \$155 \$123 \$26 sg13cmos5l_nor3_1
X$2151 VPWR VGND \$936 \$1089 \$1085 \$87 sg13cmos5l_nor3_1
X$2152 VPWR VGND \$373 \$704 \$585 \$233 sg13cmos5l_nor3_1
X$2153 VPWR VGND \$2589 \$2465 \$1871 \$2369 sg13cmos5l_and3_1
X$2154 VPWR VGND \$644 \$373 \$922 \$695 sg13cmos5l_and3_1
X$2155 VPWR VGND \$2861 \$2718 \$2781 \$2671 sg13cmos5l_and3_1
X$2156 VPWR VGND \$644 \$1516 \$1160 \$1620 sg13cmos5l_and3_1
X$2157 VPWR VGND \$1043 \$652 \$629 \$1198 sg13cmos5l_and3_1
X$2158 VPWR VGND \$3235 \$3225 \$2774 \$2718 sg13cmos5l_and3_1
X$2159 VPWR VGND \$4302 \$4344 \$4343 \$4345 sg13cmos5l_and3_1
X$2160 VPWR VGND \$2193 \$2369 \$2326 \$2183 sg13cmos5l_and3_1
X$2161 VPWR VGND \$486 \$375 sg13cmos5l_inv_1
X$2162 VPWR VGND \$1861 \$1860 sg13cmos5l_inv_1
X$2163 VPWR VGND \$1423 \$1472 sg13cmos5l_inv_1
X$2164 VPWR VGND \$3284 \$3282 sg13cmos5l_inv_1
X$2165 VPWR VGND \$3081 \$3235 sg13cmos5l_inv_1
X$2166 VPWR VGND \$3112 \$3173 sg13cmos5l_inv_1
X$2167 VPWR VGND \$818 \$819 sg13cmos5l_inv_1
X$2168 VPWR VGND \$481 \$407 sg13cmos5l_inv_1
X$2169 VPWR VGND \$31 \$674 sg13cmos5l_inv_1
X$2170 VPWR VGND \$1865 \$1657 sg13cmos5l_inv_1
X$2171 VPWR VGND \$2077 \$2304 sg13cmos5l_inv_1
X$2172 VPWR VGND \$1741 \$1733 sg13cmos5l_inv_1
X$2173 VPWR VGND \$204 \$479 sg13cmos5l_inv_1
X$2174 VPWR VGND \$854 \$901 sg13cmos5l_inv_1
X$2175 VPWR VGND \$1806 \$1996 sg13cmos5l_inv_1
X$2176 VPWR VGND \$78 \$440 sg13cmos5l_inv_1
X$2177 VPWR VGND \$374 \$489 sg13cmos5l_inv_1
X$2178 VPWR VGND \$1027 \$1722 sg13cmos5l_inv_1
X$2179 VPWR VGND \$962 \$1551 sg13cmos5l_inv_1
X$2180 VPWR VGND \$66 \$117 sg13cmos5l_inv_1
X$2181 VPWR VGND \$520 \$434 sg13cmos5l_inv_1
X$2182 VPWR VGND \$3453 \$3392 sg13cmos5l_inv_1
X$2183 VPWR VGND \$2023 \$2221 sg13cmos5l_inv_1
X$2184 VPWR VGND \$98 \$412 sg13cmos5l_inv_1
X$2185 VPWR VGND \$3546 \$3584 sg13cmos5l_inv_1
X$2186 VPWR VGND \$234 \$172 sg13cmos5l_inv_1
X$2187 VPWR VGND \$235 \$509 sg13cmos5l_inv_1
X$2188 VPWR VGND \$46 \$144 sg13cmos5l_inv_1
X$2189 VPWR VGND \$2885 \$2755 sg13cmos5l_inv_1
X$2190 VPWR VGND \$2427 \$2515 sg13cmos5l_inv_1
X$2191 VPWR VGND \$2861 \$2609 sg13cmos5l_inv_1
X$2192 VPWR VGND \$1158 \$1845 sg13cmos5l_inv_1
X$2193 VPWR VGND \$2125 \$2383 sg13cmos5l_inv_1
X$2194 VPWR VGND \$2088 \$1873 sg13cmos5l_inv_1
X$2267 \$2742 VPWR VGND sg13cmos5l_tiehi
X$2268 \$2276 VPWR VGND sg13cmos5l_tiehi
X$2269 \$2093 VPWR VGND sg13cmos5l_tiehi
X$2270 \$1941 VPWR VGND sg13cmos5l_tiehi
X$2271 \$2741 VPWR VGND sg13cmos5l_tiehi
X$2272 \$4204 VPWR VGND sg13cmos5l_tiehi
X$2273 \$1783 VPWR VGND sg13cmos5l_tiehi
X$2274 \$4091 VPWR VGND sg13cmos5l_tiehi
X$2275 \$1887 VPWR VGND sg13cmos5l_tiehi
X$2276 \$2015 VPWR VGND sg13cmos5l_tiehi
X$2277 \$2208 VPWR VGND sg13cmos5l_tiehi
X$2278 \$3315 VPWR VGND sg13cmos5l_tiehi
X$2279 \$2006 VPWR VGND sg13cmos5l_tiehi
X$2280 \$3567 VPWR VGND sg13cmos5l_tiehi
X$2281 \$1888 VPWR VGND sg13cmos5l_tiehi
X$2282 \$3369 VPWR VGND sg13cmos5l_tiehi
X$2408 VPWR VGND sg13cmos5l_decap_8
X$2409 VPWR VGND sg13cmos5l_decap_8
X$2410 VPWR VGND sg13cmos5l_decap_8
X$2411 VPWR VGND sg13cmos5l_decap_8
X$2412 VPWR VGND sg13cmos5l_decap_8
X$2413 VPWR VGND sg13cmos5l_decap_8
X$2414 VPWR VGND sg13cmos5l_decap_8
X$2415 VPWR VGND sg13cmos5l_decap_8
X$2416 VPWR VGND sg13cmos5l_decap_8
X$2417 VPWR VGND sg13cmos5l_decap_8
X$2418 VPWR VGND sg13cmos5l_decap_8
X$2419 VPWR VGND sg13cmos5l_decap_8
X$2420 VPWR VGND sg13cmos5l_decap_8
X$2421 VPWR VGND sg13cmos5l_decap_8
X$2422 VPWR VGND sg13cmos5l_decap_8
X$2423 VPWR VGND sg13cmos5l_decap_8
X$2424 VPWR VGND sg13cmos5l_decap_8
X$2425 VPWR VGND sg13cmos5l_decap_8
X$2426 VPWR VGND sg13cmos5l_decap_8
X$2427 VPWR VGND sg13cmos5l_decap_8
X$2428 VPWR VGND sg13cmos5l_decap_8
X$2429 VPWR VGND sg13cmos5l_decap_8
X$2430 VPWR VGND sg13cmos5l_decap_8
X$2431 VPWR VGND sg13cmos5l_decap_8
X$2432 VPWR VGND sg13cmos5l_decap_8
X$2433 VPWR VGND sg13cmos5l_decap_8
X$2434 VPWR VGND sg13cmos5l_decap_8
X$2435 VPWR VGND sg13cmos5l_decap_8
X$2436 VPWR VGND sg13cmos5l_decap_8
X$2437 VPWR VGND sg13cmos5l_decap_8
X$2438 VPWR VGND sg13cmos5l_decap_8
X$2439 VPWR VGND sg13cmos5l_decap_8
X$2440 VPWR VGND sg13cmos5l_decap_8
X$2441 VPWR VGND \$549 \$548 \$368 \$443 \$527 sg13cmos5l_nor4_1
X$2442 VPWR VGND \$549 \$438 \$520 \$601 sg13cmos5l_nand3b_1
X$2443 VPWR VGND sg13cmos5l_decap_8
X$2444 VPWR VGND sg13cmos5l_decap_8
X$2445 VPWR VGND sg13cmos5l_decap_8
X$2446 VPWR VGND sg13cmos5l_decap_8
X$2447 VPWR VGND sg13cmos5l_decap_8
X$2448 VPWR VGND sg13cmos5l_decap_8
X$2449 VPWR VGND sg13cmos5l_decap_8
X$2450 VPWR VGND sg13cmos5l_decap_8
X$2451 VPWR VGND sg13cmos5l_decap_8
X$2452 VPWR VGND sg13cmos5l_decap_8
X$2453 VPWR VGND sg13cmos5l_decap_8
X$2454 VPWR VGND sg13cmos5l_decap_8
X$2455 VPWR VGND sg13cmos5l_decap_8
X$2456 VPWR VGND sg13cmos5l_decap_8
X$2457 VPWR VGND sg13cmos5l_decap_8
X$2458 VPWR VGND sg13cmos5l_decap_8
X$2459 VPWR VGND sg13cmos5l_decap_8
X$2460 VPWR VGND sg13cmos5l_decap_8
X$2461 VPWR VGND sg13cmos5l_decap_8
X$2462 VPWR VGND sg13cmos5l_decap_8
X$2463 VPWR VGND sg13cmos5l_decap_8
X$2464 VPWR VGND sg13cmos5l_decap_8
X$2465 VPWR VGND sg13cmos5l_decap_8
X$2466 VPWR VGND sg13cmos5l_decap_8
X$2467 VPWR VGND sg13cmos5l_decap_8
X$2468 VPWR VGND sg13cmos5l_decap_8
X$2469 VPWR VGND sg13cmos5l_decap_8
X$2470 VPWR VGND sg13cmos5l_decap_8
X$2471 VPWR VGND sg13cmos5l_decap_8
X$2472 VPWR VGND sg13cmos5l_decap_8
X$2473 VPWR VGND sg13cmos5l_decap_8
X$2474 VPWR VGND sg13cmos5l_decap_8
X$2475 VPWR VGND \$1004 \$975 \$961 sg13cmos5l_nor2_1
X$2476 VPWR VGND \$3069 \$2774 \$3064 sg13cmos5l_nor2_1
X$2477 VPWR VGND \$307 \$369 \$75 sg13cmos5l_nor2_1
X$2478 VPWR VGND \$3061 \$3169 \$3168 sg13cmos5l_nor2_1
X$2479 VPWR VGND \$2882 \$2792 \$2830 sg13cmos5l_nor2_1
X$2480 VPWR VGND \$2230 \$2755 \$3101 sg13cmos5l_nor2_1
X$2481 VPWR VGND \$4490 \$4345 \$4346 sg13cmos5l_nor2_1
X$2482 VPWR VGND \$531 \$585 \$286 sg13cmos5l_nor2_1
X$2483 VPWR VGND \$739 \$1002 \$1005 sg13cmos5l_nor2_1
X$2484 VPWR VGND \$4014 \$2246 \$3833 sg13cmos5l_nor2_1
X$2485 VPWR VGND \$2960 \$3584 \$3419 sg13cmos5l_nor2_1
X$2486 VPWR VGND \$484 \$283 \$1085 sg13cmos5l_nor2_1
X$2487 VPWR VGND \$783 \$847 \$905 sg13cmos5l_nor2_1
X$2488 VPWR VGND \$75 \$362 \$240 sg13cmos5l_nor2_1
X$2489 VPWR VGND \$2367 \$2183 \$2188 sg13cmos5l_nor2_1
X$2490 VPWR VGND \$26 \$46 \$27 sg13cmos5l_nor2_1
X$2491 VPWR VGND \$3339 \$4030 \$4051 sg13cmos5l_nor2_1
X$2492 VPWR VGND \$37 \$36 \$34 sg13cmos5l_nor2_1
X$2493 VPWR VGND \$2297 \$2430 \$2350 sg13cmos5l_nor2_1
X$2494 VPWR VGND \$1085 \$177 \$1133 sg13cmos5l_nor2_1
X$2495 VPWR VGND \$238 \$30 \$274 sg13cmos5l_nor2_1
X$2496 VPWR VGND \$917 \$531 \$765 sg13cmos5l_nor2_1
X$2497 VPWR VGND \$2669 \$3235 \$3758 sg13cmos5l_nor2_1
X$2498 VPWR VGND \$307 \$177 \$970 sg13cmos5l_nor2_1
X$2499 VPWR VGND \$1632 \$1615 \$1605 sg13cmos5l_nor2_1
X$2500 VPWR VGND \$3351 \$2533 \$3231 sg13cmos5l_nor2_1
X$2501 VPWR VGND \$934 \$848 \$891 sg13cmos5l_nor2_1
X$2502 VPWR VGND \$3827 \$3313 \$3752 sg13cmos5l_nor2_1
X$2503 VPWR VGND \$306 \$343 \$583 sg13cmos5l_nor2_1
X$2504 VPWR VGND \$547 \$178 \$548 sg13cmos5l_nor2_1
X$2505 VPWR VGND \$3886 \$2533 \$3973 sg13cmos5l_nor2_1
X$2506 VPWR VGND \$2770 \$2369 \$2768 sg13cmos5l_nor2_1
X$2507 VPWR VGND \$124 \$435 \$359 sg13cmos5l_nor2_1
X$2508 VPWR VGND \$3429 \$4351 \$4394 sg13cmos5l_nor2_1
X$2509 VPWR VGND \$2071 \$2183 \$2118 sg13cmos5l_nor2_1
X$2510 VPWR VGND \$564 \$804 \$721 sg13cmos5l_nor2_1
X$2511 VPWR VGND \$704 \$765 \$620 sg13cmos5l_nor2_1
X$2512 VPWR VGND \$1198 \$1495 \$1524 sg13cmos5l_nor2_1
X$2513 VPWR VGND \$3860 \$3010 \$3735 sg13cmos5l_nor2_1
X$2514 VPWR VGND \$36 \$85 \$97 sg13cmos5l_nor2_1
X$2515 VPWR VGND \$70 \$67 \$55 sg13cmos5l_nor2_1
X$2516 VPWR VGND \$274 \$76 \$237 sg13cmos5l_nor2_1
X$2517 VPWR VGND \$3304 \$2774 \$3023 sg13cmos5l_nor2_1
X$2518 VPWR VGND \$286 \$49 \$279 sg13cmos5l_nor2_1
X$2519 VPWR VGND \$706 \$431 \$601 sg13cmos5l_nor2_1
X$2520 VPWR VGND \$2768 \$2183 \$2715 sg13cmos5l_nor2_1
X$2521 VPWR VGND \$912 \$33 \$911 sg13cmos5l_nor2_1
X$2522 VPWR VGND \$485 \$431 \$918 sg13cmos5l_nor2_1
X$2523 VPWR VGND \$144 \$117 \$52 sg13cmos5l_nor2_1
X$2524 VPWR VGND \$3726 \$3584 \$3860 sg13cmos5l_nor2_1
X$2525 VPWR VGND \$3883 \$3429 \$3882 sg13cmos5l_nor2_1
X$2526 VPWR VGND \$549 \$548 \$680 sg13cmos5l_nor2_1
X$2527 VPWR VGND \$46 \$66 \$137 sg13cmos5l_nor2_1
X$2528 VPWR VGND \$675 \$49 \$677 sg13cmos5l_nor2_1
X$2529 VPWR VGND \$601 \$520 \$708 sg13cmos5l_nor2_1
X$2530 VPWR VGND \$1605 \$975 \$1666 sg13cmos5l_nor2_1
X$2531 \$758 VGND \$756 VPWR \$680 \$708 sg13cmos5l_a21oi_1
X$2532 \$3152 VGND \$2872 VPWR \$2230 \$3101 sg13cmos5l_a21oi_1
X$2533 \$2750 VGND \$2625 VPWR \$2507 \$2641 sg13cmos5l_a21oi_1
X$2534 \$2450 VGND \$2358 VPWR \$1860 \$2111 sg13cmos5l_a21oi_1
X$2535 \$2385 VGND \$1706 VPWR \$1670 \$2383 sg13cmos5l_a21oi_1
X$2536 \$3175 VGND \$3003 VPWR \$2954 \$3419 sg13cmos5l_a21oi_1
X$2537 \$2483 VGND \$1988 VPWR \$2382 \$2385 sg13cmos5l_a21oi_1
X$2538 \$801 VGND \$841 VPWR \$1012 \$1296 sg13cmos5l_a21oi_1
X$2539 \$842 VGND \$926 VPWR \$674 \$995 sg13cmos5l_a21oi_1
X$2540 \$564 VGND \$447 VPWR \$319 \$531 sg13cmos5l_a21oi_1
X$2541 \$853 VGND \$652 VPWR \$713 \$77 sg13cmos5l_a21oi_1
X$2542 \$3220 VGND \$3172 VPWR \$3299 \$3112 sg13cmos5l_a21oi_1
X$2543 \$1045 VGND \$652 VPWR \$629 \$1043 sg13cmos5l_a21oi_1
X$2544 \$3642 VGND \$2799 VPWR \$3574 \$3392 sg13cmos5l_a21oi_1
X$2545 \$3304 VGND \$3488 VPWR \$3351 \$2609 sg13cmos5l_a21oi_1
X$2546 \$2600 VGND \$2369 VPWR \$2082 \$2326 sg13cmos5l_a21oi_1
X$2547 \$1574 VGND \$1613 VPWR \$1569 \$77 sg13cmos5l_a21oi_1
X$2548 \$1323 VGND \$748 VPWR \$1173 \$629 sg13cmos5l_a21oi_1
X$2549 \$2763 VGND \$2882 VPWR \$2885 \$2450 sg13cmos5l_a21oi_1
X$2550 \$4497 VGND \$3010 VPWR \$4342 \$4490 sg13cmos5l_a21oi_1
X$2551 \$107 VGND \$52 VPWR \$49 \$78 sg13cmos5l_a21oi_1
X$2552 \$2489 VGND \$2347 VPWR \$1995 \$1615 sg13cmos5l_a21oi_1
X$2553 \$1632 VGND \$891 VPWR \$1133 \$1516 sg13cmos5l_a21oi_1
X$2554 \$1665 VGND \$1619 VPWR \$1605 \$1666 sg13cmos5l_a21oi_1
X$2555 \$3224 VGND \$3225 VPWR \$3231 \$3313 sg13cmos5l_a21oi_1
X$2556 \$379 VGND \$289 VPWR \$144 \$117 sg13cmos5l_a21oi_1
X$2557 \$697 VGND \$235 VPWR \$748 \$78 sg13cmos5l_a21oi_1
X$2558 \$2770 VGND \$2465 VPWR \$1871 \$2589 sg13cmos5l_a21oi_1
X$2559 \$3061 VGND \$2990 VPWR \$3059 \$3058 sg13cmos5l_a21oi_1
X$2560 \$935 VGND \$936 VPWR \$87 \$1092 sg13cmos5l_a21oi_1
X$2561 \$1053 VGND \$844 VPWR \$930 \$911 sg13cmos5l_a21oi_1
X$2562 \$3827 VGND \$4008 VPWR \$3081 \$4012 sg13cmos5l_a21oi_1
X$2563 \$3885 VGND \$3840 VPWR \$2777 \$2774 sg13cmos5l_a21oi_1
X$2564 \$595 VGND \$348 VPWR \$456 \$434 sg13cmos5l_a21oi_1
X$2565 \$2297 VGND \$739 VPWR \$1861 \$2023 sg13cmos5l_a21oi_1
X$2566 \$2626 VGND \$2510 VPWR \$2388 \$2246 sg13cmos5l_a21oi_1
X$2567 \$3747 VGND \$3486 VPWR \$3348 \$3748 sg13cmos5l_a21oi_1
X$2568 \$4490 VGND \$4343 VPWR \$4302 \$4344 sg13cmos5l_a21oi_1
X$2569 \$2534 VGND \$1706 VPWR \$1670 \$2969 sg13cmos5l_a21oi_1
X$2570 \$977 VGND \$961 VPWR \$578 \$704 sg13cmos5l_a21oi_1
X$2571 \$4157 VGND \$3977 VPWR \$3841 \$3779 sg13cmos5l_a21oi_1
X$2572 \$706 VGND \$532 VPWR \$531 \$695 sg13cmos5l_a21oi_1
X$2573 \$2220 VGND \$2350 VPWR \$2347 \$2246 sg13cmos5l_a21oi_1
X$2574 \$2372 VGND \$2723 VPWR \$2114 \$2658 sg13cmos5l_a21oi_1
X$2575 \$2888 VGND \$3058 VPWR \$3330 \$3282 sg13cmos5l_a21oi_1
X$4036 VGND \$68 \$611 \$969 \$81 VPWR sg13cmos5l_dfrbpq_1
X$4037 VGND \$1512 \$1158 \$1845 \$1423 VPWR sg13cmos5l_dfrbpq_1
X$4038 VGND \$1512 \$1423 \$1472 \$726 VPWR sg13cmos5l_dfrbpq_1
X$4039 VGND \$1697 \$1350 \$1665 \$1628 VPWR sg13cmos5l_dfrbpq_1
X$4040 VGND \$4221 \$3748 \$4002 \$3943 VPWR sg13cmos5l_dfrbpq_1
X$4041 VGND \$68 \$374 \$489 \$98 VPWR sg13cmos5l_dfrbpq_1
X$4042 VGND \$4026 \$4116 \$4341 \$3910 VPWR sg13cmos5l_dfrbpq_1
X$4043 VGND \$167 \$103 \$270 \$81 VPWR sg13cmos5l_dfrbpq_1
X$4044 VGND \$1697 \$1518 \$1699 \$1197 VPWR sg13cmos5l_dfrbpq_1
X$4045 VGND \$4026 \$4255 \$4337 \$3910 VPWR sg13cmos5l_dfrbpq_1
X$4046 VGND \$167 \$28 \$172 \$81 VPWR sg13cmos5l_dfrbpq_1
X$4047 VGND \$1512 \$1297 \$1657 \$1426 VPWR sg13cmos5l_dfrbpq_1
X$4048 VGND \$1747 \$1522 \$1996 \$1197 VPWR sg13cmos5l_dfrbpq_1
X$4049 VGND \$4221 \$3683 \$3930 \$2194 VPWR sg13cmos5l_dfrbpq_1
X$4050 VGND \$4221 \$3117 \$4183 \$3943 VPWR sg13cmos5l_dfrbpq_1
X$4051 VGND \$72 \$33 \$141 \$83 VPWR sg13cmos5l_dfrbpq_1
X$4052 VGND \$1558 \$1958 \$2026 \$1628 VPWR sg13cmos5l_dfrbpq_1
X$4053 VGND \$1747 \$1802 \$2191 \$1197 VPWR sg13cmos5l_dfrbpq_1
X$4054 VGND \$3706 \$3452 \$3771 \$2341 VPWR sg13cmos5l_dfrbpq_1
X$4055 VGND \$1747 \$2531 \$2120 \$2194 VPWR sg13cmos5l_dfrbpq_1
X$4056 VGND \$72 \$105 \$34 \$83 VPWR sg13cmos5l_dfrbpq_1
X$4057 VGND \$1558 \$2116 \$1864 \$1628 VPWR sg13cmos5l_dfrbpq_1
X$4058 VGND \$167 \$417 \$493 \$81 VPWR sg13cmos5l_dfrbpq_1
X$4059 VGND \$1747 \$1871 \$1796 \$1628 VPWR sg13cmos5l_dfrbpq_1
X$4060 VGND \$4026 \$4320 \$4207 \$3910 VPWR sg13cmos5l_dfrbpq_1
X$4061 VGND \$2732 \$2851 \$2597 \$2194 VPWR sg13cmos5l_dfrbpq_1
X$4062 VGND \$1558 \$2105 \$1843 \$1628 VPWR sg13cmos5l_dfrbpq_1
X$4063 VGND \$2528 \$3018 \$2713 \$2194 VPWR sg13cmos5l_dfrbpq_1
X$4064 VGND \$1747 \$2125 \$2087 \$2194 VPWR sg13cmos5l_dfrbpq_1
X$4065 VGND \$4221 \$4282 \$4190 \$3943 VPWR sg13cmos5l_dfrbpq_1
X$4066 VGND \$4221 \$4351 \$4275 \$3943 VPWR sg13cmos5l_dfrbpq_1
X$4067 VGND \$1747 \$2082 \$1979 \$1197 VPWR sg13cmos5l_dfrbpq_1
X$4068 VGND \$1512 \$769 \$1565 \$81 VPWR sg13cmos5l_dfrbpq_1
X$4069 VGND \$68 \$96 \$95 \$481 VPWR sg13cmos5l_dfrbpq_1
X$4070 VGND \$1558 \$962 \$1551 \$1027 VPWR sg13cmos5l_dfrbpq_1
X$4071 VGND \$261 \$1012 \$1364 \$1197 VPWR sg13cmos5l_dfrbpq_1
X$4072 VGND \$1697 \$1296 \$1638 \$1197 VPWR sg13cmos5l_dfrbpq_1
X$4073 VGND \$2528 \$3005 \$3618 \$2341 VPWR sg13cmos5l_dfrbpq_1
X$4074 VGND \$4221 \$4267 \$4346 \$3943 VPWR sg13cmos5l_dfrbpq_1
X$4075 VGND \$72 \$31 \$155 \$83 VPWR sg13cmos5l_dfrbpq_1
X$4076 VGND \$72 \$30 \$174 \$83 VPWR sg13cmos5l_dfrbpq_1
X$4077 VPWR VGND \$176 \$67 \$70 sg13cmos5l_and2_1
X$4078 VGND \$68 \$22 \$219 \$81 VPWR sg13cmos5l_dfrbpq_1
X$4079 VGND \$167 \$98 \$412 \$204 VPWR sg13cmos5l_dfrbpq_1
X$4080 VGND \$72 \$87 \$427 \$83 VPWR sg13cmos5l_dfrbpq_1
X$4081 VGND \$4026 \$2955 \$3855 \$3910 VPWR sg13cmos5l_dfrbpq_1
X$4082 VGND \$1747 \$1336 \$1873 \$462 VPWR sg13cmos5l_dfrbpq_1
X$4083 VGND \$1558 \$1338 \$1733 \$557 VPWR sg13cmos5l_dfrbpq_1
X$4084 VGND \$1558 \$1027 \$1722 \$1158 VPWR sg13cmos5l_dfrbpq_1
X$4085 VGND \$4026 \$3581 \$4164 \$3910 VPWR sg13cmos5l_dfrbpq_1
X$4086 VGND \$4026 \$3704 \$3975 \$2341 VPWR sg13cmos5l_dfrbpq_1
X$4087 VGND \$2528 \$2161 \$2504 \$2341 VPWR sg13cmos5l_dfrbpq_1
X$4088 VGND \$2528 \$2792 \$3149 \$2341 VPWR sg13cmos5l_dfrbpq_1
X$4089 VGND \$68 \$486 \$375 \$374 VPWR sg13cmos5l_dfrbpq_1
X$4090 VGND \$2528 \$2077 \$2524 \$2341 VPWR sg13cmos5l_dfrbpq_1
X$4091 VGND \$1558 \$1333 \$2112 \$1628 VPWR sg13cmos5l_dfrbpq_1
X$4092 VGND \$2528 \$2130 \$2543 \$2194 VPWR sg13cmos5l_dfrbpq_1
X$4093 VGND \$4221 \$4227 \$4306 \$3943 VPWR sg13cmos5l_dfrbpq_1
X$4094 VGND \$4221 \$4019 \$4195 \$3943 VPWR sg13cmos5l_dfrbpq_1
X$4095 VGND \$261 \$629 \$901 \$83 VPWR sg13cmos5l_dfrbpq_1
X$4096 VGND \$3706 \$3351 \$3826 \$2194 VPWR sg13cmos5l_dfrbpq_1
X$4097 VGND \$68 \$204 \$479 \$96 VPWR sg13cmos5l_dfrbpq_1
X$4098 VGND \$4026 \$4328 \$4108 \$3910 VPWR sg13cmos5l_dfrbpq_1
X$4099 VGND \$4026 \$4299 \$4099 \$3910 VPWR sg13cmos5l_dfrbpq_1
X$4100 VGND \$68 \$481 \$407 \$962 VPWR sg13cmos5l_dfrbpq_1
X$4101 VGND \$72 \$431 \$100 \$83 VPWR sg13cmos5l_dfrbpq_1
X$4102 VGND \$2528 \$2796 \$2749 \$2341 VPWR sg13cmos5l_dfrbpq_1
X$4103 VGND \$1558 \$2066 \$1846 \$1628 VPWR sg13cmos5l_dfrbpq_1
X$4104 VGND \$1747 \$1915 \$1805 \$1197 VPWR sg13cmos5l_dfrbpq_1
X$4105 VPWR VGND \$1056 \$1518 sg13cmos5l_dlygate4sd3_1
X$4106 VPWR VGND \$46 \$118 sg13cmos5l_dlygate4sd3_1
X$4107 VPWR VGND \$916 \$1350 sg13cmos5l_dlygate4sd3_1
X$4108 VPWR VGND \$1093 \$1045 sg13cmos5l_dlygate4sd3_1
X$4109 VPWR VGND \$2326 \$2851 sg13cmos5l_dlygate4sd3_1
X$4110 VPWR VGND \$2120 \$2316 sg13cmos5l_dlygate4sd3_1
X$4111 VPWR VGND \$2078 \$2116 sg13cmos5l_dlygate4sd3_1
X$4112 VPWR VGND \$1864 \$1967 sg13cmos5l_dlygate4sd3_1
X$4113 VPWR VGND \$4496 \$4497 sg13cmos5l_dlygate4sd3_1
X$4114 VPWR VGND \$2713 \$2908 sg13cmos5l_dlygate4sd3_1
X$4115 VPWR VGND \$4275 \$4353 sg13cmos5l_dlygate4sd3_1
X$4116 VPWR VGND \$2087 \$2386 sg13cmos5l_dlygate4sd3_1
X$4117 VPWR VGND \$1796 \$2124 sg13cmos5l_dlygate4sd3_1
X$4118 VPWR VGND \$493 \$611 sg13cmos5l_dlygate4sd3_1
X$4119 VPWR VGND \$1979 \$2237 sg13cmos5l_dlygate4sd3_1
X$4120 VPWR VGND \$1843 \$2166 sg13cmos5l_dlygate4sd3_1
X$4121 VPWR VGND \$1846 \$1960 sg13cmos5l_dlygate4sd3_1
X$4122 VPWR VGND \$3568 \$3452 sg13cmos5l_dlygate4sd3_1
X$4123 VPWR VGND \$1638 \$1612 sg13cmos5l_dlygate4sd3_1
X$4124 VPWR VGND \$4338 \$4255 sg13cmos5l_dlygate4sd3_1
X$4125 VPWR VGND \$4340 \$4116 sg13cmos5l_dlygate4sd3_1
X$4126 VPWR VGND \$1805 \$1764 sg13cmos5l_dlygate4sd3_1
X$4127 VPWR VGND \$4212 \$4246 sg13cmos5l_dlygate4sd3_1
X$4128 VPWR VGND \$2321 \$1802 sg13cmos5l_dlygate4sd3_1
X$4129 VPWR VGND \$2309 \$2130 sg13cmos5l_dlygate4sd3_1
X$4130 VPWR VGND \$2589 \$2531 sg13cmos5l_dlygate4sd3_1
X$4131 VPWR VGND \$2023 \$1958 sg13cmos5l_dlygate4sd3_1
X$4132 VPWR VGND \$2164 \$2066 sg13cmos5l_dlygate4sd3_1
X$4133 VPWR VGND \$3098 \$2792 sg13cmos5l_dlygate4sd3_1
X$4134 VPWR VGND \$4049 \$2955 sg13cmos5l_dlygate4sd3_1
X$4135 VPWR VGND \$85 \$33 sg13cmos5l_dlygate4sd3_1
X$4136 VPWR VGND \$4118 \$3117 sg13cmos5l_dlygate4sd3_1
X$4137 VPWR VGND \$1615 \$1802 sg13cmos5l_dlygate4sd3_1
X$4138 VPWR VGND \$4359 \$4294 sg13cmos5l_dlygate4sd3_1
X$4139 VPWR VGND \$4190 \$4189 sg13cmos5l_dlygate4sd3_1
X$4140 VPWR VGND \$2091 \$1915 sg13cmos5l_dlygate4sd3_1
X$4141 VPWR VGND \$2193 \$2082 sg13cmos5l_dlygate4sd3_1
X$4142 VPWR VGND \$343 \$87 sg13cmos5l_dlygate4sd3_1
X$4143 VPWR VGND \$1364 \$1181 sg13cmos5l_dlygate4sd3_1
X$4144 VPWR VGND \$2597 \$2372 sg13cmos5l_dlygate4sd3_1
X$4145 VPWR VGND \$2427 \$2161 sg13cmos5l_dlygate4sd3_1
X$4146 VPWR VGND \$3631 \$4299 sg13cmos5l_dlygate4sd3_1
X$4147 VPWR VGND \$2628 \$2796 sg13cmos5l_dlygate4sd3_1
X$4148 VPWR VGND \$102 \$97 sg13cmos5l_dlygate4sd3_1
X$4149 VPWR VGND \$4030 \$4328 sg13cmos5l_dlygate4sd3_1
X$4150 VPWR VGND \$29 \$28 sg13cmos5l_dlygate4sd3_1
X$4151 VPWR VGND \$318 \$769 sg13cmos5l_dlygate4sd3_1
X$4152 VPWR VGND \$3480 \$3748 sg13cmos5l_dlygate4sd3_1
X$4153 VPWR VGND \$3886 \$4019 sg13cmos5l_dlygate4sd3_1
X$4154 VPWR VGND \$270 \$417 sg13cmos5l_dlygate4sd3_1
X$4155 VPWR VGND \$2165 \$2022 sg13cmos5l_dlygate4sd3_1
X$4156 VPWR VGND \$1252 \$1333 sg13cmos5l_dlygate4sd3_1
X$4157 VPWR VGND \$2026 \$2168 sg13cmos5l_dlygate4sd3_1
X$4158 VPWR VGND \$4108 \$4251 sg13cmos5l_dlygate4sd3_1
X$4159 VPWR VGND \$50 \$30 sg13cmos5l_dlygate4sd3_1
X$4160 VPWR VGND \$1495 \$1296 sg13cmos5l_dlygate4sd3_1
X$4161 VPWR VGND \$1569 \$1522 sg13cmos5l_dlygate4sd3_1
X$4162 VPWR VGND \$2658 \$2600 sg13cmos5l_dlygate4sd3_1
X$4163 VPWR VGND \$123 \$55 sg13cmos5l_dlygate4sd3_1
X$4164 VPWR VGND \$4172 \$3581 sg13cmos5l_dlygate4sd3_1
X$4165 VPWR VGND \$1043 \$1012 sg13cmos5l_dlygate4sd3_1
X$4166 VPWR VGND \$2861 \$3018 sg13cmos5l_dlygate4sd3_1
X$4167 VPWR VGND \$4207 \$3972 sg13cmos5l_dlygate4sd3_1
X$4168 VPWR VGND \$2065 \$2105 sg13cmos5l_dlygate4sd3_1
X$4169 VPWR VGND \$4354 \$4282 sg13cmos5l_dlygate4sd3_1
X$4170 VPWR VGND \$4342 \$4267 sg13cmos5l_dlygate4sd3_1
X$4171 VPWR VGND \$1806 \$1760 sg13cmos5l_dlygate4sd3_1
X$4172 VPWR VGND \$3376 \$3005 sg13cmos5l_dlygate4sd3_1
X$4173 VPWR VGND \$1606 \$1524 sg13cmos5l_dlygate4sd3_1
X$4174 VPWR VGND \$2313 \$2125 sg13cmos5l_dlygate4sd3_1
X$4175 VPWR VGND \$3975 \$3976 sg13cmos5l_dlygate4sd3_1
X$4176 VPWR VGND \$4196 \$4227 sg13cmos5l_dlygate4sd3_1
X$4177 VPWR VGND \$2459 \$2077 sg13cmos5l_dlygate4sd3_1
X$4178 VPWR VGND \$435 \$431 sg13cmos5l_dlygate4sd3_1
X$4179 VPWR VGND \$1906 \$1871 sg13cmos5l_dlygate4sd3_1
X$4180 VPWR VGND \$160 \$107 sg13cmos5l_dlygate4sd3_1
X$4181 VPWR VGND \$4306 \$4289 sg13cmos5l_dlygate4sd3_1
X$4182 VPWR VGND \$713 \$629 sg13cmos5l_dlygate4sd3_1
X$4183 VPWR VGND \$215 \$103 sg13cmos5l_dlygate4sd3_1
X$4184 VPWR VGND \$152 \$105 sg13cmos5l_dlygate4sd3_1
X$4185 VPWR VGND \$67 \$31 sg13cmos5l_dlygate4sd3_1
X$4186 VPWR VGND \$3894 \$3704 sg13cmos5l_dlygate4sd3_1
X$4286 VPWR VGND \$626 \$704 \$578 \$451 sg13cmos5l_a21o_1
X$5601 VGND \$3348 VPWR \$3429 sg13cmos5l_buf_1
X$5602 VGND \$4026 VPWR \$3706 sg13cmos5l_buf_1
X$5603 VGND \$3334 VPWR \$3568 sg13cmos5l_buf_1
X$5604 VGND \$283 VPWR \$1252 sg13cmos5l_buf_1
X$5605 VGND \$3429 VPWR \$3683 sg13cmos5l_buf_1
X$5606 VGND \$748 VPWR \$2357 sg13cmos5l_buf_1
X$5607 VGND \$2669 VPWR \$2489 sg13cmos5l_buf_1
X$5608 VGND \$4221 VPWR \$3706 sg13cmos5l_buf_1
X$5609 VGND \$1558 VPWR \$1697 sg13cmos5l_buf_1
X$5610 VGND \$3222 VPWR \$2246 sg13cmos5l_buf_1
X$5611 VGND \$1861 VPWR \$2309 sg13cmos5l_buf_1
X$5612 VGND \$1747 VPWR \$1697 sg13cmos5l_buf_1
X$5613 VGND \$3081 VPWR \$3351 sg13cmos5l_buf_1
X$5614 VGND \$1077 VPWR \$318 sg13cmos5l_buf_1
X$5615 VGND \$585 VPWR \$975 sg13cmos5l_buf_1
X$5616 VGND \$3313 VPWR \$2347 sg13cmos5l_buf_1
X$5617 VGND \$1697 VPWR \$261 sg13cmos5l_buf_1
X$5618 VGND \$3352 VPWR \$3480 sg13cmos5l_buf_1
X$5619 VGND \$1004 VPWR \$1056 sg13cmos5l_buf_1
X$5620 VGND \$I18147 VPWR \$1426 sg13cmos5l_buf_1
X$5621 VGND \$167 VPWR \$72 sg13cmos5l_buf_1
X$5622 VGND \$3706 VPWR \$2528 sg13cmos5l_buf_1
X$5623 VGND \$233 VPWR \$283 sg13cmos5l_buf_1
X$5624 VGND \$3546 VPWR \$4172 sg13cmos5l_buf_1
X$5625 VGND \$2885 VPWR \$2792 sg13cmos5l_buf_1
X$5626 VGND \$49 VPWR \$29 sg13cmos5l_buf_1
X$5627 VGND \$78 VPWR \$50 sg13cmos5l_buf_1
X$5628 VGND \$2645 VPWR \$2483 sg13cmos5l_buf_1
X$5629 VGND \$68 VPWR \$72 sg13cmos5l_buf_1
X$5630 VGND \$2945 VPWR \$3224 sg13cmos5l_buf_1
X$5631 VGND \$975 VPWR \$916 sg13cmos5l_buf_1
X$5632 VGND \$922 VPWR \$1004 sg13cmos5l_buf_1
X$5633 VGND \$2528 VPWR \$2732 sg13cmos5l_buf_1
X$5634 VGND \$644 VPWR \$1333 sg13cmos5l_buf_1
X$5635 VGND \$43 VPWR vctrl_in sg13cmos5l_buf_1
X$5636 VPWR VGND \$169 \$78 \$238 sg13cmos5l_nand2_1
X$5637 VGND \$261 VPWR \$2732 sg13cmos5l_buf_1
X$5638 VGND \$72 VPWR \$261 sg13cmos5l_buf_1
X$5639 VGND \$1512 VPWR \$1697 sg13cmos5l_buf_1
X$5640 VGND \$739 VPWR \$1085 sg13cmos5l_buf_1
X$5641 VGND \$2781 VPWR \$2645 sg13cmos5l_buf_1
X$5642 VGND \$4297 VPWR \$4320 sg13cmos5l_buf_1
X$5643 VGND \$41 VPWR vctrl_b_in sg13cmos5l_buf_1
X$5644 VGND \$578 VPWR \$369 sg13cmos5l_buf_1
X$5645 VGND \$I18123 VPWR \$557 sg13cmos5l_buf_1
X$5646 VGND \$I18122 VPWR \$726 sg13cmos5l_buf_1
X$5647 VGND \$408 VPWR \$41 sg13cmos5l_buf_1
X$5648 VGND \$2533 VPWR \$2609 sg13cmos5l_buf_1
X$5649 VGND \$2882 VPWR \$2358 sg13cmos5l_buf_1
X$5650 VGND \$3198 VPWR \$2347 sg13cmos5l_buf_1
X$5651 VGND \$3339 VPWR \$3452 sg13cmos5l_buf_1
X$5652 VGND \$2732 VPWR rst_n sg13cmos5l_buf_1
X$5653 VGND \$3453 VPWR \$3005 sg13cmos5l_buf_1
X$5654 VGND \$2952 VPWR \$4049 sg13cmos5l_buf_1
X$5655 VGND \$77 VPWR \$79 sg13cmos5l_buf_1
X$5656 VGND \$2347 VPWR \$2388 sg13cmos5l_buf_1
X$5657 VGND \$2246 VPWR \$2319 sg13cmos5l_buf_1
X$5658 VGND \$2358 VPWR \$748 sg13cmos5l_buf_1
X$5659 VGND \$26 VPWR \$77 sg13cmos5l_buf_1
X$5660 VGND \$3010 VPWR \$4118 sg13cmos5l_buf_1
X$5661 VGND \$178 VPWR \$152 sg13cmos5l_buf_1
X$5662 VGND \$373 VPWR \$318 sg13cmos5l_buf_1
X$8025 VPWR VGND sg13cmos5l_decap_4
X$8026 VPWR VGND sg13cmos5l_decap_4
X$8027 VPWR VGND sg13cmos5l_decap_4
X$8028 VPWR VGND sg13cmos5l_decap_4
X$8029 VPWR VGND sg13cmos5l_decap_4
X$8030 VPWR VGND sg13cmos5l_decap_4
X$8031 VPWR VGND sg13cmos5l_decap_4
X$8032 VPWR VGND sg13cmos5l_decap_4
X$8033 VPWR VGND sg13cmos5l_decap_4
X$8034 VPWR VGND sg13cmos5l_decap_4
X$8035 VPWR VGND sg13cmos5l_decap_4
X$8036 VPWR VGND sg13cmos5l_decap_4
X$8037 VPWR VGND sg13cmos5l_decap_4
X$8038 VPWR VGND sg13cmos5l_decap_4
X$8039 VPWR VGND sg13cmos5l_decap_4
X$8040 VPWR VGND sg13cmos5l_decap_4
X$8041 VPWR VGND sg13cmos5l_decap_4
X$8042 VPWR VGND sg13cmos5l_decap_4
X$8043 VPWR VGND sg13cmos5l_decap_4
X$8044 VPWR VGND sg13cmos5l_decap_4
X$8045 VPWR VGND sg13cmos5l_decap_4
X$8046 VPWR VGND sg13cmos5l_decap_4
X$8047 VPWR VGND sg13cmos5l_decap_4
X$8048 VPWR VGND sg13cmos5l_decap_4
X$8049 VPWR VGND sg13cmos5l_decap_4
X$8050 VPWR VGND sg13cmos5l_decap_4
X$8051 VPWR VGND sg13cmos5l_decap_4
X$8052 VPWR VGND sg13cmos5l_decap_4
X$8053 VPWR VGND sg13cmos5l_decap_4
X$8054 VPWR VGND sg13cmos5l_decap_4
X$8055 VPWR VGND sg13cmos5l_decap_4
X$8056 VPWR VGND sg13cmos5l_decap_4
X$8057 VPWR VGND sg13cmos5l_decap_4
X$8058 VPWR VGND sg13cmos5l_decap_4
X$8059 VPWR VGND sg13cmos5l_decap_4
X$8060 VPWR VGND sg13cmos5l_decap_4
X$8061 VPWR VGND sg13cmos5l_decap_4
X$8062 VPWR VGND sg13cmos5l_decap_4
X$8063 VPWR VGND sg13cmos5l_decap_4
X$10746 VPWR VGND sg13cmos5l_decap_4
X$10748 VGND \$414 VPWR \$43 sg13cmos5l_buf_1
X$10752 VPWR VGND \$66 \$22 sg13cmos5l_dlygate4sd3_1
X$10753 VGND \$68 \$118 \$27 \$81 VPWR sg13cmos5l_dfrbpq_1
X$10755 \$45 VGND \$52 VPWR \$49 \$26 sg13cmos5l_a21oi_1
X$10756 VPWR VGND \$75 \$31 \$76 sg13cmos5l_nor2_1
X$10757 VPWR VGND sg13cmos5l_decap_8
X$10759 in_tieon VPWR VGND sg13cmos5l_tiehi
X$10762 VPWR VGND \$96 \$95 sg13cmos5l_inv_1
X$10763 VPWR VGND \$78 \$52 \$49 \$70 sg13cmos5l_and3_1
X$10764 VPWR VGND \$124 \$141 \$102 \$26 sg13cmos5l_nor3_1
X$10779 VGND \$37 VPWR \$177 \$176 \$178 sg13cmos5l_o21ai_1
X$10785 VPWR VGND \$270 \$215 \$177 sg13cmos5l_nand2b_1
X$10790 VGND VPWR \$79 \$215 \$270 sg13cmos5l_nor2b_1
X$10791 \$105 \$308 \$307 VPWR VGND sg13cmos5l_or2_1
X$10809 \$506 VGND VPWR \$289 \$369 \$534 \$137 sg13cmos5l_a22oi_1
X$10810 VGND \$614 \$81 VPWR sg13cmos5l_buf_8
X$10838 VPWR VGND \$1092 \$1173 \$629 sg13cmos5l_xnor2_1
X$10885 VPWR VGND \$1860 \$2111 \$283 \$484 \$2230 sg13cmos5l_or4_1
X$10902 in_tieoff VPWR VGND sg13cmos5l_tielo
M$1 \$312 \$250 \$313 VAPWR sg13_hv_pmos L=0.5u W=16u AS=5.44p AD=5.44p
+ PS=34.72u PD=34.72u rfmode=0
M$2 \$391 \$391 \$391 VGND sg13_hv_nmos L=0.5u W=2u AS=0.68p AD=0.68p PS=4.68u
+ PD=4.68u rfmode=0
M$3 \$313 \$313 \$313 VAPWR sg13_hv_pmos L=0.5u W=12u AS=4.08p AD=4.08p
+ PS=26.04u PD=26.04u rfmode=0
M$4 \$312 \$312 \$312 VGND sg13_hv_nmos L=0.5u W=2u AS=0.68p AD=0.68p PS=4.68u
+ PD=4.68u rfmode=0
M$5 \$391 analog_1 \$313 VAPWR sg13_hv_pmos L=0.5u W=16u AS=5.44p AD=5.44p
+ PS=34.72u PD=34.72u rfmode=0
M$7 \$391 \$391 VGND VGND sg13_hv_nmos L=0.5u W=8u AS=2.72p AD=2.72p PS=18.72u
+ PD=18.72u rfmode=0
M$8 \$312 \$391 VGND VGND sg13_hv_nmos L=0.5u W=8u AS=2.72p AD=2.72p PS=18.72u
+ PD=18.72u rfmode=0
M$10 VGND VGND VGND VGND sg13_hv_nmos L=0.5u W=38.5u AS=13.09p AD=13.09p
+ PS=96.72u PD=96.72u rfmode=0
M$13 \$312 \$312 \$312 VAPWR sg13_hv_pmos L=0.5u W=4u AS=1.36p AD=1.36p
+ PS=8.68u PD=8.68u rfmode=0
M$17 \$391 \$391 \$391 VAPWR sg13_hv_pmos L=0.5u W=4u AS=1.36p AD=1.36p
+ PS=8.68u PD=8.68u rfmode=0
R$22 VGND \$250 VGND rhigh w=2u l=12.9u ps=0u b=0 m=1
R$26 \$1186 VGND VGND rhigh w=2u l=4.25u ps=0u b=0 m=1
M$27 \$1371 \$1371 \$1371 VGND sg13_hv_nmos L=0.5u W=2u AS=0.68p AD=0.68p
+ PS=4.68u PD=4.68u rfmode=0
M$29 \$1371 \$1452 VGND VGND sg13_hv_nmos L=0.5u W=8u AS=2.72p AD=2.72p
+ PS=18.72u PD=18.72u rfmode=0
M$31 \$1452 \$1452 VGND VGND sg13_hv_nmos L=0.5u W=8u AS=2.72p AD=2.72p
+ PS=18.72u PD=18.72u rfmode=0
M$34 \$1452 \$1452 \$1452 VGND sg13_hv_nmos L=0.5u W=2u AS=0.68p AD=0.68p
+ PS=4.68u PD=4.68u rfmode=0
R$38 \$250 \$1266 VGND rhigh w=2u l=2.8u ps=0u b=0 m=1
M$39 \$1452 analog_1 \$1372 VAPWR sg13_hv_pmos L=0.5u W=16u AS=5.44p AD=5.44p
+ PS=34.72u PD=34.72u rfmode=0
M$41 \$1371 \$1371 \$1371 VAPWR sg13_hv_pmos L=0.5u W=4u AS=1.36p AD=1.36p
+ PS=8.68u PD=8.68u rfmode=0
M$42 \$1371 \$1266 \$1372 VAPWR sg13_hv_pmos L=0.5u W=16u AS=5.44p AD=5.44p
+ PS=34.72u PD=34.72u rfmode=0
M$44 \$1372 \$1372 \$1372 VAPWR sg13_hv_pmos L=0.5u W=12u AS=4.08p AD=4.08p
+ PS=26.04u PD=26.04u rfmode=0
M$46 \$1452 \$1452 \$1452 VAPWR sg13_hv_pmos L=0.5u W=4u AS=1.36p AD=1.36p
+ PS=8.68u PD=8.68u rfmode=0
M$52 \$2133 \$2133 VGND VGND sg13_hv_nmos L=0.5u W=8u AS=2.72p AD=2.72p
+ PS=18.72u PD=18.72u rfmode=0
M$54 \$2131 \$2133 VGND VGND sg13_hv_nmos L=0.5u W=8u AS=2.72p AD=2.72p
+ PS=18.72u PD=18.72u rfmode=0
M$56 \$2131 \$2131 \$2131 VGND sg13_hv_nmos L=0.5u W=2u AS=0.68p AD=0.68p
+ PS=4.68u PD=4.68u rfmode=0
M$59 \$2134 \$2134 \$2134 VAPWR sg13_hv_pmos L=0.5u W=12u AS=4.08p AD=4.08p
+ PS=26.04u PD=26.04u rfmode=0
M$60 \$2133 analog_1 \$2134 VAPWR sg13_hv_pmos L=0.5u W=16u AS=5.44p AD=5.44p
+ PS=34.72u PD=34.72u rfmode=0
M$62 \$2131 \$2041 \$2134 VAPWR sg13_hv_pmos L=0.5u W=16u AS=5.44p AD=5.44p
+ PS=34.72u PD=34.72u rfmode=0
M$69 \$2133 \$2133 \$2133 VGND sg13_hv_nmos L=0.5u W=2u AS=0.68p AD=0.68p
+ PS=4.68u PD=4.68u rfmode=0
M$70 VGND \$1684 \$I24116 VGND sg13_lv_nmos L=0.13u W=0.55u AS=0.14505p
+ AD=0.187p PS=1.15u PD=1.78u rfmode=0
M$71 VGND \$1779 \$I24117 VGND sg13_lv_nmos L=0.13u W=0.74u AS=0.14505p
+ AD=0.1406p PS=1.15u PD=1.12u rfmode=0
M$72 \$I24117 \$I24116 \$1896 VGND sg13_lv_nmos L=0.13u W=0.74u AS=0.1406p
+ AD=0.333p PS=1.12u PD=2.38u rfmode=0
M$73 \$I24116 \$1684 VPWR VPWR sg13_lv_pmos L=0.13u W=0.84u AS=0.2856p
+ AD=0.2198p PS=2.36u PD=1.53u rfmode=0
M$74 VPWR \$1779 \$1896 VPWR sg13_lv_pmos L=0.13u W=1.12u AS=0.2198p AD=0.2128p
+ PS=1.53u PD=1.5u rfmode=0
M$75 \$1896 \$I24116 VPWR VPWR sg13_lv_pmos L=0.13u W=1.12u AS=0.2128p
+ AD=0.3808p PS=1.5u PD=2.92u rfmode=0
M$76 \$1939 \$1894 \$I24120 VGND sg13_lv_nmos L=0.13u W=0.74u AS=0.2516p
+ AD=0.1406p PS=2.16u PD=1.12u rfmode=0
M$77 \$I24120 \$1784 VGND VGND sg13_lv_nmos L=0.13u W=0.74u AS=0.1406p
+ AD=0.2516p PS=1.12u PD=2.16u rfmode=0
M$78 \$1939 \$1782 VGND VGND sg13_lv_nmos L=0.13u W=0.74u AS=0.2516p AD=0.1406p
+ PS=2.16u PD=1.12u rfmode=0
M$79 VGND \$1785 \$I24121 VGND sg13_lv_nmos L=0.13u W=0.74u AS=0.1406p
+ AD=0.1406p PS=1.12u PD=1.12u rfmode=0
M$80 \$I24121 \$2014 \$1939 VGND sg13_lv_nmos L=0.13u W=0.74u AS=0.1406p
+ AD=0.2516p PS=1.12u PD=2.16u rfmode=0
M$81 VPWR \$1894 \$I24119 VPWR sg13_lv_pmos L=0.13u W=1.12u AS=0.3808p
+ AD=0.2128p PS=2.92u PD=1.5u rfmode=0
M$82 \$I24119 \$1784 VPWR VPWR sg13_lv_pmos L=0.13u W=1.12u AS=0.2128p
+ AD=0.3808p PS=1.5u PD=2.92u rfmode=0
M$83 \$1939 \$1782 \$I24118 VPWR sg13_lv_pmos L=0.13u W=1.12u AS=0.3808p
+ AD=0.2128p PS=2.92u PD=1.5u rfmode=0
M$84 \$I24118 \$1785 \$I24119 VPWR sg13_lv_pmos L=0.13u W=1.12u AS=0.2128p
+ AD=0.2128p PS=1.5u PD=1.5u rfmode=0
M$85 \$I24119 \$2014 \$I24118 VPWR sg13_lv_pmos L=0.13u W=1.12u AS=0.2128p
+ AD=0.3808p PS=1.5u PD=2.92u rfmode=0
M$86 \$2261 \$I24123 VGND VGND sg13_lv_nmos L=0.13u W=0.74u AS=0.2351p
+ AD=0.15745p PS=2.16u PD=1.175u rfmode=0
M$87 VGND \$1775 \$I24123 VGND sg13_lv_nmos L=0.13u W=0.64u AS=0.15745p
+ AD=0.1216p PS=1.175u PD=1.02u rfmode=0
M$88 \$I24123 \$1771 \$I24124 VGND sg13_lv_nmos L=0.13u W=0.64u AS=0.1216p
+ AD=0.0816p PS=1.02u PD=0.895u rfmode=0
M$89 \$I24124 \$1890 VGND VGND sg13_lv_nmos L=0.13u W=0.64u AS=0.0816p
+ AD=0.2176p PS=0.895u PD=1.96u rfmode=0
M$90 \$I24123 \$1775 \$I24122 VPWR sg13_lv_pmos L=0.13u W=1u AS=0.35p
+ AD=0.2125p PS=2.7u PD=1.425u rfmode=0
M$91 \$I24122 \$1771 VPWR VPWR sg13_lv_pmos L=0.13u W=1u AS=0.2125p AD=0.19p
+ PS=1.425u PD=1.38u rfmode=0
M$92 VPWR \$1890 \$I24122 VPWR sg13_lv_pmos L=0.13u W=1u AS=0.19p AD=0.34p
+ PS=1.38u PD=2.68u rfmode=0
M$93 \$2261 \$I24123 VPWR VPWR sg13_lv_pmos L=0.13u W=1.12u AS=0.3808p
+ AD=0.3808p PS=2.92u PD=2.92u rfmode=0
M$94 VGND \$1776 \$I24127 VGND sg13_lv_nmos L=0.13u W=0.64u AS=0.2272p
+ AD=0.0784p PS=1.99u PD=0.885u rfmode=0
M$95 \$I24127 \$1778 \$I24126 VGND sg13_lv_nmos L=0.13u W=0.64u AS=0.0784p
+ AD=0.2176p PS=0.885u PD=1.96u rfmode=0
M$96 VGND \$1776 \$I24125 VGND sg13_lv_nmos L=0.13u W=0.74u AS=0.1898p
+ AD=0.2516p PS=1.36u PD=2.16u rfmode=0
M$97 VGND \$1778 \$I24125 VGND sg13_lv_nmos L=0.13u W=0.74u AS=0.1898p
+ AD=0.1406p PS=1.36u PD=1.12u rfmode=0
M$98 \$I24125 \$I24126 \$1779 VGND sg13_lv_nmos L=0.13u W=0.74u AS=0.1406p
+ AD=0.2516p PS=1.12u PD=2.16u rfmode=0
M$99 VPWR \$1776 \$I24126 VPWR sg13_lv_pmos L=0.13u W=0.84u AS=0.4536p
+ AD=0.1596p PS=2.76u PD=1.22u rfmode=0
M$100 VPWR \$1778 \$I24126 VPWR sg13_lv_pmos L=0.13u W=0.84u AS=0.2891p
+ AD=0.1596p PS=1.695u PD=1.22u rfmode=0
M$101 VPWR \$1776 \$I24128 VPWR sg13_lv_pmos L=0.13u W=1.12u AS=0.2891p
+ AD=0.1428p PS=1.695u PD=1.375u rfmode=0
M$102 \$I24128 \$1778 \$1779 VPWR sg13_lv_pmos L=0.13u W=1.12u AS=0.1428p
+ AD=0.2408p PS=1.375u PD=1.55u rfmode=0
M$103 \$1779 \$I24126 VPWR VPWR sg13_lv_pmos L=0.13u W=1.12u AS=0.2408p
+ AD=0.3808p PS=1.55u PD=2.92u rfmode=0
M$104 VGND \$1682 \$I24129 VGND sg13_lv_nmos L=0.13u W=0.55u AS=0.18575p
+ AD=0.187p PS=1.26u PD=1.78u rfmode=0
M$105 VGND \$2016 \$I24131 VGND sg13_lv_nmos L=0.13u W=0.74u AS=0.18575p
+ AD=0.1406p PS=1.26u PD=1.12u rfmode=0
M$106 \$I24131 \$1896 \$I24130 VGND sg13_lv_nmos L=0.13u W=0.74u AS=0.1406p
+ AD=0.1406p PS=1.12u PD=1.12u rfmode=0
M$107 \$I24130 \$I24129 \$1784 VGND sg13_lv_nmos L=0.13u W=0.74u AS=0.1406p
+ AD=0.3404p PS=1.12u PD=2.4u rfmode=0
M$108 \$I24129 \$1682 VPWR VPWR sg13_lv_pmos L=0.13u W=0.84u AS=0.2856p
+ AD=0.2198p PS=2.36u PD=1.53u rfmode=0
M$109 VPWR \$2016 \$1784 VPWR sg13_lv_pmos L=0.13u W=1.12u AS=0.2198p
+ AD=0.2128p PS=1.53u PD=1.5u rfmode=0
M$110 \$1784 \$1896 VPWR VPWR sg13_lv_pmos L=0.13u W=1.12u AS=0.2128p
+ AD=0.2128p PS=1.5u PD=1.5u rfmode=0
M$111 VPWR \$I24129 \$1784 VPWR sg13_lv_pmos L=0.13u W=1.12u AS=0.2128p
+ AD=0.3808p PS=1.5u PD=2.92u rfmode=0
M$112 VGND \$1771 \$1682 VGND sg13_lv_nmos L=0.13u W=0.74u AS=0.2516p
+ AD=0.1406p PS=2.16u PD=1.12u rfmode=0
M$113 \$1682 \$2209 VGND VGND sg13_lv_nmos L=0.13u W=0.74u AS=0.1406p
+ AD=0.1406p PS=1.12u PD=1.12u rfmode=0
M$114 VGND \$2098 \$1682 VGND sg13_lv_nmos L=0.13u W=0.74u AS=0.1406p
+ AD=0.1406p PS=1.12u PD=1.12u rfmode=0
M$115 \$1682 \$2406 VGND VGND sg13_lv_nmos L=0.13u W=0.74u AS=0.1406p
+ AD=0.237575p PS=1.12u PD=2.16u rfmode=0
M$116 VPWR \$1771 \$I24133 VPWR sg13_lv_pmos L=0.13u W=1.12u AS=0.3808p
+ AD=0.2128p PS=2.92u PD=1.5u rfmode=0
M$117 \$I24133 \$2209 \$I24132 VPWR sg13_lv_pmos L=0.13u W=1.12u AS=0.2128p
+ AD=0.2128p PS=1.5u PD=1.5u rfmode=0
M$118 \$I24132 \$2098 \$I24134 VPWR sg13_lv_pmos L=0.13u W=1.12u AS=0.2128p
+ AD=0.2128p PS=1.5u PD=1.5u rfmode=0
M$119 \$I24134 \$2406 \$1682 VPWR sg13_lv_pmos L=0.13u W=1.12u AS=0.2128p
+ AD=0.4368p PS=1.5u PD=3.02u rfmode=0
M$120 VGND \$1773 \$2138 VGND sg13_lv_nmos L=0.13u W=0.74u AS=0.2516p
+ AD=0.1406p PS=2.16u PD=1.12u rfmode=0
M$121 \$2138 \$2203 \$I24136 VGND sg13_lv_nmos L=0.13u W=0.74u AS=0.1406p
+ AD=0.1406p PS=1.12u PD=1.12u rfmode=0
M$122 \$I24136 \$2151 VGND VGND sg13_lv_nmos L=0.13u W=0.74u AS=0.1406p
+ AD=0.2516p PS=1.12u PD=2.16u rfmode=0
M$123 \$2138 \$1773 \$I24135 VPWR sg13_lv_pmos L=0.13u W=1.12u AS=0.3808p
+ AD=0.2128p PS=2.92u PD=1.5u rfmode=0
M$124 \$I24135 \$2203 VPWR VPWR sg13_lv_pmos L=0.13u W=1.12u AS=0.2128p
+ AD=0.2128p PS=1.5u PD=1.5u rfmode=0
M$125 VPWR \$2151 \$I24135 VPWR sg13_lv_pmos L=0.13u W=1.12u AS=0.2128p
+ AD=0.3808p PS=1.5u PD=2.92u rfmode=0
M$126 VGND \$2261 \$2204 VGND sg13_lv_nmos L=0.13u W=0.74u AS=0.2516p
+ AD=0.1406p PS=2.16u PD=1.12u rfmode=0
M$127 \$2204 \$1769 \$I24138 VGND sg13_lv_nmos L=0.13u W=0.74u AS=0.1406p
+ AD=0.1406p PS=1.12u PD=1.12u rfmode=0
M$128 \$I24138 \$1770 VGND VGND sg13_lv_nmos L=0.13u W=0.74u AS=0.1406p
+ AD=0.2516p PS=1.12u PD=2.16u rfmode=0
M$129 \$2204 \$2261 \$I24137 VPWR sg13_lv_pmos L=0.13u W=1.12u AS=0.3808p
+ AD=0.2128p PS=2.92u PD=1.5u rfmode=0
M$130 \$I24137 \$1769 VPWR VPWR sg13_lv_pmos L=0.13u W=1.12u AS=0.2128p
+ AD=0.2128p PS=1.5u PD=1.5u rfmode=0
M$131 VPWR \$1770 \$I24137 VPWR sg13_lv_pmos L=0.13u W=1.12u AS=0.2128p
+ AD=0.3808p PS=1.5u PD=2.92u rfmode=0
M$132 VGND \$1681 \$1818 VGND sg13_lv_nmos L=0.13u W=0.74u AS=0.2516p
+ AD=0.1406p PS=2.16u PD=1.12u rfmode=0
M$133 \$1818 \$1679 \$I24140 VGND sg13_lv_nmos L=0.13u W=0.74u AS=0.1406p
+ AD=0.1406p PS=1.12u PD=1.12u rfmode=0
M$134 \$I24140 \$1682 VGND VGND sg13_lv_nmos L=0.13u W=0.74u AS=0.1406p
+ AD=0.2516p PS=1.12u PD=2.16u rfmode=0
M$135 \$1818 \$1681 \$I24139 VPWR sg13_lv_pmos L=0.13u W=1.12u AS=0.3808p
+ AD=0.2128p PS=2.92u PD=1.5u rfmode=0
M$136 \$I24139 \$1679 VPWR VPWR sg13_lv_pmos L=0.13u W=1.12u AS=0.2128p
+ AD=0.2128p PS=1.5u PD=1.5u rfmode=0
M$137 VPWR \$1682 \$I24139 VPWR sg13_lv_pmos L=0.13u W=1.12u AS=0.2128p
+ AD=0.3808p PS=1.5u PD=2.92u rfmode=0
M$138 VGND \$1896 \$I24142 VGND sg13_lv_nmos L=0.13u W=0.74u AS=0.2886p
+ AD=0.1406p PS=2.26u PD=1.12u rfmode=0
M$139 \$I24142 \$2101 \$I24141 VGND sg13_lv_nmos L=0.13u W=0.74u AS=0.1406p
+ AD=0.1406p PS=1.12u PD=1.12u rfmode=0
M$140 \$I24141 \$2095 \$2151 VGND sg13_lv_nmos L=0.13u W=0.74u AS=0.1406p
+ AD=0.2516p PS=1.12u PD=2.16u rfmode=0
M$141 VPWR \$1896 \$2151 VPWR sg13_lv_pmos L=0.13u W=1.12u AS=0.3808p
+ AD=0.2128p PS=2.92u PD=1.5u rfmode=0
M$142 \$2151 \$2101 VPWR VPWR sg13_lv_pmos L=0.13u W=1.12u AS=0.2128p
+ AD=0.2128p PS=1.5u PD=1.5u rfmode=0
M$143 VPWR \$2095 \$2151 VPWR sg13_lv_pmos L=0.13u W=1.12u AS=0.2128p
+ AD=0.3808p PS=1.5u PD=2.92u rfmode=0
M$144 VGND \$1770 \$I24143 VGND sg13_lv_nmos L=0.13u W=0.55u AS=0.187p
+ AD=0.1045p PS=1.78u PD=0.93u rfmode=0
M$145 \$I24143 \$1775 VGND VGND sg13_lv_nmos L=0.13u W=0.55u AS=0.1045p
+ AD=0.1469p PS=0.93u PD=1.155u rfmode=0
M$146 VGND \$I24143 \$1773 VGND sg13_lv_nmos L=0.13u W=0.74u AS=0.1469p
+ AD=0.2516p PS=1.155u PD=2.16u rfmode=0
M$147 \$I24143 \$1770 \$I24144 VPWR sg13_lv_pmos L=0.13u W=0.84u AS=0.2856p
+ AD=0.1596p PS=2.36u PD=1.22u rfmode=0
M$148 VPWR \$1775 \$I24144 VPWR sg13_lv_pmos L=0.13u W=0.84u AS=0.2226p
+ AD=0.1596p PS=1.535u PD=1.22u rfmode=0
M$149 VPWR \$I24143 \$1773 VPWR sg13_lv_pmos L=0.13u W=1.12u AS=0.2226p
+ AD=0.3976p PS=1.535u PD=2.95u rfmode=0
M$150 \$I24145 \$1684 VGND VGND sg13_lv_nmos L=0.15u W=0.74u AS=0.2516p
+ AD=0.1406p PS=2.16u PD=1.12u rfmode=0
M$151 VGND \$1779 \$I24145 VGND sg13_lv_nmos L=0.15u W=0.74u AS=0.1406p
+ AD=0.1406p PS=1.12u PD=1.12u rfmode=0
M$152 \$I24145 \$1890 \$1770 VGND sg13_lv_nmos L=0.15u W=0.74u AS=0.1406p
+ AD=0.2516p PS=1.12u PD=2.16u rfmode=0
M$153 VPWR \$1684 \$I24146 VPWR sg13_lv_pmos L=0.15u W=1.12u AS=0.3808p
+ AD=0.2128p PS=2.92u PD=1.5u rfmode=0
M$154 \$I24146 \$1779 \$1770 VPWR sg13_lv_pmos L=0.15u W=1.12u AS=0.2128p
+ AD=0.2128p PS=1.5u PD=1.5u rfmode=0
M$155 \$1770 \$1890 VPWR VPWR sg13_lv_pmos L=0.15u W=1.12u AS=0.2128p
+ AD=0.3808p PS=1.5u PD=2.92u rfmode=0
M$156 \$I24147 \$1684 VGND VGND sg13_lv_nmos L=0.15u W=0.74u AS=0.2516p
+ AD=0.1406p PS=2.16u PD=1.12u rfmode=0
M$157 VGND \$1779 \$I24147 VGND sg13_lv_nmos L=0.15u W=0.74u AS=0.1406p
+ AD=0.1406p PS=1.12u PD=1.12u rfmode=0
M$158 \$I24147 \$1680 \$1782 VGND sg13_lv_nmos L=0.15u W=0.74u AS=0.1406p
+ AD=0.2516p PS=1.12u PD=2.16u rfmode=0
M$159 VPWR \$1684 \$I24148 VPWR sg13_lv_pmos L=0.15u W=1.12u AS=0.3808p
+ AD=0.2128p PS=2.92u PD=1.5u rfmode=0
M$160 \$I24148 \$1779 \$1782 VPWR sg13_lv_pmos L=0.15u W=1.12u AS=0.2128p
+ AD=0.2128p PS=1.5u PD=1.5u rfmode=0
M$161 \$1782 \$1680 VPWR VPWR sg13_lv_pmos L=0.15u W=1.12u AS=0.2128p
+ AD=0.3808p PS=1.5u PD=2.92u rfmode=0
M$162 \$I24149 \$2016 VGND VGND sg13_lv_nmos L=0.15u W=0.74u AS=0.2516p
+ AD=0.1406p PS=2.16u PD=1.12u rfmode=0
M$163 VGND \$1684 \$I24149 VGND sg13_lv_nmos L=0.15u W=0.74u AS=0.1406p
+ AD=0.1406p PS=1.12u PD=1.12u rfmode=0
M$164 \$I24149 \$1680 \$2104 VGND sg13_lv_nmos L=0.15u W=0.74u AS=0.1406p
+ AD=0.2516p PS=1.12u PD=2.16u rfmode=0
M$165 VPWR \$2016 \$I24150 VPWR sg13_lv_pmos L=0.15u W=1.12u AS=0.3808p
+ AD=0.2128p PS=2.92u PD=1.5u rfmode=0
M$166 \$I24150 \$1684 \$2104 VPWR sg13_lv_pmos L=0.15u W=1.12u AS=0.2128p
+ AD=0.2128p PS=1.5u PD=1.5u rfmode=0
M$167 \$2104 \$1680 VPWR VPWR sg13_lv_pmos L=0.15u W=1.12u AS=0.2128p
+ AD=0.3808p PS=1.5u PD=2.92u rfmode=0
M$168 \$I24151 \$1776 VGND VGND sg13_lv_nmos L=0.15u W=0.74u AS=0.2516p
+ AD=0.1406p PS=2.16u PD=1.12u rfmode=0
M$169 VGND \$1682 \$I24151 VGND sg13_lv_nmos L=0.15u W=0.74u AS=0.1406p
+ AD=0.1406p PS=1.12u PD=1.12u rfmode=0
M$170 \$I24151 \$1680 \$1681 VGND sg13_lv_nmos L=0.15u W=0.74u AS=0.1406p
+ AD=0.2516p PS=1.12u PD=2.16u rfmode=0
M$171 VPWR \$1776 \$I24152 VPWR sg13_lv_pmos L=0.15u W=1.12u AS=0.3808p
+ AD=0.2128p PS=2.92u PD=1.5u rfmode=0
M$172 \$I24152 \$1682 \$1681 VPWR sg13_lv_pmos L=0.15u W=1.12u AS=0.2128p
+ AD=0.2128p PS=1.5u PD=1.5u rfmode=0
M$173 \$1681 \$1680 VPWR VPWR sg13_lv_pmos L=0.15u W=1.12u AS=0.2128p
+ AD=0.3808p PS=1.5u PD=2.92u rfmode=0
M$174 VGND \$1776 \$604 VGND sg13_lv_nmos L=0.13u W=0.74u AS=0.2516p AD=0.1406p
+ PS=2.16u PD=1.12u rfmode=0
M$175 \$604 \$1684 VGND VGND sg13_lv_nmos L=0.13u W=0.74u AS=0.1406p AD=0.2516p
+ PS=1.12u PD=2.16u rfmode=0
M$176 VPWR \$1776 \$I24153 VPWR sg13_lv_pmos L=0.13u W=1.12u AS=0.4032p
+ AD=0.1176p PS=2.96u PD=1.33u rfmode=0
M$177 \$I24153 \$1684 \$604 VPWR sg13_lv_pmos L=0.13u W=1.12u AS=0.1176p
+ AD=0.3808p PS=1.33u PD=2.92u rfmode=0
M$178 VGND \$1784 \$I24154 VGND sg13_lv_nmos L=0.13u W=0.55u AS=0.17255p
+ AD=0.187p PS=1.25u PD=1.78u rfmode=0
M$179 VGND \$I24154 \$2150 VGND sg13_lv_nmos L=0.13u W=0.74u AS=0.17255p
+ AD=0.1406p PS=1.25u PD=1.12u rfmode=0
M$180 \$2150 \$2103 VGND VGND sg13_lv_nmos L=0.13u W=0.74u AS=0.1406p
+ AD=0.2516p PS=1.12u PD=2.16u rfmode=0
M$181 \$I24154 \$1784 VPWR VPWR sg13_lv_pmos L=0.13u W=0.84u AS=0.2856p
+ AD=0.2618p PS=2.36u PD=1.63u rfmode=0
M$182 VPWR \$I24154 \$I24155 VPWR sg13_lv_pmos L=0.13u W=1.12u AS=0.2618p
+ AD=0.1176p PS=1.63u PD=1.33u rfmode=0
M$183 \$I24155 \$2103 \$2150 VPWR sg13_lv_pmos L=0.13u W=1.12u AS=0.1176p
+ AD=0.3808p PS=1.33u PD=2.92u rfmode=0
M$184 VGND \$1896 \$I24156 VGND sg13_lv_nmos L=0.13u W=0.55u AS=0.17255p
+ AD=0.187p PS=1.25u PD=1.78u rfmode=0
M$185 VGND \$I24156 \$1785 VGND sg13_lv_nmos L=0.13u W=0.74u AS=0.17255p
+ AD=0.1406p PS=1.25u PD=1.12u rfmode=0
M$186 \$1785 \$1682 VGND VGND sg13_lv_nmos L=0.13u W=0.74u AS=0.1406p
+ AD=0.2516p PS=1.12u PD=2.16u rfmode=0
M$187 \$I24156 \$1896 VPWR VPWR sg13_lv_pmos L=0.13u W=0.84u AS=0.2856p
+ AD=0.2618p PS=2.36u PD=1.63u rfmode=0
M$188 VPWR \$I24156 \$I24157 VPWR sg13_lv_pmos L=0.13u W=1.12u AS=0.2618p
+ AD=0.1176p PS=1.63u PD=1.33u rfmode=0
M$189 \$I24157 \$1682 \$1785 VPWR sg13_lv_pmos L=0.13u W=1.12u AS=0.1176p
+ AD=0.3808p PS=1.33u PD=2.92u rfmode=0
M$190 VGND \$1776 \$I24158 VGND sg13_lv_nmos L=0.13u W=0.55u AS=0.17255p
+ AD=0.187p PS=1.25u PD=1.78u rfmode=0
M$191 VGND \$I24158 \$835 VGND sg13_lv_nmos L=0.13u W=0.74u AS=0.17255p
+ AD=0.1406p PS=1.25u PD=1.12u rfmode=0
M$192 \$835 \$1684 VGND VGND sg13_lv_nmos L=0.13u W=0.74u AS=0.1406p AD=0.2516p
+ PS=1.12u PD=2.16u rfmode=0
M$193 \$I24158 \$1776 VPWR VPWR sg13_lv_pmos L=0.13u W=0.84u AS=0.2856p
+ AD=0.2618p PS=2.36u PD=1.63u rfmode=0
M$194 VPWR \$I24158 \$I24159 VPWR sg13_lv_pmos L=0.13u W=1.12u AS=0.2618p
+ AD=0.1176p PS=1.63u PD=1.33u rfmode=0
M$195 \$I24159 \$1684 \$835 VPWR sg13_lv_pmos L=0.13u W=1.12u AS=0.1176p
+ AD=0.3808p PS=1.33u PD=2.92u rfmode=0
M$196 \$I24160 \$2098 \$I24161 VGND sg13_lv_nmos L=0.13u W=0.64u AS=0.2176p
+ AD=0.1216p PS=1.96u PD=1.02u rfmode=0
M$197 VGND \$2101 \$I24161 VGND sg13_lv_nmos L=0.13u W=0.64u AS=0.1331p
+ AD=0.1216p PS=1.12u PD=1.02u rfmode=0
M$198 VGND \$I24160 \$2014 VGND sg13_lv_nmos L=0.13u W=0.74u AS=0.1331p
+ AD=0.2516p PS=1.12u PD=2.16u rfmode=0
M$199 VPWR \$2098 \$I24160 VPWR sg13_lv_pmos L=0.13u W=0.84u AS=0.2856p
+ AD=0.1596p PS=2.36u PD=1.22u rfmode=0
M$200 VPWR \$2101 \$I24160 VPWR sg13_lv_pmos L=0.13u W=0.84u AS=0.1918p
+ AD=0.1596p PS=1.5u PD=1.22u rfmode=0
M$201 VPWR \$I24160 \$2014 VPWR sg13_lv_pmos L=0.13u W=1.12u AS=0.1918p
+ AD=0.3808p PS=1.5u PD=2.92u rfmode=0
M$202 \$I24162 \$1680 \$I24163 VGND sg13_lv_nmos L=0.13u W=0.64u AS=0.2176p
+ AD=0.1216p PS=1.96u PD=1.02u rfmode=0
M$203 VGND \$2865 \$I24163 VGND sg13_lv_nmos L=0.13u W=0.64u AS=0.1331p
+ AD=0.1216p PS=1.12u PD=1.02u rfmode=0
M$204 VGND \$I24162 \$1931 VGND sg13_lv_nmos L=0.13u W=0.74u AS=0.1331p
+ AD=0.2516p PS=1.12u PD=2.16u rfmode=0
M$205 VPWR \$1680 \$I24162 VPWR sg13_lv_pmos L=0.13u W=0.84u AS=0.2856p
+ AD=0.1596p PS=2.36u PD=1.22u rfmode=0
M$206 VPWR \$2865 \$I24162 VPWR sg13_lv_pmos L=0.13u W=0.84u AS=0.1918p
+ AD=0.1596p PS=1.5u PD=1.22u rfmode=0
M$207 VPWR \$I24162 \$1931 VPWR sg13_lv_pmos L=0.13u W=1.12u AS=0.1918p
+ AD=0.3808p PS=1.5u PD=2.92u rfmode=0
M$208 \$I24164 \$1680 \$I24165 VGND sg13_lv_nmos L=0.13u W=0.64u AS=0.2176p
+ AD=0.1216p PS=1.96u PD=1.02u rfmode=0
M$209 VGND \$3760 \$I24165 VGND sg13_lv_nmos L=0.13u W=0.64u AS=0.1331p
+ AD=0.1216p PS=1.12u PD=1.02u rfmode=0
M$210 VGND \$I24164 \$3603 VGND sg13_lv_nmos L=0.13u W=0.74u AS=0.1331p
+ AD=0.2516p PS=1.12u PD=2.16u rfmode=0
M$211 VPWR \$1680 \$I24164 VPWR sg13_lv_pmos L=0.13u W=0.84u AS=0.2856p
+ AD=0.1596p PS=2.36u PD=1.22u rfmode=0
M$212 VPWR \$3760 \$I24164 VPWR sg13_lv_pmos L=0.13u W=0.84u AS=0.1918p
+ AD=0.1596p PS=1.5u PD=1.22u rfmode=0
M$213 VPWR \$I24164 \$3603 VPWR sg13_lv_pmos L=0.13u W=1.12u AS=0.1918p
+ AD=0.3808p PS=1.5u PD=2.92u rfmode=0
M$214 \$I24166 \$1680 \$I24167 VGND sg13_lv_nmos L=0.13u W=0.64u AS=0.2176p
+ AD=0.1216p PS=1.96u PD=1.02u rfmode=0
M$215 VGND \$1785 \$I24167 VGND sg13_lv_nmos L=0.13u W=0.64u AS=0.1331p
+ AD=0.1216p PS=1.12u PD=1.02u rfmode=0
M$216 VGND \$I24166 \$1895 VGND sg13_lv_nmos L=0.13u W=0.74u AS=0.1331p
+ AD=0.2516p PS=1.12u PD=2.16u rfmode=0
M$217 VPWR \$1680 \$I24166 VPWR sg13_lv_pmos L=0.13u W=0.84u AS=0.2856p
+ AD=0.1596p PS=2.36u PD=1.22u rfmode=0
M$218 VPWR \$1785 \$I24166 VPWR sg13_lv_pmos L=0.13u W=0.84u AS=0.1918p
+ AD=0.1596p PS=1.5u PD=1.22u rfmode=0
M$219 VPWR \$I24166 \$1895 VPWR sg13_lv_pmos L=0.13u W=1.12u AS=0.1918p
+ AD=0.3808p PS=1.5u PD=2.92u rfmode=0
M$220 \$I24168 \$2985 VGND VGND sg13_lv_nmos L=0.13u W=2.22u AS=0.5365p
+ AD=0.4218p PS=4.41u PD=3.36u rfmode=0
M$223 VGND \$I24168 \$2011 VGND sg13_lv_nmos L=0.13u W=5.92u AS=1.1248p
+ AD=1.2358p PS=8.96u PD=10u rfmode=0
M$231 \$I24168 \$2985 VPWR VPWR sg13_lv_pmos L=0.13u W=3.36u AS=0.8064p
+ AD=0.6384p PS=5.92u PD=4.5u rfmode=0
M$234 VPWR \$I24168 \$2011 VPWR sg13_lv_pmos L=0.13u W=8.96u AS=1.7024p
+ AD=1.876p PS=12u PD=13.43u rfmode=0
M$242 \$I24169 clk VGND VGND sg13_lv_nmos L=0.13u W=2.22u AS=0.5365p AD=0.4218p
+ PS=4.41u PD=3.36u rfmode=0
M$245 VGND \$I24169 \$1600 VGND sg13_lv_nmos L=0.13u W=5.92u AS=1.1248p
+ AD=1.2358p PS=8.96u PD=10u rfmode=0
M$253 \$I24169 clk VPWR VPWR sg13_lv_pmos L=0.13u W=3.36u AS=0.8064p AD=0.6384p
+ PS=5.92u PD=4.5u rfmode=0
M$256 VPWR \$I24169 \$1600 VPWR sg13_lv_pmos L=0.13u W=8.96u AS=1.7024p
+ AD=1.876p PS=12u PD=13.43u rfmode=0
M$264 \$I24170 clk VGND VGND sg13_lv_nmos L=0.13u W=2.22u AS=0.5365p AD=0.4218p
+ PS=4.41u PD=3.36u rfmode=0
M$267 VGND \$I24170 \$2985 VGND sg13_lv_nmos L=0.13u W=5.92u AS=1.1248p
+ AD=1.2358p PS=8.96u PD=10u rfmode=0
M$275 \$I24170 clk VPWR VPWR sg13_lv_pmos L=0.13u W=3.36u AS=0.8064p AD=0.6384p
+ PS=5.92u PD=4.5u rfmode=0
M$278 VPWR \$I24170 \$2985 VPWR sg13_lv_pmos L=0.13u W=8.96u AS=1.7024p
+ AD=1.876p PS=12u PD=13.43u rfmode=0
M$286 \$I24171 \$2011 VGND VGND sg13_lv_nmos L=0.13u W=2.22u AS=0.5365p
+ AD=0.4218p PS=4.41u PD=3.36u rfmode=0
M$289 VGND \$I24171 \$1781 VGND sg13_lv_nmos L=0.13u W=5.92u AS=1.1248p
+ AD=1.2358p PS=8.96u PD=10u rfmode=0
M$297 \$I24171 \$2011 VPWR VPWR sg13_lv_pmos L=0.13u W=3.36u AS=0.8064p
+ AD=0.6384p PS=5.92u PD=4.5u rfmode=0
M$300 VPWR \$I24171 \$1781 VPWR sg13_lv_pmos L=0.13u W=8.96u AS=1.7024p
+ AD=1.876p PS=12u PD=13.43u rfmode=0
M$308 \$I24172 \$2011 VGND VGND sg13_lv_nmos L=0.13u W=2.22u AS=0.5365p
+ AD=0.4218p PS=4.41u PD=3.36u rfmode=0
M$311 VGND \$I24172 \$3316 VGND sg13_lv_nmos L=0.13u W=5.92u AS=1.1248p
+ AD=1.2358p PS=8.96u PD=10u rfmode=0
M$319 \$I24172 \$2011 VPWR VPWR sg13_lv_pmos L=0.13u W=3.36u AS=0.8064p
+ AD=0.6384p PS=5.92u PD=4.5u rfmode=0
M$322 VPWR \$I24172 \$3316 VPWR sg13_lv_pmos L=0.13u W=8.96u AS=1.7024p
+ AD=1.876p PS=12u PD=13.43u rfmode=0
M$330 \$I24173 \$2011 VGND VGND sg13_lv_nmos L=0.13u W=2.22u AS=0.5365p
+ AD=0.4218p PS=4.41u PD=3.36u rfmode=0
M$333 VGND \$I24173 \$1889 VGND sg13_lv_nmos L=0.13u W=5.92u AS=1.1248p
+ AD=1.2358p PS=8.96u PD=10u rfmode=0
M$341 \$I24173 \$2011 VPWR VPWR sg13_lv_pmos L=0.13u W=3.36u AS=0.8064p
+ AD=0.6384p PS=5.92u PD=4.5u rfmode=0
M$344 VPWR \$I24173 \$1889 VPWR sg13_lv_pmos L=0.13u W=8.96u AS=1.7024p
+ AD=1.876p PS=12u PD=13.43u rfmode=0
M$352 \$I24174 \$2011 VGND VGND sg13_lv_nmos L=0.13u W=2.22u AS=0.5365p
+ AD=0.4218p PS=4.41u PD=3.36u rfmode=0
M$355 VGND \$I24174 \$2340 VGND sg13_lv_nmos L=0.13u W=5.92u AS=1.1248p
+ AD=1.2358p PS=8.96u PD=10u rfmode=0
M$363 \$I24174 \$2011 VPWR VPWR sg13_lv_pmos L=0.13u W=3.36u AS=0.8064p
+ AD=0.6384p PS=5.92u PD=4.5u rfmode=0
M$366 VPWR \$I24174 \$2340 VPWR sg13_lv_pmos L=0.13u W=8.96u AS=1.7024p
+ AD=1.876p PS=12u PD=13.43u rfmode=0
M$374 \$I24175 \$1600 VGND VGND sg13_lv_nmos L=0.13u W=2.22u AS=0.5365p
+ AD=0.4218p PS=4.41u PD=3.36u rfmode=0
M$377 VGND \$I24175 \$1716 VGND sg13_lv_nmos L=0.13u W=5.92u AS=1.1248p
+ AD=1.2358p PS=8.96u PD=10u rfmode=0
M$385 \$I24175 \$1600 VPWR VPWR sg13_lv_pmos L=0.13u W=3.36u AS=0.8064p
+ AD=0.6384p PS=5.92u PD=4.5u rfmode=0
M$388 VPWR \$I24175 \$1716 VPWR sg13_lv_pmos L=0.13u W=8.96u AS=1.7024p
+ AD=1.876p PS=12u PD=13.43u rfmode=0
M$396 VGND \$I24177 \$I24188 VGND sg13_lv_nmos L=0.13u W=0.74u AS=0.317325p
+ AD=0.2516p PS=1.805u PD=2.16u rfmode=0
M$397 VGND \$3316 \$I24177 VGND sg13_lv_nmos L=0.13u W=0.74u AS=0.317325p
+ AD=0.2516p PS=1.805u PD=2.16u rfmode=0
M$398 \$I24184 \$I24177 \$I24180 VGND sg13_lv_nmos L=0.13u W=0.42u AS=0.12665p
+ AD=0.1428p PS=1.145u PD=1.52u rfmode=0
M$399 \$I24176 \$I24188 \$I24184 VGND sg13_lv_nmos L=0.13u W=0.74u AS=0.3473p
+ AD=0.12665p PS=2.71u PD=1.145u rfmode=0
M$400 \$I24178 \$4092 \$I24185 VGND sg13_lv_nmos L=0.13u W=0.42u AS=0.1428p
+ AD=0.0609p PS=1.52u PD=0.71u rfmode=0
M$401 \$I24185 \$4091 VGND VGND sg13_lv_nmos L=0.13u W=0.42u AS=0.0609p
+ AD=0.1626p PS=0.71u PD=1.415u rfmode=0
M$402 VGND \$I24183 \$I24176 VGND sg13_lv_nmos L=0.13u W=0.74u AS=0.1626p
+ AD=0.2516p PS=1.415u PD=2.16u rfmode=0
M$403 \$I24182 \$I24184 VGND VGND sg13_lv_nmos L=0.13u W=0.74u AS=0.2516p
+ AD=0.1406p PS=2.16u PD=1.12u rfmode=0
M$404 VGND \$I24182 \$2399 VGND sg13_lv_nmos L=0.13u W=0.74u AS=0.1406p
+ AD=0.2516p PS=1.12u PD=2.16u rfmode=0
M$405 \$I24178 \$I24177 \$I24183 VGND sg13_lv_nmos L=0.13u W=0.42u AS=0.1296p
+ AD=0.0798p PS=1.52u PD=0.8u rfmode=0
M$406 \$I24183 \$I24188 \$I24179 VGND sg13_lv_nmos L=0.13u W=0.42u AS=0.0798p
+ AD=0.2373p PS=0.8u PD=1.97u rfmode=0
M$407 \$I24180 \$I24181 VGND VGND sg13_lv_nmos L=0.13u W=0.42u AS=0.1428p
+ AD=0.0798p PS=1.52u PD=0.8u rfmode=0
M$408 VGND \$4091 \$I24187 VGND sg13_lv_nmos L=0.13u W=0.42u AS=0.0798p
+ AD=0.0378p PS=0.8u PD=0.6u rfmode=0
M$409 \$I24187 \$I24184 \$I24181 VGND sg13_lv_nmos L=0.13u W=0.42u AS=0.0378p
+ AD=0.1428p PS=0.6u PD=1.52u rfmode=0
M$410 VGND \$4091 \$I24186 VGND sg13_lv_nmos L=0.13u W=0.42u AS=0.1701p
+ AD=0.0378p PS=1.65u PD=0.6u rfmode=0
M$411 \$I24186 \$I24176 \$I24179 VGND sg13_lv_nmos L=0.13u W=0.42u AS=0.0378p
+ AD=0.1428p PS=0.6u PD=1.52u rfmode=0
M$412 \$I24184 \$I24188 \$I24190 VPWR sg13_lv_pmos L=0.13u W=0.42u AS=0.2048p
+ AD=0.09345p PS=1.63u PD=0.865u rfmode=0
M$413 \$I24190 \$I24181 VPWR VPWR sg13_lv_pmos L=0.13u W=0.42u AS=0.09345p
+ AD=0.204p PS=0.865u PD=1.835u rfmode=0
M$414 VPWR \$4091 \$I24181 VPWR sg13_lv_pmos L=0.13u W=0.42u AS=0.204p
+ AD=0.0798p PS=1.835u PD=0.8u rfmode=0
M$415 \$I24181 \$I24184 VPWR VPWR sg13_lv_pmos L=0.13u W=0.42u AS=0.0798p
+ AD=0.4659p PS=0.8u PD=3.65u rfmode=0
M$416 \$I24176 \$I24177 \$I24184 VPWR sg13_lv_pmos L=0.13u W=1u AS=0.34p
+ AD=0.2048p PS=2.68u PD=1.63u rfmode=0
M$417 \$I24182 \$I24184 VPWR VPWR sg13_lv_pmos L=0.13u W=1.12u AS=0.3864p
+ AD=0.2128p PS=2.93u PD=1.5u rfmode=0
M$418 VPWR \$I24182 \$2399 VPWR sg13_lv_pmos L=0.13u W=1.12u AS=0.2128p
+ AD=0.3808p PS=1.5u PD=2.92u rfmode=0
M$419 VPWR \$4092 \$I24178 VPWR sg13_lv_pmos L=0.13u W=0.42u AS=0.1428p
+ AD=0.0798p PS=1.52u PD=0.8u rfmode=0
M$420 VPWR \$4091 \$I24178 VPWR sg13_lv_pmos L=0.13u W=0.42u AS=0.3623875p
+ AD=0.0798p PS=2.605u PD=0.8u rfmode=0
M$421 VPWR \$I24183 \$I24176 VPWR sg13_lv_pmos L=0.13u W=1u AS=0.3623875p
+ AD=0.34p PS=2.605u PD=2.68u rfmode=0
M$422 \$I24188 \$I24177 VPWR VPWR sg13_lv_pmos L=0.13u W=1.12u AS=0.3864p
+ AD=0.41165p PS=2.93u PD=2.12u rfmode=0
M$423 VPWR \$3316 \$I24177 VPWR sg13_lv_pmos L=0.13u W=1.12u AS=0.41165p
+ AD=0.4088p PS=2.12u PD=2.97u rfmode=0
M$424 \$I24183 \$4091 VPWR VPWR sg13_lv_pmos L=0.13u W=0.42u AS=0.147p
+ AD=0.1563p PS=1.54u PD=1.22u rfmode=0
M$425 VPWR \$I24176 \$I24189 VPWR sg13_lv_pmos L=0.13u W=0.42u AS=0.1563p
+ AD=0.063p PS=1.22u PD=0.72u rfmode=0
M$426 \$I24189 \$I24177 \$I24183 VPWR sg13_lv_pmos L=0.13u W=0.42u AS=0.063p
+ AD=0.0798p PS=0.72u PD=0.8u rfmode=0
M$427 \$I24183 \$I24188 \$I24178 VPWR sg13_lv_pmos L=0.13u W=0.42u AS=0.0798p
+ AD=0.1428p PS=0.8u PD=1.52u rfmode=0
M$428 VGND \$I24192 \$I24203 VGND sg13_lv_nmos L=0.13u W=0.74u AS=0.317325p
+ AD=0.2516p PS=1.805u PD=2.16u rfmode=0
M$429 VGND \$1781 \$I24192 VGND sg13_lv_nmos L=0.13u W=0.74u AS=0.317325p
+ AD=0.2516p PS=1.805u PD=2.16u rfmode=0
M$430 \$I24199 \$I24192 \$I24195 VGND sg13_lv_nmos L=0.13u W=0.42u AS=0.12665p
+ AD=0.1428p PS=1.145u PD=1.52u rfmode=0
M$431 \$I24191 \$I24203 \$I24199 VGND sg13_lv_nmos L=0.13u W=0.74u AS=0.3473p
+ AD=0.12665p PS=2.71u PD=1.145u rfmode=0
M$432 \$I24193 \$1895 \$I24200 VGND sg13_lv_nmos L=0.13u W=0.42u AS=0.1428p
+ AD=0.0609p PS=1.52u PD=0.71u rfmode=0
M$433 \$I24200 \$1941 VGND VGND sg13_lv_nmos L=0.13u W=0.42u AS=0.0609p
+ AD=0.1626p PS=0.71u PD=1.415u rfmode=0
M$434 VGND \$I24198 \$I24191 VGND sg13_lv_nmos L=0.13u W=0.74u AS=0.1626p
+ AD=0.2516p PS=1.415u PD=2.16u rfmode=0
M$435 \$I24197 \$I24199 VGND VGND sg13_lv_nmos L=0.13u W=0.74u AS=0.2516p
+ AD=0.1406p PS=2.16u PD=1.12u rfmode=0
M$436 VGND \$I24197 \$1684 VGND sg13_lv_nmos L=0.13u W=0.74u AS=0.1406p
+ AD=0.2516p PS=1.12u PD=2.16u rfmode=0
M$437 \$I24193 \$I24192 \$I24198 VGND sg13_lv_nmos L=0.13u W=0.42u AS=0.1296p
+ AD=0.0798p PS=1.52u PD=0.8u rfmode=0
M$438 \$I24198 \$I24203 \$I24194 VGND sg13_lv_nmos L=0.13u W=0.42u AS=0.0798p
+ AD=0.2373p PS=0.8u PD=1.97u rfmode=0
M$439 \$I24195 \$I24196 VGND VGND sg13_lv_nmos L=0.13u W=0.42u AS=0.1428p
+ AD=0.0798p PS=1.52u PD=0.8u rfmode=0
M$440 VGND \$1941 \$I24202 VGND sg13_lv_nmos L=0.13u W=0.42u AS=0.0798p
+ AD=0.0378p PS=0.8u PD=0.6u rfmode=0
M$441 \$I24202 \$I24199 \$I24196 VGND sg13_lv_nmos L=0.13u W=0.42u AS=0.0378p
+ AD=0.1428p PS=0.6u PD=1.52u rfmode=0
M$442 VGND \$1941 \$I24201 VGND sg13_lv_nmos L=0.13u W=0.42u AS=0.1701p
+ AD=0.0378p PS=1.65u PD=0.6u rfmode=0
M$443 \$I24201 \$I24191 \$I24194 VGND sg13_lv_nmos L=0.13u W=0.42u AS=0.0378p
+ AD=0.1428p PS=0.6u PD=1.52u rfmode=0
M$444 \$I24199 \$I24203 \$I24205 VPWR sg13_lv_pmos L=0.13u W=0.42u AS=0.2048p
+ AD=0.09345p PS=1.63u PD=0.865u rfmode=0
M$445 \$I24205 \$I24196 VPWR VPWR sg13_lv_pmos L=0.13u W=0.42u AS=0.09345p
+ AD=0.204p PS=0.865u PD=1.835u rfmode=0
M$446 VPWR \$1941 \$I24196 VPWR sg13_lv_pmos L=0.13u W=0.42u AS=0.204p
+ AD=0.0798p PS=1.835u PD=0.8u rfmode=0
M$447 \$I24196 \$I24199 VPWR VPWR sg13_lv_pmos L=0.13u W=0.42u AS=0.0798p
+ AD=0.4659p PS=0.8u PD=3.65u rfmode=0
M$448 \$I24191 \$I24192 \$I24199 VPWR sg13_lv_pmos L=0.13u W=1u AS=0.34p
+ AD=0.2048p PS=2.68u PD=1.63u rfmode=0
M$449 \$I24197 \$I24199 VPWR VPWR sg13_lv_pmos L=0.13u W=1.12u AS=0.3864p
+ AD=0.2128p PS=2.93u PD=1.5u rfmode=0
M$450 VPWR \$I24197 \$1684 VPWR sg13_lv_pmos L=0.13u W=1.12u AS=0.2128p
+ AD=0.3808p PS=1.5u PD=2.92u rfmode=0
M$451 VPWR \$1895 \$I24193 VPWR sg13_lv_pmos L=0.13u W=0.42u AS=0.1428p
+ AD=0.0798p PS=1.52u PD=0.8u rfmode=0
M$452 VPWR \$1941 \$I24193 VPWR sg13_lv_pmos L=0.13u W=0.42u AS=0.3623875p
+ AD=0.0798p PS=2.605u PD=0.8u rfmode=0
M$453 VPWR \$I24198 \$I24191 VPWR sg13_lv_pmos L=0.13u W=1u AS=0.3623875p
+ AD=0.34p PS=2.605u PD=2.68u rfmode=0
M$454 \$I24203 \$I24192 VPWR VPWR sg13_lv_pmos L=0.13u W=1.12u AS=0.3864p
+ AD=0.41165p PS=2.93u PD=2.12u rfmode=0
M$455 VPWR \$1781 \$I24192 VPWR sg13_lv_pmos L=0.13u W=1.12u AS=0.41165p
+ AD=0.4088p PS=2.12u PD=2.97u rfmode=0
M$456 \$I24198 \$1941 VPWR VPWR sg13_lv_pmos L=0.13u W=0.42u AS=0.147p
+ AD=0.1563p PS=1.54u PD=1.22u rfmode=0
M$457 VPWR \$I24191 \$I24204 VPWR sg13_lv_pmos L=0.13u W=0.42u AS=0.1563p
+ AD=0.063p PS=1.22u PD=0.72u rfmode=0
M$458 \$I24204 \$I24192 \$I24198 VPWR sg13_lv_pmos L=0.13u W=0.42u AS=0.063p
+ AD=0.0798p PS=0.72u PD=0.8u rfmode=0
M$459 \$I24198 \$I24203 \$I24193 VPWR sg13_lv_pmos L=0.13u W=0.42u AS=0.0798p
+ AD=0.1428p PS=0.8u PD=1.52u rfmode=0
M$460 VGND \$I24207 \$I24218 VGND sg13_lv_nmos L=0.13u W=0.74u AS=0.317325p
+ AD=0.2516p PS=1.805u PD=2.16u rfmode=0
M$461 VGND \$1781 \$I24207 VGND sg13_lv_nmos L=0.13u W=0.74u AS=0.317325p
+ AD=0.2516p PS=1.805u PD=2.16u rfmode=0
M$462 \$I24214 \$I24207 \$I24210 VGND sg13_lv_nmos L=0.13u W=0.42u AS=0.12665p
+ AD=0.1428p PS=1.145u PD=1.52u rfmode=0
M$463 \$I24206 \$I24218 \$I24214 VGND sg13_lv_nmos L=0.13u W=0.74u AS=0.3473p
+ AD=0.12665p PS=2.71u PD=1.145u rfmode=0
M$464 \$I24208 \$2150 \$I24215 VGND sg13_lv_nmos L=0.13u W=0.42u AS=0.1428p
+ AD=0.0609p PS=1.52u PD=0.71u rfmode=0
M$465 \$I24215 \$2276 VGND VGND sg13_lv_nmos L=0.13u W=0.42u AS=0.0609p
+ AD=0.1626p PS=0.71u PD=1.415u rfmode=0
M$466 VGND \$I24213 \$I24206 VGND sg13_lv_nmos L=0.13u W=0.74u AS=0.1626p
+ AD=0.2516p PS=1.415u PD=2.16u rfmode=0
M$467 \$I24212 \$I24214 VGND VGND sg13_lv_nmos L=0.13u W=0.74u AS=0.2516p
+ AD=0.1406p PS=2.16u PD=1.12u rfmode=0
M$468 VGND \$I24212 \$2101 VGND sg13_lv_nmos L=0.13u W=0.74u AS=0.1406p
+ AD=0.2516p PS=1.12u PD=2.16u rfmode=0
M$469 \$I24208 \$I24207 \$I24213 VGND sg13_lv_nmos L=0.13u W=0.42u AS=0.1296p
+ AD=0.0798p PS=1.52u PD=0.8u rfmode=0
M$470 \$I24213 \$I24218 \$I24209 VGND sg13_lv_nmos L=0.13u W=0.42u AS=0.0798p
+ AD=0.2373p PS=0.8u PD=1.97u rfmode=0
M$471 \$I24210 \$I24211 VGND VGND sg13_lv_nmos L=0.13u W=0.42u AS=0.1428p
+ AD=0.0798p PS=1.52u PD=0.8u rfmode=0
M$472 VGND \$2276 \$I24217 VGND sg13_lv_nmos L=0.13u W=0.42u AS=0.0798p
+ AD=0.0378p PS=0.8u PD=0.6u rfmode=0
M$473 \$I24217 \$I24214 \$I24211 VGND sg13_lv_nmos L=0.13u W=0.42u AS=0.0378p
+ AD=0.1428p PS=0.6u PD=1.52u rfmode=0
M$474 VGND \$2276 \$I24216 VGND sg13_lv_nmos L=0.13u W=0.42u AS=0.1701p
+ AD=0.0378p PS=1.65u PD=0.6u rfmode=0
M$475 \$I24216 \$I24206 \$I24209 VGND sg13_lv_nmos L=0.13u W=0.42u AS=0.0378p
+ AD=0.1428p PS=0.6u PD=1.52u rfmode=0
M$476 \$I24214 \$I24218 \$I24220 VPWR sg13_lv_pmos L=0.13u W=0.42u AS=0.2048p
+ AD=0.09345p PS=1.63u PD=0.865u rfmode=0
M$477 \$I24220 \$I24211 VPWR VPWR sg13_lv_pmos L=0.13u W=0.42u AS=0.09345p
+ AD=0.204p PS=0.865u PD=1.835u rfmode=0
M$478 VPWR \$2276 \$I24211 VPWR sg13_lv_pmos L=0.13u W=0.42u AS=0.204p
+ AD=0.0798p PS=1.835u PD=0.8u rfmode=0
M$479 \$I24211 \$I24214 VPWR VPWR sg13_lv_pmos L=0.13u W=0.42u AS=0.0798p
+ AD=0.4659p PS=0.8u PD=3.65u rfmode=0
M$480 \$I24206 \$I24207 \$I24214 VPWR sg13_lv_pmos L=0.13u W=1u AS=0.34p
+ AD=0.2048p PS=2.68u PD=1.63u rfmode=0
M$481 \$I24212 \$I24214 VPWR VPWR sg13_lv_pmos L=0.13u W=1.12u AS=0.3864p
+ AD=0.2128p PS=2.93u PD=1.5u rfmode=0
M$482 VPWR \$I24212 \$2101 VPWR sg13_lv_pmos L=0.13u W=1.12u AS=0.2128p
+ AD=0.3808p PS=1.5u PD=2.92u rfmode=0
M$483 VPWR \$2150 \$I24208 VPWR sg13_lv_pmos L=0.13u W=0.42u AS=0.1428p
+ AD=0.0798p PS=1.52u PD=0.8u rfmode=0
M$484 VPWR \$2276 \$I24208 VPWR sg13_lv_pmos L=0.13u W=0.42u AS=0.3623875p
+ AD=0.0798p PS=2.605u PD=0.8u rfmode=0
M$485 VPWR \$I24213 \$I24206 VPWR sg13_lv_pmos L=0.13u W=1u AS=0.3623875p
+ AD=0.34p PS=2.605u PD=2.68u rfmode=0
M$486 \$I24218 \$I24207 VPWR VPWR sg13_lv_pmos L=0.13u W=1.12u AS=0.3864p
+ AD=0.41165p PS=2.93u PD=2.12u rfmode=0
M$487 VPWR \$1781 \$I24207 VPWR sg13_lv_pmos L=0.13u W=1.12u AS=0.41165p
+ AD=0.4088p PS=2.12u PD=2.97u rfmode=0
M$488 \$I24213 \$2276 VPWR VPWR sg13_lv_pmos L=0.13u W=0.42u AS=0.147p
+ AD=0.1563p PS=1.54u PD=1.22u rfmode=0
M$489 VPWR \$I24206 \$I24219 VPWR sg13_lv_pmos L=0.13u W=0.42u AS=0.1563p
+ AD=0.063p PS=1.22u PD=0.72u rfmode=0
M$490 \$I24219 \$I24207 \$I24213 VPWR sg13_lv_pmos L=0.13u W=0.42u AS=0.063p
+ AD=0.0798p PS=0.72u PD=0.8u rfmode=0
M$491 \$I24213 \$I24218 \$I24208 VPWR sg13_lv_pmos L=0.13u W=0.42u AS=0.0798p
+ AD=0.1428p PS=0.8u PD=1.52u rfmode=0
M$492 VGND \$I24222 \$I24233 VGND sg13_lv_nmos L=0.13u W=0.74u AS=0.317325p
+ AD=0.2516p PS=1.805u PD=2.16u rfmode=0
M$493 VGND \$2340 \$I24222 VGND sg13_lv_nmos L=0.13u W=0.74u AS=0.317325p
+ AD=0.2516p PS=1.805u PD=2.16u rfmode=0
M$494 \$I24229 \$I24222 \$I24225 VGND sg13_lv_nmos L=0.13u W=0.42u AS=0.12665p
+ AD=0.1428p PS=1.145u PD=1.52u rfmode=0
M$495 \$I24221 \$I24233 \$I24229 VGND sg13_lv_nmos L=0.13u W=0.74u AS=0.3473p
+ AD=0.12665p PS=2.71u PD=1.145u rfmode=0
M$496 \$I24223 \$2559 \$I24230 VGND sg13_lv_nmos L=0.13u W=0.42u AS=0.1428p
+ AD=0.0609p PS=1.52u PD=0.71u rfmode=0
M$497 \$I24230 \$2742 VGND VGND sg13_lv_nmos L=0.13u W=0.42u AS=0.0609p
+ AD=0.1626p PS=0.71u PD=1.415u rfmode=0
M$498 VGND \$I24228 \$I24221 VGND sg13_lv_nmos L=0.13u W=0.74u AS=0.1626p
+ AD=0.2516p PS=1.415u PD=2.16u rfmode=0
M$499 \$I24227 \$I24229 VGND VGND sg13_lv_nmos L=0.13u W=0.74u AS=0.2516p
+ AD=0.1406p PS=2.16u PD=1.12u rfmode=0
M$500 VGND \$I24227 \$718 VGND sg13_lv_nmos L=0.13u W=0.74u AS=0.1406p
+ AD=0.2516p PS=1.12u PD=2.16u rfmode=0
M$501 \$I24223 \$I24222 \$I24228 VGND sg13_lv_nmos L=0.13u W=0.42u AS=0.1296p
+ AD=0.0798p PS=1.52u PD=0.8u rfmode=0
M$502 \$I24228 \$I24233 \$I24224 VGND sg13_lv_nmos L=0.13u W=0.42u AS=0.0798p
+ AD=0.2373p PS=0.8u PD=1.97u rfmode=0
M$503 \$I24225 \$I24226 VGND VGND sg13_lv_nmos L=0.13u W=0.42u AS=0.1428p
+ AD=0.0798p PS=1.52u PD=0.8u rfmode=0
M$504 VGND \$2742 \$I24232 VGND sg13_lv_nmos L=0.13u W=0.42u AS=0.0798p
+ AD=0.0378p PS=0.8u PD=0.6u rfmode=0
M$505 \$I24232 \$I24229 \$I24226 VGND sg13_lv_nmos L=0.13u W=0.42u AS=0.0378p
+ AD=0.1428p PS=0.6u PD=1.52u rfmode=0
M$506 VGND \$2742 \$I24231 VGND sg13_lv_nmos L=0.13u W=0.42u AS=0.1701p
+ AD=0.0378p PS=1.65u PD=0.6u rfmode=0
M$507 \$I24231 \$I24221 \$I24224 VGND sg13_lv_nmos L=0.13u W=0.42u AS=0.0378p
+ AD=0.1428p PS=0.6u PD=1.52u rfmode=0
M$508 \$I24229 \$I24233 \$I24235 VPWR sg13_lv_pmos L=0.13u W=0.42u AS=0.2048p
+ AD=0.09345p PS=1.63u PD=0.865u rfmode=0
M$509 \$I24235 \$I24226 VPWR VPWR sg13_lv_pmos L=0.13u W=0.42u AS=0.09345p
+ AD=0.204p PS=0.865u PD=1.835u rfmode=0
M$510 VPWR \$2742 \$I24226 VPWR sg13_lv_pmos L=0.13u W=0.42u AS=0.204p
+ AD=0.0798p PS=1.835u PD=0.8u rfmode=0
M$511 \$I24226 \$I24229 VPWR VPWR sg13_lv_pmos L=0.13u W=0.42u AS=0.0798p
+ AD=0.4659p PS=0.8u PD=3.65u rfmode=0
M$512 \$I24221 \$I24222 \$I24229 VPWR sg13_lv_pmos L=0.13u W=1u AS=0.34p
+ AD=0.2048p PS=2.68u PD=1.63u rfmode=0
M$513 \$I24227 \$I24229 VPWR VPWR sg13_lv_pmos L=0.13u W=1.12u AS=0.3864p
+ AD=0.2128p PS=2.93u PD=1.5u rfmode=0
M$514 VPWR \$I24227 \$718 VPWR sg13_lv_pmos L=0.13u W=1.12u AS=0.2128p
+ AD=0.3808p PS=1.5u PD=2.92u rfmode=0
M$515 VPWR \$2559 \$I24223 VPWR sg13_lv_pmos L=0.13u W=0.42u AS=0.1428p
+ AD=0.0798p PS=1.52u PD=0.8u rfmode=0
M$516 VPWR \$2742 \$I24223 VPWR sg13_lv_pmos L=0.13u W=0.42u AS=0.3623875p
+ AD=0.0798p PS=2.605u PD=0.8u rfmode=0
M$517 VPWR \$I24228 \$I24221 VPWR sg13_lv_pmos L=0.13u W=1u AS=0.3623875p
+ AD=0.34p PS=2.605u PD=2.68u rfmode=0
M$518 \$I24233 \$I24222 VPWR VPWR sg13_lv_pmos L=0.13u W=1.12u AS=0.3864p
+ AD=0.41165p PS=2.93u PD=2.12u rfmode=0
M$519 VPWR \$2340 \$I24222 VPWR sg13_lv_pmos L=0.13u W=1.12u AS=0.41165p
+ AD=0.4088p PS=2.12u PD=2.97u rfmode=0
M$520 \$I24228 \$2742 VPWR VPWR sg13_lv_pmos L=0.13u W=0.42u AS=0.147p
+ AD=0.1563p PS=1.54u PD=1.22u rfmode=0
M$521 VPWR \$I24221 \$I24234 VPWR sg13_lv_pmos L=0.13u W=0.42u AS=0.1563p
+ AD=0.063p PS=1.22u PD=0.72u rfmode=0
M$522 \$I24234 \$I24222 \$I24228 VPWR sg13_lv_pmos L=0.13u W=0.42u AS=0.063p
+ AD=0.0798p PS=0.72u PD=0.8u rfmode=0
M$523 \$I24228 \$I24233 \$I24223 VPWR sg13_lv_pmos L=0.13u W=0.42u AS=0.0798p
+ AD=0.1428p PS=0.8u PD=1.52u rfmode=0
M$524 VGND \$I24237 \$I24248 VGND sg13_lv_nmos L=0.13u W=0.74u AS=0.317325p
+ AD=0.2516p PS=1.805u PD=2.16u rfmode=0
M$525 VGND \$3316 \$I24237 VGND sg13_lv_nmos L=0.13u W=0.74u AS=0.317325p
+ AD=0.2516p PS=1.805u PD=2.16u rfmode=0
M$526 \$I24244 \$I24237 \$I24240 VGND sg13_lv_nmos L=0.13u W=0.42u AS=0.12665p
+ AD=0.1428p PS=1.145u PD=1.52u rfmode=0
M$527 \$I24236 \$I24248 \$I24244 VGND sg13_lv_nmos L=0.13u W=0.74u AS=0.3473p
+ AD=0.12665p PS=2.71u PD=1.145u rfmode=0
M$528 \$I24238 \$4512 \$I24245 VGND sg13_lv_nmos L=0.13u W=0.42u AS=0.1428p
+ AD=0.0609p PS=1.52u PD=0.71u rfmode=0
M$529 \$I24245 \$4204 VGND VGND sg13_lv_nmos L=0.13u W=0.42u AS=0.0609p
+ AD=0.1626p PS=0.71u PD=1.415u rfmode=0
M$530 VGND \$I24243 \$I24236 VGND sg13_lv_nmos L=0.13u W=0.74u AS=0.1626p
+ AD=0.2516p PS=1.415u PD=2.16u rfmode=0
M$531 \$I24242 \$I24244 VGND VGND sg13_lv_nmos L=0.13u W=0.74u AS=0.2516p
+ AD=0.1406p PS=2.16u PD=1.12u rfmode=0
M$532 VGND \$I24242 \$4205 VGND sg13_lv_nmos L=0.13u W=0.74u AS=0.1406p
+ AD=0.2516p PS=1.12u PD=2.16u rfmode=0
M$533 \$I24238 \$I24237 \$I24243 VGND sg13_lv_nmos L=0.13u W=0.42u AS=0.1296p
+ AD=0.0798p PS=1.52u PD=0.8u rfmode=0
M$534 \$I24243 \$I24248 \$I24239 VGND sg13_lv_nmos L=0.13u W=0.42u AS=0.0798p
+ AD=0.2373p PS=0.8u PD=1.97u rfmode=0
M$535 \$I24240 \$I24241 VGND VGND sg13_lv_nmos L=0.13u W=0.42u AS=0.1428p
+ AD=0.0798p PS=1.52u PD=0.8u rfmode=0
M$536 VGND \$4204 \$I24247 VGND sg13_lv_nmos L=0.13u W=0.42u AS=0.0798p
+ AD=0.0378p PS=0.8u PD=0.6u rfmode=0
M$537 \$I24247 \$I24244 \$I24241 VGND sg13_lv_nmos L=0.13u W=0.42u AS=0.0378p
+ AD=0.1428p PS=0.6u PD=1.52u rfmode=0
M$538 VGND \$4204 \$I24246 VGND sg13_lv_nmos L=0.13u W=0.42u AS=0.1701p
+ AD=0.0378p PS=1.65u PD=0.6u rfmode=0
M$539 \$I24246 \$I24236 \$I24239 VGND sg13_lv_nmos L=0.13u W=0.42u AS=0.0378p
+ AD=0.1428p PS=0.6u PD=1.52u rfmode=0
M$540 \$I24244 \$I24248 \$I24250 VPWR sg13_lv_pmos L=0.13u W=0.42u AS=0.2048p
+ AD=0.09345p PS=1.63u PD=0.865u rfmode=0
M$541 \$I24250 \$I24241 VPWR VPWR sg13_lv_pmos L=0.13u W=0.42u AS=0.09345p
+ AD=0.204p PS=0.865u PD=1.835u rfmode=0
M$542 VPWR \$4204 \$I24241 VPWR sg13_lv_pmos L=0.13u W=0.42u AS=0.204p
+ AD=0.0798p PS=1.835u PD=0.8u rfmode=0
M$543 \$I24241 \$I24244 VPWR VPWR sg13_lv_pmos L=0.13u W=0.42u AS=0.0798p
+ AD=0.4659p PS=0.8u PD=3.65u rfmode=0
M$544 \$I24236 \$I24237 \$I24244 VPWR sg13_lv_pmos L=0.13u W=1u AS=0.34p
+ AD=0.2048p PS=2.68u PD=1.63u rfmode=0
M$545 \$I24242 \$I24244 VPWR VPWR sg13_lv_pmos L=0.13u W=1.12u AS=0.3864p
+ AD=0.2128p PS=2.93u PD=1.5u rfmode=0
M$546 VPWR \$I24242 \$4205 VPWR sg13_lv_pmos L=0.13u W=1.12u AS=0.2128p
+ AD=0.3808p PS=1.5u PD=2.92u rfmode=0
M$547 VPWR \$4512 \$I24238 VPWR sg13_lv_pmos L=0.13u W=0.42u AS=0.1428p
+ AD=0.0798p PS=1.52u PD=0.8u rfmode=0
M$548 VPWR \$4204 \$I24238 VPWR sg13_lv_pmos L=0.13u W=0.42u AS=0.3623875p
+ AD=0.0798p PS=2.605u PD=0.8u rfmode=0
M$549 VPWR \$I24243 \$I24236 VPWR sg13_lv_pmos L=0.13u W=1u AS=0.3623875p
+ AD=0.34p PS=2.605u PD=2.68u rfmode=0
M$550 \$I24248 \$I24237 VPWR VPWR sg13_lv_pmos L=0.13u W=1.12u AS=0.3864p
+ AD=0.41165p PS=2.93u PD=2.12u rfmode=0
M$551 VPWR \$3316 \$I24237 VPWR sg13_lv_pmos L=0.13u W=1.12u AS=0.41165p
+ AD=0.4088p PS=2.12u PD=2.97u rfmode=0
M$552 \$I24243 \$4204 VPWR VPWR sg13_lv_pmos L=0.13u W=0.42u AS=0.147p
+ AD=0.1563p PS=1.54u PD=1.22u rfmode=0
M$553 VPWR \$I24236 \$I24249 VPWR sg13_lv_pmos L=0.13u W=0.42u AS=0.1563p
+ AD=0.063p PS=1.22u PD=0.72u rfmode=0
M$554 \$I24249 \$I24237 \$I24243 VPWR sg13_lv_pmos L=0.13u W=0.42u AS=0.063p
+ AD=0.0798p PS=0.72u PD=0.8u rfmode=0
M$555 \$I24243 \$I24248 \$I24238 VPWR sg13_lv_pmos L=0.13u W=0.42u AS=0.0798p
+ AD=0.1428p PS=0.8u PD=1.52u rfmode=0
M$556 VGND \$I24252 \$I24263 VGND sg13_lv_nmos L=0.13u W=0.74u AS=0.317325p
+ AD=0.2516p PS=1.805u PD=2.16u rfmode=0
M$557 VGND \$2340 \$I24252 VGND sg13_lv_nmos L=0.13u W=0.74u AS=0.317325p
+ AD=0.2516p PS=1.805u PD=2.16u rfmode=0
M$558 \$I24259 \$I24252 \$I24255 VGND sg13_lv_nmos L=0.13u W=0.42u AS=0.12665p
+ AD=0.1428p PS=1.145u PD=1.52u rfmode=0
M$559 \$I24251 \$I24263 \$I24259 VGND sg13_lv_nmos L=0.13u W=0.74u AS=0.3473p
+ AD=0.12665p PS=2.71u PD=1.145u rfmode=0
M$560 \$I24253 \$2917 \$I24260 VGND sg13_lv_nmos L=0.13u W=0.42u AS=0.1428p
+ AD=0.0609p PS=1.52u PD=0.71u rfmode=0
M$561 \$I24260 \$2741 VGND VGND sg13_lv_nmos L=0.13u W=0.42u AS=0.0609p
+ AD=0.1626p PS=0.71u PD=1.415u rfmode=0
M$562 VGND \$I24258 \$I24251 VGND sg13_lv_nmos L=0.13u W=0.74u AS=0.1626p
+ AD=0.2516p PS=1.415u PD=2.16u rfmode=0
M$563 \$I24257 \$I24259 VGND VGND sg13_lv_nmos L=0.13u W=0.74u AS=0.2516p
+ AD=0.1406p PS=2.16u PD=1.12u rfmode=0
M$564 VGND \$I24257 \$2622 VGND sg13_lv_nmos L=0.13u W=0.74u AS=0.1406p
+ AD=0.2516p PS=1.12u PD=2.16u rfmode=0
M$565 \$I24253 \$I24252 \$I24258 VGND sg13_lv_nmos L=0.13u W=0.42u AS=0.1296p
+ AD=0.0798p PS=1.52u PD=0.8u rfmode=0
M$566 \$I24258 \$I24263 \$I24254 VGND sg13_lv_nmos L=0.13u W=0.42u AS=0.0798p
+ AD=0.2373p PS=0.8u PD=1.97u rfmode=0
M$567 \$I24255 \$I24256 VGND VGND sg13_lv_nmos L=0.13u W=0.42u AS=0.1428p
+ AD=0.0798p PS=1.52u PD=0.8u rfmode=0
M$568 VGND \$2741 \$I24262 VGND sg13_lv_nmos L=0.13u W=0.42u AS=0.0798p
+ AD=0.0378p PS=0.8u PD=0.6u rfmode=0
M$569 \$I24262 \$I24259 \$I24256 VGND sg13_lv_nmos L=0.13u W=0.42u AS=0.0378p
+ AD=0.1428p PS=0.6u PD=1.52u rfmode=0
M$570 VGND \$2741 \$I24261 VGND sg13_lv_nmos L=0.13u W=0.42u AS=0.1701p
+ AD=0.0378p PS=1.65u PD=0.6u rfmode=0
M$571 \$I24261 \$I24251 \$I24254 VGND sg13_lv_nmos L=0.13u W=0.42u AS=0.0378p
+ AD=0.1428p PS=0.6u PD=1.52u rfmode=0
M$572 \$I24259 \$I24263 \$I24265 VPWR sg13_lv_pmos L=0.13u W=0.42u AS=0.2048p
+ AD=0.09345p PS=1.63u PD=0.865u rfmode=0
M$573 \$I24265 \$I24256 VPWR VPWR sg13_lv_pmos L=0.13u W=0.42u AS=0.09345p
+ AD=0.204p PS=0.865u PD=1.835u rfmode=0
M$574 VPWR \$2741 \$I24256 VPWR sg13_lv_pmos L=0.13u W=0.42u AS=0.204p
+ AD=0.0798p PS=1.835u PD=0.8u rfmode=0
M$575 \$I24256 \$I24259 VPWR VPWR sg13_lv_pmos L=0.13u W=0.42u AS=0.0798p
+ AD=0.4659p PS=0.8u PD=3.65u rfmode=0
M$576 \$I24251 \$I24252 \$I24259 VPWR sg13_lv_pmos L=0.13u W=1u AS=0.34p
+ AD=0.2048p PS=2.68u PD=1.63u rfmode=0
M$577 \$I24257 \$I24259 VPWR VPWR sg13_lv_pmos L=0.13u W=1.12u AS=0.3864p
+ AD=0.2128p PS=2.93u PD=1.5u rfmode=0
M$578 VPWR \$I24257 \$2622 VPWR sg13_lv_pmos L=0.13u W=1.12u AS=0.2128p
+ AD=0.3808p PS=1.5u PD=2.92u rfmode=0
M$579 VPWR \$2917 \$I24253 VPWR sg13_lv_pmos L=0.13u W=0.42u AS=0.1428p
+ AD=0.0798p PS=1.52u PD=0.8u rfmode=0
M$580 VPWR \$2741 \$I24253 VPWR sg13_lv_pmos L=0.13u W=0.42u AS=0.3623875p
+ AD=0.0798p PS=2.605u PD=0.8u rfmode=0
M$581 VPWR \$I24258 \$I24251 VPWR sg13_lv_pmos L=0.13u W=1u AS=0.3623875p
+ AD=0.34p PS=2.605u PD=2.68u rfmode=0
M$582 \$I24263 \$I24252 VPWR VPWR sg13_lv_pmos L=0.13u W=1.12u AS=0.3864p
+ AD=0.41165p PS=2.93u PD=2.12u rfmode=0
M$583 VPWR \$2340 \$I24252 VPWR sg13_lv_pmos L=0.13u W=1.12u AS=0.41165p
+ AD=0.4088p PS=2.12u PD=2.97u rfmode=0
M$584 \$I24258 \$2741 VPWR VPWR sg13_lv_pmos L=0.13u W=0.42u AS=0.147p
+ AD=0.1563p PS=1.54u PD=1.22u rfmode=0
M$585 VPWR \$I24251 \$I24264 VPWR sg13_lv_pmos L=0.13u W=0.42u AS=0.1563p
+ AD=0.063p PS=1.22u PD=0.72u rfmode=0
M$586 \$I24264 \$I24252 \$I24258 VPWR sg13_lv_pmos L=0.13u W=0.42u AS=0.063p
+ AD=0.0798p PS=0.72u PD=0.8u rfmode=0
M$587 \$I24258 \$I24263 \$I24253 VPWR sg13_lv_pmos L=0.13u W=0.42u AS=0.0798p
+ AD=0.1428p PS=0.8u PD=1.52u rfmode=0
M$588 VGND \$I24267 \$I24278 VGND sg13_lv_nmos L=0.13u W=0.74u AS=0.317325p
+ AD=0.2516p PS=1.805u PD=2.16u rfmode=0
M$589 VGND \$1889 \$I24267 VGND sg13_lv_nmos L=0.13u W=0.74u AS=0.317325p
+ AD=0.2516p PS=1.805u PD=2.16u rfmode=0
M$590 \$I24274 \$I24267 \$I24270 VGND sg13_lv_nmos L=0.13u W=0.42u AS=0.12665p
+ AD=0.1428p PS=1.145u PD=1.52u rfmode=0
M$591 \$I24266 \$I24278 \$I24274 VGND sg13_lv_nmos L=0.13u W=0.74u AS=0.3473p
+ AD=0.12665p PS=2.71u PD=1.145u rfmode=0
M$592 \$I24268 \$1931 \$I24275 VGND sg13_lv_nmos L=0.13u W=0.42u AS=0.1428p
+ AD=0.0609p PS=1.52u PD=0.71u rfmode=0
M$593 \$I24275 \$1888 VGND VGND sg13_lv_nmos L=0.13u W=0.42u AS=0.0609p
+ AD=0.1626p PS=0.71u PD=1.415u rfmode=0
M$594 VGND \$I24273 \$I24266 VGND sg13_lv_nmos L=0.13u W=0.74u AS=0.1626p
+ AD=0.2516p PS=1.415u PD=2.16u rfmode=0
M$595 \$I24272 \$I24274 VGND VGND sg13_lv_nmos L=0.13u W=0.74u AS=0.2516p
+ AD=0.1406p PS=2.16u PD=1.12u rfmode=0
M$596 VGND \$I24272 \$1774 VGND sg13_lv_nmos L=0.13u W=0.74u AS=0.1406p
+ AD=0.2516p PS=1.12u PD=2.16u rfmode=0
M$597 \$I24268 \$I24267 \$I24273 VGND sg13_lv_nmos L=0.13u W=0.42u AS=0.1296p
+ AD=0.0798p PS=1.52u PD=0.8u rfmode=0
M$598 \$I24273 \$I24278 \$I24269 VGND sg13_lv_nmos L=0.13u W=0.42u AS=0.0798p
+ AD=0.2373p PS=0.8u PD=1.97u rfmode=0
M$599 \$I24270 \$I24271 VGND VGND sg13_lv_nmos L=0.13u W=0.42u AS=0.1428p
+ AD=0.0798p PS=1.52u PD=0.8u rfmode=0
M$600 VGND \$1888 \$I24277 VGND sg13_lv_nmos L=0.13u W=0.42u AS=0.0798p
+ AD=0.0378p PS=0.8u PD=0.6u rfmode=0
M$601 \$I24277 \$I24274 \$I24271 VGND sg13_lv_nmos L=0.13u W=0.42u AS=0.0378p
+ AD=0.1428p PS=0.6u PD=1.52u rfmode=0
M$602 VGND \$1888 \$I24276 VGND sg13_lv_nmos L=0.13u W=0.42u AS=0.1701p
+ AD=0.0378p PS=1.65u PD=0.6u rfmode=0
M$603 \$I24276 \$I24266 \$I24269 VGND sg13_lv_nmos L=0.13u W=0.42u AS=0.0378p
+ AD=0.1428p PS=0.6u PD=1.52u rfmode=0
M$604 \$I24274 \$I24278 \$I24280 VPWR sg13_lv_pmos L=0.13u W=0.42u AS=0.2048p
+ AD=0.09345p PS=1.63u PD=0.865u rfmode=0
M$605 \$I24280 \$I24271 VPWR VPWR sg13_lv_pmos L=0.13u W=0.42u AS=0.09345p
+ AD=0.204p PS=0.865u PD=1.835u rfmode=0
M$606 VPWR \$1888 \$I24271 VPWR sg13_lv_pmos L=0.13u W=0.42u AS=0.204p
+ AD=0.0798p PS=1.835u PD=0.8u rfmode=0
M$607 \$I24271 \$I24274 VPWR VPWR sg13_lv_pmos L=0.13u W=0.42u AS=0.0798p
+ AD=0.4659p PS=0.8u PD=3.65u rfmode=0
M$608 \$I24266 \$I24267 \$I24274 VPWR sg13_lv_pmos L=0.13u W=1u AS=0.34p
+ AD=0.2048p PS=2.68u PD=1.63u rfmode=0
M$609 \$I24272 \$I24274 VPWR VPWR sg13_lv_pmos L=0.13u W=1.12u AS=0.3864p
+ AD=0.2128p PS=2.93u PD=1.5u rfmode=0
M$610 VPWR \$I24272 \$1774 VPWR sg13_lv_pmos L=0.13u W=1.12u AS=0.2128p
+ AD=0.3808p PS=1.5u PD=2.92u rfmode=0
M$611 VPWR \$1931 \$I24268 VPWR sg13_lv_pmos L=0.13u W=0.42u AS=0.1428p
+ AD=0.0798p PS=1.52u PD=0.8u rfmode=0
M$612 VPWR \$1888 \$I24268 VPWR sg13_lv_pmos L=0.13u W=0.42u AS=0.3623875p
+ AD=0.0798p PS=2.605u PD=0.8u rfmode=0
M$613 VPWR \$I24273 \$I24266 VPWR sg13_lv_pmos L=0.13u W=1u AS=0.3623875p
+ AD=0.34p PS=2.605u PD=2.68u rfmode=0
M$614 \$I24278 \$I24267 VPWR VPWR sg13_lv_pmos L=0.13u W=1.12u AS=0.3864p
+ AD=0.41165p PS=2.93u PD=2.12u rfmode=0
M$615 VPWR \$1889 \$I24267 VPWR sg13_lv_pmos L=0.13u W=1.12u AS=0.41165p
+ AD=0.4088p PS=2.12u PD=2.97u rfmode=0
M$616 \$I24273 \$1888 VPWR VPWR sg13_lv_pmos L=0.13u W=0.42u AS=0.147p
+ AD=0.1563p PS=1.54u PD=1.22u rfmode=0
M$617 VPWR \$I24266 \$I24279 VPWR sg13_lv_pmos L=0.13u W=0.42u AS=0.1563p
+ AD=0.063p PS=1.22u PD=0.72u rfmode=0
M$618 \$I24279 \$I24267 \$I24273 VPWR sg13_lv_pmos L=0.13u W=0.42u AS=0.063p
+ AD=0.0798p PS=0.72u PD=0.8u rfmode=0
M$619 \$I24273 \$I24278 \$I24268 VPWR sg13_lv_pmos L=0.13u W=0.42u AS=0.0798p
+ AD=0.1428p PS=0.8u PD=1.52u rfmode=0
M$620 VGND \$I24282 \$I24293 VGND sg13_lv_nmos L=0.13u W=0.74u AS=0.317325p
+ AD=0.2516p PS=1.805u PD=2.16u rfmode=0
M$621 VGND \$3316 \$I24282 VGND sg13_lv_nmos L=0.13u W=0.74u AS=0.317325p
+ AD=0.2516p PS=1.805u PD=2.16u rfmode=0
M$622 \$I24289 \$I24282 \$I24285 VGND sg13_lv_nmos L=0.13u W=0.42u AS=0.12665p
+ AD=0.1428p PS=1.145u PD=1.52u rfmode=0
M$623 \$I24281 \$I24293 \$I24289 VGND sg13_lv_nmos L=0.13u W=0.74u AS=0.3473p
+ AD=0.12665p PS=2.71u PD=1.145u rfmode=0
M$624 \$I24283 \$3603 \$I24290 VGND sg13_lv_nmos L=0.13u W=0.42u AS=0.1428p
+ AD=0.0609p PS=1.52u PD=0.71u rfmode=0
M$625 \$I24290 \$3567 VGND VGND sg13_lv_nmos L=0.13u W=0.42u AS=0.0609p
+ AD=0.1626p PS=0.71u PD=1.415u rfmode=0
M$626 VGND \$I24288 \$I24281 VGND sg13_lv_nmos L=0.13u W=0.74u AS=0.1626p
+ AD=0.2516p PS=1.415u PD=2.16u rfmode=0
M$627 \$I24287 \$I24289 VGND VGND sg13_lv_nmos L=0.13u W=0.74u AS=0.2516p
+ AD=0.1406p PS=2.16u PD=1.12u rfmode=0
M$628 VGND \$I24287 \$3253 VGND sg13_lv_nmos L=0.13u W=0.74u AS=0.1406p
+ AD=0.2516p PS=1.12u PD=2.16u rfmode=0
M$629 \$I24283 \$I24282 \$I24288 VGND sg13_lv_nmos L=0.13u W=0.42u AS=0.1296p
+ AD=0.0798p PS=1.52u PD=0.8u rfmode=0
M$630 \$I24288 \$I24293 \$I24284 VGND sg13_lv_nmos L=0.13u W=0.42u AS=0.0798p
+ AD=0.2373p PS=0.8u PD=1.97u rfmode=0
M$631 \$I24285 \$I24286 VGND VGND sg13_lv_nmos L=0.13u W=0.42u AS=0.1428p
+ AD=0.0798p PS=1.52u PD=0.8u rfmode=0
M$632 VGND \$3567 \$I24292 VGND sg13_lv_nmos L=0.13u W=0.42u AS=0.0798p
+ AD=0.0378p PS=0.8u PD=0.6u rfmode=0
M$633 \$I24292 \$I24289 \$I24286 VGND sg13_lv_nmos L=0.13u W=0.42u AS=0.0378p
+ AD=0.1428p PS=0.6u PD=1.52u rfmode=0
M$634 VGND \$3567 \$I24291 VGND sg13_lv_nmos L=0.13u W=0.42u AS=0.1701p
+ AD=0.0378p PS=1.65u PD=0.6u rfmode=0
M$635 \$I24291 \$I24281 \$I24284 VGND sg13_lv_nmos L=0.13u W=0.42u AS=0.0378p
+ AD=0.1428p PS=0.6u PD=1.52u rfmode=0
M$636 \$I24289 \$I24293 \$I24295 VPWR sg13_lv_pmos L=0.13u W=0.42u AS=0.2048p
+ AD=0.09345p PS=1.63u PD=0.865u rfmode=0
M$637 \$I24295 \$I24286 VPWR VPWR sg13_lv_pmos L=0.13u W=0.42u AS=0.09345p
+ AD=0.204p PS=0.865u PD=1.835u rfmode=0
M$638 VPWR \$3567 \$I24286 VPWR sg13_lv_pmos L=0.13u W=0.42u AS=0.204p
+ AD=0.0798p PS=1.835u PD=0.8u rfmode=0
M$639 \$I24286 \$I24289 VPWR VPWR sg13_lv_pmos L=0.13u W=0.42u AS=0.0798p
+ AD=0.4659p PS=0.8u PD=3.65u rfmode=0
M$640 \$I24281 \$I24282 \$I24289 VPWR sg13_lv_pmos L=0.13u W=1u AS=0.34p
+ AD=0.2048p PS=2.68u PD=1.63u rfmode=0
M$641 \$I24287 \$I24289 VPWR VPWR sg13_lv_pmos L=0.13u W=1.12u AS=0.3864p
+ AD=0.2128p PS=2.93u PD=1.5u rfmode=0
M$642 VPWR \$I24287 \$3253 VPWR sg13_lv_pmos L=0.13u W=1.12u AS=0.2128p
+ AD=0.3808p PS=1.5u PD=2.92u rfmode=0
M$643 VPWR \$3603 \$I24283 VPWR sg13_lv_pmos L=0.13u W=0.42u AS=0.1428p
+ AD=0.0798p PS=1.52u PD=0.8u rfmode=0
M$644 VPWR \$3567 \$I24283 VPWR sg13_lv_pmos L=0.13u W=0.42u AS=0.3623875p
+ AD=0.0798p PS=2.605u PD=0.8u rfmode=0
M$645 VPWR \$I24288 \$I24281 VPWR sg13_lv_pmos L=0.13u W=1u AS=0.3623875p
+ AD=0.34p PS=2.605u PD=2.68u rfmode=0
M$646 \$I24293 \$I24282 VPWR VPWR sg13_lv_pmos L=0.13u W=1.12u AS=0.3864p
+ AD=0.41165p PS=2.93u PD=2.12u rfmode=0
M$647 VPWR \$3316 \$I24282 VPWR sg13_lv_pmos L=0.13u W=1.12u AS=0.41165p
+ AD=0.4088p PS=2.12u PD=2.97u rfmode=0
M$648 \$I24288 \$3567 VPWR VPWR sg13_lv_pmos L=0.13u W=0.42u AS=0.147p
+ AD=0.1563p PS=1.54u PD=1.22u rfmode=0
M$649 VPWR \$I24281 \$I24294 VPWR sg13_lv_pmos L=0.13u W=0.42u AS=0.1563p
+ AD=0.063p PS=1.22u PD=0.72u rfmode=0
M$650 \$I24294 \$I24282 \$I24288 VPWR sg13_lv_pmos L=0.13u W=0.42u AS=0.063p
+ AD=0.0798p PS=0.72u PD=0.8u rfmode=0
M$651 \$I24288 \$I24293 \$I24283 VPWR sg13_lv_pmos L=0.13u W=0.42u AS=0.0798p
+ AD=0.1428p PS=0.8u PD=1.52u rfmode=0
M$652 VGND \$I24297 \$I24308 VGND sg13_lv_nmos L=0.13u W=0.74u AS=0.317325p
+ AD=0.2516p PS=1.805u PD=2.16u rfmode=0
M$653 VGND \$2340 \$I24297 VGND sg13_lv_nmos L=0.13u W=0.74u AS=0.317325p
+ AD=0.2516p PS=1.805u PD=2.16u rfmode=0
M$654 \$I24304 \$I24297 \$I24300 VGND sg13_lv_nmos L=0.13u W=0.42u AS=0.12665p
+ AD=0.1428p PS=1.145u PD=1.52u rfmode=0
M$655 \$I24296 \$I24308 \$I24304 VGND sg13_lv_nmos L=0.13u W=0.74u AS=0.3473p
+ AD=0.12665p PS=2.71u PD=1.145u rfmode=0
M$656 \$I24298 \$3318 \$I24305 VGND sg13_lv_nmos L=0.13u W=0.42u AS=0.1428p
+ AD=0.0609p PS=1.52u PD=0.71u rfmode=0
M$657 \$I24305 \$3369 VGND VGND sg13_lv_nmos L=0.13u W=0.42u AS=0.0609p
+ AD=0.1626p PS=0.71u PD=1.415u rfmode=0
M$658 VGND \$I24303 \$I24296 VGND sg13_lv_nmos L=0.13u W=0.74u AS=0.1626p
+ AD=0.2516p PS=1.415u PD=2.16u rfmode=0
M$659 \$I24302 \$I24304 VGND VGND sg13_lv_nmos L=0.13u W=0.74u AS=0.2516p
+ AD=0.1406p PS=2.16u PD=1.12u rfmode=0
M$660 VGND \$I24302 \$1768 VGND sg13_lv_nmos L=0.13u W=0.74u AS=0.1406p
+ AD=0.2516p PS=1.12u PD=2.16u rfmode=0
M$661 \$I24298 \$I24297 \$I24303 VGND sg13_lv_nmos L=0.13u W=0.42u AS=0.1296p
+ AD=0.0798p PS=1.52u PD=0.8u rfmode=0
M$662 \$I24303 \$I24308 \$I24299 VGND sg13_lv_nmos L=0.13u W=0.42u AS=0.0798p
+ AD=0.2373p PS=0.8u PD=1.97u rfmode=0
M$663 \$I24300 \$I24301 VGND VGND sg13_lv_nmos L=0.13u W=0.42u AS=0.1428p
+ AD=0.0798p PS=1.52u PD=0.8u rfmode=0
M$664 VGND \$3369 \$I24307 VGND sg13_lv_nmos L=0.13u W=0.42u AS=0.0798p
+ AD=0.0378p PS=0.8u PD=0.6u rfmode=0
M$665 \$I24307 \$I24304 \$I24301 VGND sg13_lv_nmos L=0.13u W=0.42u AS=0.0378p
+ AD=0.1428p PS=0.6u PD=1.52u rfmode=0
M$666 VGND \$3369 \$I24306 VGND sg13_lv_nmos L=0.13u W=0.42u AS=0.1701p
+ AD=0.0378p PS=1.65u PD=0.6u rfmode=0
M$667 \$I24306 \$I24296 \$I24299 VGND sg13_lv_nmos L=0.13u W=0.42u AS=0.0378p
+ AD=0.1428p PS=0.6u PD=1.52u rfmode=0
M$668 \$I24304 \$I24308 \$I24310 VPWR sg13_lv_pmos L=0.13u W=0.42u AS=0.2048p
+ AD=0.09345p PS=1.63u PD=0.865u rfmode=0
M$669 \$I24310 \$I24301 VPWR VPWR sg13_lv_pmos L=0.13u W=0.42u AS=0.09345p
+ AD=0.204p PS=0.865u PD=1.835u rfmode=0
M$670 VPWR \$3369 \$I24301 VPWR sg13_lv_pmos L=0.13u W=0.42u AS=0.204p
+ AD=0.0798p PS=1.835u PD=0.8u rfmode=0
M$671 \$I24301 \$I24304 VPWR VPWR sg13_lv_pmos L=0.13u W=0.42u AS=0.0798p
+ AD=0.4659p PS=0.8u PD=3.65u rfmode=0
M$672 \$I24296 \$I24297 \$I24304 VPWR sg13_lv_pmos L=0.13u W=1u AS=0.34p
+ AD=0.2048p PS=2.68u PD=1.63u rfmode=0
M$673 \$I24302 \$I24304 VPWR VPWR sg13_lv_pmos L=0.13u W=1.12u AS=0.3864p
+ AD=0.2128p PS=2.93u PD=1.5u rfmode=0
M$674 VPWR \$I24302 \$1768 VPWR sg13_lv_pmos L=0.13u W=1.12u AS=0.2128p
+ AD=0.3808p PS=1.5u PD=2.92u rfmode=0
M$675 VPWR \$3318 \$I24298 VPWR sg13_lv_pmos L=0.13u W=0.42u AS=0.1428p
+ AD=0.0798p PS=1.52u PD=0.8u rfmode=0
M$676 VPWR \$3369 \$I24298 VPWR sg13_lv_pmos L=0.13u W=0.42u AS=0.3623875p
+ AD=0.0798p PS=2.605u PD=0.8u rfmode=0
M$677 VPWR \$I24303 \$I24296 VPWR sg13_lv_pmos L=0.13u W=1u AS=0.3623875p
+ AD=0.34p PS=2.605u PD=2.68u rfmode=0
M$678 \$I24308 \$I24297 VPWR VPWR sg13_lv_pmos L=0.13u W=1.12u AS=0.3864p
+ AD=0.41165p PS=2.93u PD=2.12u rfmode=0
M$679 VPWR \$2340 \$I24297 VPWR sg13_lv_pmos L=0.13u W=1.12u AS=0.41165p
+ AD=0.4088p PS=2.12u PD=2.97u rfmode=0
M$680 \$I24303 \$3369 VPWR VPWR sg13_lv_pmos L=0.13u W=0.42u AS=0.147p
+ AD=0.1563p PS=1.54u PD=1.22u rfmode=0
M$681 VPWR \$I24296 \$I24309 VPWR sg13_lv_pmos L=0.13u W=0.42u AS=0.1563p
+ AD=0.063p PS=1.22u PD=0.72u rfmode=0
M$682 \$I24309 \$I24297 \$I24303 VPWR sg13_lv_pmos L=0.13u W=0.42u AS=0.063p
+ AD=0.0798p PS=0.72u PD=0.8u rfmode=0
M$683 \$I24303 \$I24308 \$I24298 VPWR sg13_lv_pmos L=0.13u W=0.42u AS=0.0798p
+ AD=0.1428p PS=0.8u PD=1.52u rfmode=0
M$684 VGND \$I24312 \$I24323 VGND sg13_lv_nmos L=0.13u W=0.74u AS=0.317325p
+ AD=0.2516p PS=1.805u PD=2.16u rfmode=0
M$685 VGND \$1781 \$I24312 VGND sg13_lv_nmos L=0.13u W=0.74u AS=0.317325p
+ AD=0.2516p PS=1.805u PD=2.16u rfmode=0
M$686 \$I24319 \$I24312 \$I24315 VGND sg13_lv_nmos L=0.13u W=0.42u AS=0.12665p
+ AD=0.1428p PS=1.145u PD=1.52u rfmode=0
M$687 \$I24311 \$I24323 \$I24319 VGND sg13_lv_nmos L=0.13u W=0.74u AS=0.3473p
+ AD=0.12665p PS=2.71u PD=1.145u rfmode=0
M$688 \$I24313 \$2056 \$I24320 VGND sg13_lv_nmos L=0.13u W=0.42u AS=0.1428p
+ AD=0.0609p PS=1.52u PD=0.71u rfmode=0
M$689 \$I24320 \$2015 VGND VGND sg13_lv_nmos L=0.13u W=0.42u AS=0.0609p
+ AD=0.1626p PS=0.71u PD=1.415u rfmode=0
M$690 VGND \$I24318 \$I24311 VGND sg13_lv_nmos L=0.13u W=0.74u AS=0.1626p
+ AD=0.2516p PS=1.415u PD=2.16u rfmode=0
M$691 \$I24317 \$I24319 VGND VGND sg13_lv_nmos L=0.13u W=0.74u AS=0.2516p
+ AD=0.1406p PS=2.16u PD=1.12u rfmode=0
M$692 VGND \$I24317 \$2095 VGND sg13_lv_nmos L=0.13u W=0.74u AS=0.1406p
+ AD=0.2516p PS=1.12u PD=2.16u rfmode=0
M$693 \$I24313 \$I24312 \$I24318 VGND sg13_lv_nmos L=0.13u W=0.42u AS=0.1296p
+ AD=0.0798p PS=1.52u PD=0.8u rfmode=0
M$694 \$I24318 \$I24323 \$I24314 VGND sg13_lv_nmos L=0.13u W=0.42u AS=0.0798p
+ AD=0.2373p PS=0.8u PD=1.97u rfmode=0
M$695 \$I24315 \$I24316 VGND VGND sg13_lv_nmos L=0.13u W=0.42u AS=0.1428p
+ AD=0.0798p PS=1.52u PD=0.8u rfmode=0
M$696 VGND \$2015 \$I24322 VGND sg13_lv_nmos L=0.13u W=0.42u AS=0.0798p
+ AD=0.0378p PS=0.8u PD=0.6u rfmode=0
M$697 \$I24322 \$I24319 \$I24316 VGND sg13_lv_nmos L=0.13u W=0.42u AS=0.0378p
+ AD=0.1428p PS=0.6u PD=1.52u rfmode=0
M$698 VGND \$2015 \$I24321 VGND sg13_lv_nmos L=0.13u W=0.42u AS=0.1701p
+ AD=0.0378p PS=1.65u PD=0.6u rfmode=0
M$699 \$I24321 \$I24311 \$I24314 VGND sg13_lv_nmos L=0.13u W=0.42u AS=0.0378p
+ AD=0.1428p PS=0.6u PD=1.52u rfmode=0
M$700 \$I24319 \$I24323 \$I24325 VPWR sg13_lv_pmos L=0.13u W=0.42u AS=0.2048p
+ AD=0.09345p PS=1.63u PD=0.865u rfmode=0
M$701 \$I24325 \$I24316 VPWR VPWR sg13_lv_pmos L=0.13u W=0.42u AS=0.09345p
+ AD=0.204p PS=0.865u PD=1.835u rfmode=0
M$702 VPWR \$2015 \$I24316 VPWR sg13_lv_pmos L=0.13u W=0.42u AS=0.204p
+ AD=0.0798p PS=1.835u PD=0.8u rfmode=0
M$703 \$I24316 \$I24319 VPWR VPWR sg13_lv_pmos L=0.13u W=0.42u AS=0.0798p
+ AD=0.4659p PS=0.8u PD=3.65u rfmode=0
M$704 \$I24311 \$I24312 \$I24319 VPWR sg13_lv_pmos L=0.13u W=1u AS=0.34p
+ AD=0.2048p PS=2.68u PD=1.63u rfmode=0
M$705 \$I24317 \$I24319 VPWR VPWR sg13_lv_pmos L=0.13u W=1.12u AS=0.3864p
+ AD=0.2128p PS=2.93u PD=1.5u rfmode=0
M$706 VPWR \$I24317 \$2095 VPWR sg13_lv_pmos L=0.13u W=1.12u AS=0.2128p
+ AD=0.3808p PS=1.5u PD=2.92u rfmode=0
M$707 VPWR \$2056 \$I24313 VPWR sg13_lv_pmos L=0.13u W=0.42u AS=0.1428p
+ AD=0.0798p PS=1.52u PD=0.8u rfmode=0
M$708 VPWR \$2015 \$I24313 VPWR sg13_lv_pmos L=0.13u W=0.42u AS=0.3623875p
+ AD=0.0798p PS=2.605u PD=0.8u rfmode=0
M$709 VPWR \$I24318 \$I24311 VPWR sg13_lv_pmos L=0.13u W=1u AS=0.3623875p
+ AD=0.34p PS=2.605u PD=2.68u rfmode=0
M$710 \$I24323 \$I24312 VPWR VPWR sg13_lv_pmos L=0.13u W=1.12u AS=0.3864p
+ AD=0.41165p PS=2.93u PD=2.12u rfmode=0
M$711 VPWR \$1781 \$I24312 VPWR sg13_lv_pmos L=0.13u W=1.12u AS=0.41165p
+ AD=0.4088p PS=2.12u PD=2.97u rfmode=0
M$712 \$I24318 \$2015 VPWR VPWR sg13_lv_pmos L=0.13u W=0.42u AS=0.147p
+ AD=0.1563p PS=1.54u PD=1.22u rfmode=0
M$713 VPWR \$I24311 \$I24324 VPWR sg13_lv_pmos L=0.13u W=0.42u AS=0.1563p
+ AD=0.063p PS=1.22u PD=0.72u rfmode=0
M$714 \$I24324 \$I24312 \$I24318 VPWR sg13_lv_pmos L=0.13u W=0.42u AS=0.063p
+ AD=0.0798p PS=0.72u PD=0.8u rfmode=0
M$715 \$I24318 \$I24323 \$I24313 VPWR sg13_lv_pmos L=0.13u W=0.42u AS=0.0798p
+ AD=0.1428p PS=0.8u PD=1.52u rfmode=0
M$716 VGND \$I24327 \$I24338 VGND sg13_lv_nmos L=0.13u W=0.74u AS=0.317325p
+ AD=0.2516p PS=1.805u PD=2.16u rfmode=0
M$717 VGND \$1889 \$I24327 VGND sg13_lv_nmos L=0.13u W=0.74u AS=0.317325p
+ AD=0.2516p PS=1.805u PD=2.16u rfmode=0
M$718 \$I24334 \$I24327 \$I24330 VGND sg13_lv_nmos L=0.13u W=0.42u AS=0.12665p
+ AD=0.1428p PS=1.145u PD=1.52u rfmode=0
M$719 \$I24326 \$I24338 \$I24334 VGND sg13_lv_nmos L=0.13u W=0.74u AS=0.3473p
+ AD=0.12665p PS=2.71u PD=1.145u rfmode=0
M$720 \$I24328 \$3606 \$I24335 VGND sg13_lv_nmos L=0.13u W=0.42u AS=0.1428p
+ AD=0.0609p PS=1.52u PD=0.71u rfmode=0
M$721 \$I24335 \$2006 VGND VGND sg13_lv_nmos L=0.13u W=0.42u AS=0.0609p
+ AD=0.1626p PS=0.71u PD=1.415u rfmode=0
M$722 VGND \$I24333 \$I24326 VGND sg13_lv_nmos L=0.13u W=0.74u AS=0.1626p
+ AD=0.2516p PS=1.415u PD=2.16u rfmode=0
M$723 \$I24332 \$I24334 VGND VGND sg13_lv_nmos L=0.13u W=0.74u AS=0.2516p
+ AD=0.1406p PS=2.16u PD=1.12u rfmode=0
M$724 VGND \$I24332 \$1929 VGND sg13_lv_nmos L=0.13u W=0.74u AS=0.1406p
+ AD=0.2516p PS=1.12u PD=2.16u rfmode=0
M$725 \$I24328 \$I24327 \$I24333 VGND sg13_lv_nmos L=0.13u W=0.42u AS=0.1296p
+ AD=0.0798p PS=1.52u PD=0.8u rfmode=0
M$726 \$I24333 \$I24338 \$I24329 VGND sg13_lv_nmos L=0.13u W=0.42u AS=0.0798p
+ AD=0.2373p PS=0.8u PD=1.97u rfmode=0
M$727 \$I24330 \$I24331 VGND VGND sg13_lv_nmos L=0.13u W=0.42u AS=0.1428p
+ AD=0.0798p PS=1.52u PD=0.8u rfmode=0
M$728 VGND \$2006 \$I24337 VGND sg13_lv_nmos L=0.13u W=0.42u AS=0.0798p
+ AD=0.0378p PS=0.8u PD=0.6u rfmode=0
M$729 \$I24337 \$I24334 \$I24331 VGND sg13_lv_nmos L=0.13u W=0.42u AS=0.0378p
+ AD=0.1428p PS=0.6u PD=1.52u rfmode=0
M$730 VGND \$2006 \$I24336 VGND sg13_lv_nmos L=0.13u W=0.42u AS=0.1701p
+ AD=0.0378p PS=1.65u PD=0.6u rfmode=0
M$731 \$I24336 \$I24326 \$I24329 VGND sg13_lv_nmos L=0.13u W=0.42u AS=0.0378p
+ AD=0.1428p PS=0.6u PD=1.52u rfmode=0
M$732 \$I24334 \$I24338 \$I24340 VPWR sg13_lv_pmos L=0.13u W=0.42u AS=0.2048p
+ AD=0.09345p PS=1.63u PD=0.865u rfmode=0
M$733 \$I24340 \$I24331 VPWR VPWR sg13_lv_pmos L=0.13u W=0.42u AS=0.09345p
+ AD=0.204p PS=0.865u PD=1.835u rfmode=0
M$734 VPWR \$2006 \$I24331 VPWR sg13_lv_pmos L=0.13u W=0.42u AS=0.204p
+ AD=0.0798p PS=1.835u PD=0.8u rfmode=0
M$735 \$I24331 \$I24334 VPWR VPWR sg13_lv_pmos L=0.13u W=0.42u AS=0.0798p
+ AD=0.4659p PS=0.8u PD=3.65u rfmode=0
M$736 \$I24326 \$I24327 \$I24334 VPWR sg13_lv_pmos L=0.13u W=1u AS=0.34p
+ AD=0.2048p PS=2.68u PD=1.63u rfmode=0
M$737 \$I24332 \$I24334 VPWR VPWR sg13_lv_pmos L=0.13u W=1.12u AS=0.3864p
+ AD=0.2128p PS=2.93u PD=1.5u rfmode=0
M$738 VPWR \$I24332 \$1929 VPWR sg13_lv_pmos L=0.13u W=1.12u AS=0.2128p
+ AD=0.3808p PS=1.5u PD=2.92u rfmode=0
M$739 VPWR \$3606 \$I24328 VPWR sg13_lv_pmos L=0.13u W=0.42u AS=0.1428p
+ AD=0.0798p PS=1.52u PD=0.8u rfmode=0
M$740 VPWR \$2006 \$I24328 VPWR sg13_lv_pmos L=0.13u W=0.42u AS=0.3623875p
+ AD=0.0798p PS=2.605u PD=0.8u rfmode=0
M$741 VPWR \$I24333 \$I24326 VPWR sg13_lv_pmos L=0.13u W=1u AS=0.3623875p
+ AD=0.34p PS=2.605u PD=2.68u rfmode=0
M$742 \$I24338 \$I24327 VPWR VPWR sg13_lv_pmos L=0.13u W=1.12u AS=0.3864p
+ AD=0.41165p PS=2.93u PD=2.12u rfmode=0
M$743 VPWR \$1889 \$I24327 VPWR sg13_lv_pmos L=0.13u W=1.12u AS=0.41165p
+ AD=0.4088p PS=2.12u PD=2.97u rfmode=0
M$744 \$I24333 \$2006 VPWR VPWR sg13_lv_pmos L=0.13u W=0.42u AS=0.147p
+ AD=0.1563p PS=1.54u PD=1.22u rfmode=0
M$745 VPWR \$I24326 \$I24339 VPWR sg13_lv_pmos L=0.13u W=0.42u AS=0.1563p
+ AD=0.063p PS=1.22u PD=0.72u rfmode=0
M$746 \$I24339 \$I24327 \$I24333 VPWR sg13_lv_pmos L=0.13u W=0.42u AS=0.063p
+ AD=0.0798p PS=0.72u PD=0.8u rfmode=0
M$747 \$I24333 \$I24338 \$I24328 VPWR sg13_lv_pmos L=0.13u W=0.42u AS=0.0798p
+ AD=0.1428p PS=0.8u PD=1.52u rfmode=0
M$748 VGND \$I24342 \$I24353 VGND sg13_lv_nmos L=0.13u W=0.74u AS=0.317325p
+ AD=0.2516p PS=1.805u PD=2.16u rfmode=0
M$749 VGND \$3316 \$I24342 VGND sg13_lv_nmos L=0.13u W=0.74u AS=0.317325p
+ AD=0.2516p PS=1.805u PD=2.16u rfmode=0
M$750 \$I24349 \$I24342 \$I24345 VGND sg13_lv_nmos L=0.13u W=0.42u AS=0.12665p
+ AD=0.1428p PS=1.145u PD=1.52u rfmode=0
M$751 \$I24341 \$I24353 \$I24349 VGND sg13_lv_nmos L=0.13u W=0.74u AS=0.3473p
+ AD=0.12665p PS=2.71u PD=1.145u rfmode=0
M$752 \$I24343 \$3367 \$I24350 VGND sg13_lv_nmos L=0.13u W=0.42u AS=0.1428p
+ AD=0.0609p PS=1.52u PD=0.71u rfmode=0
M$753 \$I24350 \$3315 VGND VGND sg13_lv_nmos L=0.13u W=0.42u AS=0.0609p
+ AD=0.1626p PS=0.71u PD=1.415u rfmode=0
M$754 VGND \$I24348 \$I24341 VGND sg13_lv_nmos L=0.13u W=0.74u AS=0.1626p
+ AD=0.2516p PS=1.415u PD=2.16u rfmode=0
M$755 \$I24347 \$I24349 VGND VGND sg13_lv_nmos L=0.13u W=0.74u AS=0.2516p
+ AD=0.1406p PS=2.16u PD=1.12u rfmode=0
M$756 VGND \$I24347 \$3317 VGND sg13_lv_nmos L=0.13u W=0.74u AS=0.1406p
+ AD=0.2516p PS=1.12u PD=2.16u rfmode=0
M$757 \$I24343 \$I24342 \$I24348 VGND sg13_lv_nmos L=0.13u W=0.42u AS=0.1296p
+ AD=0.0798p PS=1.52u PD=0.8u rfmode=0
M$758 \$I24348 \$I24353 \$I24344 VGND sg13_lv_nmos L=0.13u W=0.42u AS=0.0798p
+ AD=0.2373p PS=0.8u PD=1.97u rfmode=0
M$759 \$I24345 \$I24346 VGND VGND sg13_lv_nmos L=0.13u W=0.42u AS=0.1428p
+ AD=0.0798p PS=1.52u PD=0.8u rfmode=0
M$760 VGND \$3315 \$I24352 VGND sg13_lv_nmos L=0.13u W=0.42u AS=0.0798p
+ AD=0.0378p PS=0.8u PD=0.6u rfmode=0
M$761 \$I24352 \$I24349 \$I24346 VGND sg13_lv_nmos L=0.13u W=0.42u AS=0.0378p
+ AD=0.1428p PS=0.6u PD=1.52u rfmode=0
M$762 VGND \$3315 \$I24351 VGND sg13_lv_nmos L=0.13u W=0.42u AS=0.1701p
+ AD=0.0378p PS=1.65u PD=0.6u rfmode=0
M$763 \$I24351 \$I24341 \$I24344 VGND sg13_lv_nmos L=0.13u W=0.42u AS=0.0378p
+ AD=0.1428p PS=0.6u PD=1.52u rfmode=0
M$764 \$I24349 \$I24353 \$I24355 VPWR sg13_lv_pmos L=0.13u W=0.42u AS=0.2048p
+ AD=0.09345p PS=1.63u PD=0.865u rfmode=0
M$765 \$I24355 \$I24346 VPWR VPWR sg13_lv_pmos L=0.13u W=0.42u AS=0.09345p
+ AD=0.204p PS=0.865u PD=1.835u rfmode=0
M$766 VPWR \$3315 \$I24346 VPWR sg13_lv_pmos L=0.13u W=0.42u AS=0.204p
+ AD=0.0798p PS=1.835u PD=0.8u rfmode=0
M$767 \$I24346 \$I24349 VPWR VPWR sg13_lv_pmos L=0.13u W=0.42u AS=0.0798p
+ AD=0.4659p PS=0.8u PD=3.65u rfmode=0
M$768 \$I24341 \$I24342 \$I24349 VPWR sg13_lv_pmos L=0.13u W=1u AS=0.34p
+ AD=0.2048p PS=2.68u PD=1.63u rfmode=0
M$769 \$I24347 \$I24349 VPWR VPWR sg13_lv_pmos L=0.13u W=1.12u AS=0.3864p
+ AD=0.2128p PS=2.93u PD=1.5u rfmode=0
M$770 VPWR \$I24347 \$3317 VPWR sg13_lv_pmos L=0.13u W=1.12u AS=0.2128p
+ AD=0.3808p PS=1.5u PD=2.92u rfmode=0
M$771 VPWR \$3367 \$I24343 VPWR sg13_lv_pmos L=0.13u W=0.42u AS=0.1428p
+ AD=0.0798p PS=1.52u PD=0.8u rfmode=0
M$772 VPWR \$3315 \$I24343 VPWR sg13_lv_pmos L=0.13u W=0.42u AS=0.3623875p
+ AD=0.0798p PS=2.605u PD=0.8u rfmode=0
M$773 VPWR \$I24348 \$I24341 VPWR sg13_lv_pmos L=0.13u W=1u AS=0.3623875p
+ AD=0.34p PS=2.605u PD=2.68u rfmode=0
M$774 \$I24353 \$I24342 VPWR VPWR sg13_lv_pmos L=0.13u W=1.12u AS=0.3864p
+ AD=0.41165p PS=2.93u PD=2.12u rfmode=0
M$775 VPWR \$3316 \$I24342 VPWR sg13_lv_pmos L=0.13u W=1.12u AS=0.41165p
+ AD=0.4088p PS=2.12u PD=2.97u rfmode=0
M$776 \$I24348 \$3315 VPWR VPWR sg13_lv_pmos L=0.13u W=0.42u AS=0.147p
+ AD=0.1563p PS=1.54u PD=1.22u rfmode=0
M$777 VPWR \$I24341 \$I24354 VPWR sg13_lv_pmos L=0.13u W=0.42u AS=0.1563p
+ AD=0.063p PS=1.22u PD=0.72u rfmode=0
M$778 \$I24354 \$I24342 \$I24348 VPWR sg13_lv_pmos L=0.13u W=0.42u AS=0.063p
+ AD=0.0798p PS=0.72u PD=0.8u rfmode=0
M$779 \$I24348 \$I24353 \$I24343 VPWR sg13_lv_pmos L=0.13u W=0.42u AS=0.0798p
+ AD=0.1428p PS=0.8u PD=1.52u rfmode=0
M$780 VGND \$I24357 \$I24368 VGND sg13_lv_nmos L=0.13u W=0.74u AS=0.317325p
+ AD=0.2516p PS=1.805u PD=2.16u rfmode=0
M$781 VGND \$2340 \$I24357 VGND sg13_lv_nmos L=0.13u W=0.74u AS=0.317325p
+ AD=0.2516p PS=1.805u PD=2.16u rfmode=0
M$782 \$I24364 \$I24357 \$I24360 VGND sg13_lv_nmos L=0.13u W=0.42u AS=0.12665p
+ AD=0.1428p PS=1.145u PD=1.52u rfmode=0
M$783 \$I24356 \$I24368 \$I24364 VGND sg13_lv_nmos L=0.13u W=0.74u AS=0.3473p
+ AD=0.12665p PS=2.71u PD=1.145u rfmode=0
M$784 \$I24358 \$2264 \$I24365 VGND sg13_lv_nmos L=0.13u W=0.42u AS=0.1428p
+ AD=0.0609p PS=1.52u PD=0.71u rfmode=0
M$785 \$I24365 \$2208 VGND VGND sg13_lv_nmos L=0.13u W=0.42u AS=0.0609p
+ AD=0.1626p PS=0.71u PD=1.415u rfmode=0
M$786 VGND \$I24363 \$I24356 VGND sg13_lv_nmos L=0.13u W=0.74u AS=0.1626p
+ AD=0.2516p PS=1.415u PD=2.16u rfmode=0
M$787 \$I24362 \$I24364 VGND VGND sg13_lv_nmos L=0.13u W=0.74u AS=0.2516p
+ AD=0.1406p PS=2.16u PD=1.12u rfmode=0
M$788 VGND \$I24362 \$2412 VGND sg13_lv_nmos L=0.13u W=0.74u AS=0.1406p
+ AD=0.2516p PS=1.12u PD=2.16u rfmode=0
M$789 \$I24358 \$I24357 \$I24363 VGND sg13_lv_nmos L=0.13u W=0.42u AS=0.1296p
+ AD=0.0798p PS=1.52u PD=0.8u rfmode=0
M$790 \$I24363 \$I24368 \$I24359 VGND sg13_lv_nmos L=0.13u W=0.42u AS=0.0798p
+ AD=0.2373p PS=0.8u PD=1.97u rfmode=0
M$791 \$I24360 \$I24361 VGND VGND sg13_lv_nmos L=0.13u W=0.42u AS=0.1428p
+ AD=0.0798p PS=1.52u PD=0.8u rfmode=0
M$792 VGND \$2208 \$I24367 VGND sg13_lv_nmos L=0.13u W=0.42u AS=0.0798p
+ AD=0.0378p PS=0.8u PD=0.6u rfmode=0
M$793 \$I24367 \$I24364 \$I24361 VGND sg13_lv_nmos L=0.13u W=0.42u AS=0.0378p
+ AD=0.1428p PS=0.6u PD=1.52u rfmode=0
M$794 VGND \$2208 \$I24366 VGND sg13_lv_nmos L=0.13u W=0.42u AS=0.1701p
+ AD=0.0378p PS=1.65u PD=0.6u rfmode=0
M$795 \$I24366 \$I24356 \$I24359 VGND sg13_lv_nmos L=0.13u W=0.42u AS=0.0378p
+ AD=0.1428p PS=0.6u PD=1.52u rfmode=0
M$796 \$I24364 \$I24368 \$I24370 VPWR sg13_lv_pmos L=0.13u W=0.42u AS=0.2048p
+ AD=0.09345p PS=1.63u PD=0.865u rfmode=0
M$797 \$I24370 \$I24361 VPWR VPWR sg13_lv_pmos L=0.13u W=0.42u AS=0.09345p
+ AD=0.204p PS=0.865u PD=1.835u rfmode=0
M$798 VPWR \$2208 \$I24361 VPWR sg13_lv_pmos L=0.13u W=0.42u AS=0.204p
+ AD=0.0798p PS=1.835u PD=0.8u rfmode=0
M$799 \$I24361 \$I24364 VPWR VPWR sg13_lv_pmos L=0.13u W=0.42u AS=0.0798p
+ AD=0.4659p PS=0.8u PD=3.65u rfmode=0
M$800 \$I24356 \$I24357 \$I24364 VPWR sg13_lv_pmos L=0.13u W=1u AS=0.34p
+ AD=0.2048p PS=2.68u PD=1.63u rfmode=0
M$801 \$I24362 \$I24364 VPWR VPWR sg13_lv_pmos L=0.13u W=1.12u AS=0.3864p
+ AD=0.2128p PS=2.93u PD=1.5u rfmode=0
M$802 VPWR \$I24362 \$2412 VPWR sg13_lv_pmos L=0.13u W=1.12u AS=0.2128p
+ AD=0.3808p PS=1.5u PD=2.92u rfmode=0
M$803 VPWR \$2264 \$I24358 VPWR sg13_lv_pmos L=0.13u W=0.42u AS=0.1428p
+ AD=0.0798p PS=1.52u PD=0.8u rfmode=0
M$804 VPWR \$2208 \$I24358 VPWR sg13_lv_pmos L=0.13u W=0.42u AS=0.3623875p
+ AD=0.0798p PS=2.605u PD=0.8u rfmode=0
M$805 VPWR \$I24363 \$I24356 VPWR sg13_lv_pmos L=0.13u W=1u AS=0.3623875p
+ AD=0.34p PS=2.605u PD=2.68u rfmode=0
M$806 \$I24368 \$I24357 VPWR VPWR sg13_lv_pmos L=0.13u W=1.12u AS=0.3864p
+ AD=0.41165p PS=2.93u PD=2.12u rfmode=0
M$807 VPWR \$2340 \$I24357 VPWR sg13_lv_pmos L=0.13u W=1.12u AS=0.41165p
+ AD=0.4088p PS=2.12u PD=2.97u rfmode=0
M$808 \$I24363 \$2208 VPWR VPWR sg13_lv_pmos L=0.13u W=0.42u AS=0.147p
+ AD=0.1563p PS=1.54u PD=1.22u rfmode=0
M$809 VPWR \$I24356 \$I24369 VPWR sg13_lv_pmos L=0.13u W=0.42u AS=0.1563p
+ AD=0.063p PS=1.22u PD=0.72u rfmode=0
M$810 \$I24369 \$I24357 \$I24363 VPWR sg13_lv_pmos L=0.13u W=0.42u AS=0.063p
+ AD=0.0798p PS=0.72u PD=0.8u rfmode=0
M$811 \$I24363 \$I24368 \$I24358 VPWR sg13_lv_pmos L=0.13u W=0.42u AS=0.0798p
+ AD=0.1428p PS=0.8u PD=1.52u rfmode=0
M$812 VGND \$I24372 \$I24383 VGND sg13_lv_nmos L=0.13u W=0.74u AS=0.317325p
+ AD=0.2516p PS=1.805u PD=2.16u rfmode=0
M$813 VGND \$1889 \$I24372 VGND sg13_lv_nmos L=0.13u W=0.74u AS=0.317325p
+ AD=0.2516p PS=1.805u PD=2.16u rfmode=0
M$814 \$I24379 \$I24372 \$I24375 VGND sg13_lv_nmos L=0.13u W=0.42u AS=0.12665p
+ AD=0.1428p PS=1.145u PD=1.52u rfmode=0
M$815 \$I24371 \$I24383 \$I24379 VGND sg13_lv_nmos L=0.13u W=0.74u AS=0.3473p
+ AD=0.12665p PS=2.71u PD=1.145u rfmode=0
M$816 \$I24373 \$2136 \$I24380 VGND sg13_lv_nmos L=0.13u W=0.42u AS=0.1428p
+ AD=0.0609p PS=1.52u PD=0.71u rfmode=0
M$817 \$I24380 \$2093 VGND VGND sg13_lv_nmos L=0.13u W=0.42u AS=0.0609p
+ AD=0.1626p PS=0.71u PD=1.415u rfmode=0
M$818 VGND \$I24378 \$I24371 VGND sg13_lv_nmos L=0.13u W=0.74u AS=0.1626p
+ AD=0.2516p PS=1.415u PD=2.16u rfmode=0
M$819 \$I24377 \$I24379 VGND VGND sg13_lv_nmos L=0.13u W=0.74u AS=0.2516p
+ AD=0.1406p PS=2.16u PD=1.12u rfmode=0
M$820 VGND \$I24377 \$2013 VGND sg13_lv_nmos L=0.13u W=0.74u AS=0.1406p
+ AD=0.2516p PS=1.12u PD=2.16u rfmode=0
M$821 \$I24373 \$I24372 \$I24378 VGND sg13_lv_nmos L=0.13u W=0.42u AS=0.1296p
+ AD=0.0798p PS=1.52u PD=0.8u rfmode=0
M$822 \$I24378 \$I24383 \$I24374 VGND sg13_lv_nmos L=0.13u W=0.42u AS=0.0798p
+ AD=0.2373p PS=0.8u PD=1.97u rfmode=0
M$823 \$I24375 \$I24376 VGND VGND sg13_lv_nmos L=0.13u W=0.42u AS=0.1428p
+ AD=0.0798p PS=1.52u PD=0.8u rfmode=0
M$824 VGND \$2093 \$I24382 VGND sg13_lv_nmos L=0.13u W=0.42u AS=0.0798p
+ AD=0.0378p PS=0.8u PD=0.6u rfmode=0
M$825 \$I24382 \$I24379 \$I24376 VGND sg13_lv_nmos L=0.13u W=0.42u AS=0.0378p
+ AD=0.1428p PS=0.6u PD=1.52u rfmode=0
M$826 VGND \$2093 \$I24381 VGND sg13_lv_nmos L=0.13u W=0.42u AS=0.1701p
+ AD=0.0378p PS=1.65u PD=0.6u rfmode=0
M$827 \$I24381 \$I24371 \$I24374 VGND sg13_lv_nmos L=0.13u W=0.42u AS=0.0378p
+ AD=0.1428p PS=0.6u PD=1.52u rfmode=0
M$828 \$I24379 \$I24383 \$I24385 VPWR sg13_lv_pmos L=0.13u W=0.42u AS=0.2048p
+ AD=0.09345p PS=1.63u PD=0.865u rfmode=0
M$829 \$I24385 \$I24376 VPWR VPWR sg13_lv_pmos L=0.13u W=0.42u AS=0.09345p
+ AD=0.204p PS=0.865u PD=1.835u rfmode=0
M$830 VPWR \$2093 \$I24376 VPWR sg13_lv_pmos L=0.13u W=0.42u AS=0.204p
+ AD=0.0798p PS=1.835u PD=0.8u rfmode=0
M$831 \$I24376 \$I24379 VPWR VPWR sg13_lv_pmos L=0.13u W=0.42u AS=0.0798p
+ AD=0.4659p PS=0.8u PD=3.65u rfmode=0
M$832 \$I24371 \$I24372 \$I24379 VPWR sg13_lv_pmos L=0.13u W=1u AS=0.34p
+ AD=0.2048p PS=2.68u PD=1.63u rfmode=0
M$833 \$I24377 \$I24379 VPWR VPWR sg13_lv_pmos L=0.13u W=1.12u AS=0.3864p
+ AD=0.2128p PS=2.93u PD=1.5u rfmode=0
M$834 VPWR \$I24377 \$2013 VPWR sg13_lv_pmos L=0.13u W=1.12u AS=0.2128p
+ AD=0.3808p PS=1.5u PD=2.92u rfmode=0
M$835 VPWR \$2136 \$I24373 VPWR sg13_lv_pmos L=0.13u W=0.42u AS=0.1428p
+ AD=0.0798p PS=1.52u PD=0.8u rfmode=0
M$836 VPWR \$2093 \$I24373 VPWR sg13_lv_pmos L=0.13u W=0.42u AS=0.3623875p
+ AD=0.0798p PS=2.605u PD=0.8u rfmode=0
M$837 VPWR \$I24378 \$I24371 VPWR sg13_lv_pmos L=0.13u W=1u AS=0.3623875p
+ AD=0.34p PS=2.605u PD=2.68u rfmode=0
M$838 \$I24383 \$I24372 VPWR VPWR sg13_lv_pmos L=0.13u W=1.12u AS=0.3864p
+ AD=0.41165p PS=2.93u PD=2.12u rfmode=0
M$839 VPWR \$1889 \$I24372 VPWR sg13_lv_pmos L=0.13u W=1.12u AS=0.41165p
+ AD=0.4088p PS=2.12u PD=2.97u rfmode=0
M$840 \$I24378 \$2093 VPWR VPWR sg13_lv_pmos L=0.13u W=0.42u AS=0.147p
+ AD=0.1563p PS=1.54u PD=1.22u rfmode=0
M$841 VPWR \$I24371 \$I24384 VPWR sg13_lv_pmos L=0.13u W=0.42u AS=0.1563p
+ AD=0.063p PS=1.22u PD=0.72u rfmode=0
M$842 \$I24384 \$I24372 \$I24378 VPWR sg13_lv_pmos L=0.13u W=0.42u AS=0.063p
+ AD=0.0798p PS=0.72u PD=0.8u rfmode=0
M$843 \$I24378 \$I24383 \$I24373 VPWR sg13_lv_pmos L=0.13u W=0.42u AS=0.0798p
+ AD=0.1428p PS=0.8u PD=1.52u rfmode=0
M$844 VGND \$I24387 \$I24398 VGND sg13_lv_nmos L=0.13u W=0.74u AS=0.317325p
+ AD=0.2516p PS=1.805u PD=2.16u rfmode=0
M$845 VGND \$1889 \$I24387 VGND sg13_lv_nmos L=0.13u W=0.74u AS=0.317325p
+ AD=0.2516p PS=1.805u PD=2.16u rfmode=0
M$846 \$I24394 \$I24387 \$I24390 VGND sg13_lv_nmos L=0.13u W=0.42u AS=0.12665p
+ AD=0.1428p PS=1.145u PD=1.52u rfmode=0
M$847 \$I24386 \$I24398 \$I24394 VGND sg13_lv_nmos L=0.13u W=0.74u AS=0.3473p
+ AD=0.12665p PS=2.71u PD=1.145u rfmode=0
M$848 \$I24388 \$2051 \$I24395 VGND sg13_lv_nmos L=0.13u W=0.42u AS=0.1428p
+ AD=0.0609p PS=1.52u PD=0.71u rfmode=0
M$849 \$I24395 \$1887 VGND VGND sg13_lv_nmos L=0.13u W=0.42u AS=0.0609p
+ AD=0.1626p PS=0.71u PD=1.415u rfmode=0
M$850 VGND \$I24393 \$I24386 VGND sg13_lv_nmos L=0.13u W=0.74u AS=0.1626p
+ AD=0.2516p PS=1.415u PD=2.16u rfmode=0
M$851 \$I24392 \$I24394 VGND VGND sg13_lv_nmos L=0.13u W=0.74u AS=0.2516p
+ AD=0.1406p PS=2.16u PD=1.12u rfmode=0
M$852 VGND \$I24392 \$1927 VGND sg13_lv_nmos L=0.13u W=0.74u AS=0.1406p
+ AD=0.2516p PS=1.12u PD=2.16u rfmode=0
M$853 \$I24388 \$I24387 \$I24393 VGND sg13_lv_nmos L=0.13u W=0.42u AS=0.1296p
+ AD=0.0798p PS=1.52u PD=0.8u rfmode=0
M$854 \$I24393 \$I24398 \$I24389 VGND sg13_lv_nmos L=0.13u W=0.42u AS=0.0798p
+ AD=0.2373p PS=0.8u PD=1.97u rfmode=0
M$855 \$I24390 \$I24391 VGND VGND sg13_lv_nmos L=0.13u W=0.42u AS=0.1428p
+ AD=0.0798p PS=1.52u PD=0.8u rfmode=0
M$856 VGND \$1887 \$I24397 VGND sg13_lv_nmos L=0.13u W=0.42u AS=0.0798p
+ AD=0.0378p PS=0.8u PD=0.6u rfmode=0
M$857 \$I24397 \$I24394 \$I24391 VGND sg13_lv_nmos L=0.13u W=0.42u AS=0.0378p
+ AD=0.1428p PS=0.6u PD=1.52u rfmode=0
M$858 VGND \$1887 \$I24396 VGND sg13_lv_nmos L=0.13u W=0.42u AS=0.1701p
+ AD=0.0378p PS=1.65u PD=0.6u rfmode=0
M$859 \$I24396 \$I24386 \$I24389 VGND sg13_lv_nmos L=0.13u W=0.42u AS=0.0378p
+ AD=0.1428p PS=0.6u PD=1.52u rfmode=0
M$860 \$I24394 \$I24398 \$I24400 VPWR sg13_lv_pmos L=0.13u W=0.42u AS=0.2048p
+ AD=0.09345p PS=1.63u PD=0.865u rfmode=0
M$861 \$I24400 \$I24391 VPWR VPWR sg13_lv_pmos L=0.13u W=0.42u AS=0.09345p
+ AD=0.204p PS=0.865u PD=1.835u rfmode=0
M$862 VPWR \$1887 \$I24391 VPWR sg13_lv_pmos L=0.13u W=0.42u AS=0.204p
+ AD=0.0798p PS=1.835u PD=0.8u rfmode=0
M$863 \$I24391 \$I24394 VPWR VPWR sg13_lv_pmos L=0.13u W=0.42u AS=0.0798p
+ AD=0.4659p PS=0.8u PD=3.65u rfmode=0
M$864 \$I24386 \$I24387 \$I24394 VPWR sg13_lv_pmos L=0.13u W=1u AS=0.34p
+ AD=0.2048p PS=2.68u PD=1.63u rfmode=0
M$865 \$I24392 \$I24394 VPWR VPWR sg13_lv_pmos L=0.13u W=1.12u AS=0.3864p
+ AD=0.2128p PS=2.93u PD=1.5u rfmode=0
M$866 VPWR \$I24392 \$1927 VPWR sg13_lv_pmos L=0.13u W=1.12u AS=0.2128p
+ AD=0.3808p PS=1.5u PD=2.92u rfmode=0
M$867 VPWR \$2051 \$I24388 VPWR sg13_lv_pmos L=0.13u W=0.42u AS=0.1428p
+ AD=0.0798p PS=1.52u PD=0.8u rfmode=0
M$868 VPWR \$1887 \$I24388 VPWR sg13_lv_pmos L=0.13u W=0.42u AS=0.3623875p
+ AD=0.0798p PS=2.605u PD=0.8u rfmode=0
M$869 VPWR \$I24393 \$I24386 VPWR sg13_lv_pmos L=0.13u W=1u AS=0.3623875p
+ AD=0.34p PS=2.605u PD=2.68u rfmode=0
M$870 \$I24398 \$I24387 VPWR VPWR sg13_lv_pmos L=0.13u W=1.12u AS=0.3864p
+ AD=0.41165p PS=2.93u PD=2.12u rfmode=0
M$871 VPWR \$1889 \$I24387 VPWR sg13_lv_pmos L=0.13u W=1.12u AS=0.41165p
+ AD=0.4088p PS=2.12u PD=2.97u rfmode=0
M$872 \$I24393 \$1887 VPWR VPWR sg13_lv_pmos L=0.13u W=0.42u AS=0.147p
+ AD=0.1563p PS=1.54u PD=1.22u rfmode=0
M$873 VPWR \$I24386 \$I24399 VPWR sg13_lv_pmos L=0.13u W=0.42u AS=0.1563p
+ AD=0.063p PS=1.22u PD=0.72u rfmode=0
M$874 \$I24399 \$I24387 \$I24393 VPWR sg13_lv_pmos L=0.13u W=0.42u AS=0.063p
+ AD=0.0798p PS=0.72u PD=0.8u rfmode=0
M$875 \$I24393 \$I24398 \$I24388 VPWR sg13_lv_pmos L=0.13u W=0.42u AS=0.0798p
+ AD=0.1428p PS=0.8u PD=1.52u rfmode=0
M$876 VGND \$I24402 \$I24413 VGND sg13_lv_nmos L=0.13u W=0.74u AS=0.317325p
+ AD=0.2516p PS=1.805u PD=2.16u rfmode=0
M$877 VGND \$1781 \$I24402 VGND sg13_lv_nmos L=0.13u W=0.74u AS=0.317325p
+ AD=0.2516p PS=1.805u PD=2.16u rfmode=0
M$878 \$I24409 \$I24402 \$I24405 VGND sg13_lv_nmos L=0.13u W=0.42u AS=0.12665p
+ AD=0.1428p PS=1.145u PD=1.52u rfmode=0
M$879 \$I24401 \$I24413 \$I24409 VGND sg13_lv_nmos L=0.13u W=0.74u AS=0.3473p
+ AD=0.12665p PS=2.71u PD=1.145u rfmode=0
M$880 \$I24403 \$1831 \$I24410 VGND sg13_lv_nmos L=0.13u W=0.42u AS=0.1428p
+ AD=0.0609p PS=1.52u PD=0.71u rfmode=0
M$881 \$I24410 \$1783 VGND VGND sg13_lv_nmos L=0.13u W=0.42u AS=0.0609p
+ AD=0.1626p PS=0.71u PD=1.415u rfmode=0
M$882 VGND \$I24408 \$I24401 VGND sg13_lv_nmos L=0.13u W=0.74u AS=0.1626p
+ AD=0.2516p PS=1.415u PD=2.16u rfmode=0
M$883 \$I24407 \$I24409 VGND VGND sg13_lv_nmos L=0.13u W=0.74u AS=0.2516p
+ AD=0.1406p PS=2.16u PD=1.12u rfmode=0
M$884 VGND \$I24407 \$1776 VGND sg13_lv_nmos L=0.13u W=0.74u AS=0.1406p
+ AD=0.2516p PS=1.12u PD=2.16u rfmode=0
M$885 \$I24403 \$I24402 \$I24408 VGND sg13_lv_nmos L=0.13u W=0.42u AS=0.1296p
+ AD=0.0798p PS=1.52u PD=0.8u rfmode=0
M$886 \$I24408 \$I24413 \$I24404 VGND sg13_lv_nmos L=0.13u W=0.42u AS=0.0798p
+ AD=0.2373p PS=0.8u PD=1.97u rfmode=0
M$887 \$I24405 \$I24406 VGND VGND sg13_lv_nmos L=0.13u W=0.42u AS=0.1428p
+ AD=0.0798p PS=1.52u PD=0.8u rfmode=0
M$888 VGND \$1783 \$I24412 VGND sg13_lv_nmos L=0.13u W=0.42u AS=0.0798p
+ AD=0.0378p PS=0.8u PD=0.6u rfmode=0
M$889 \$I24412 \$I24409 \$I24406 VGND sg13_lv_nmos L=0.13u W=0.42u AS=0.0378p
+ AD=0.1428p PS=0.6u PD=1.52u rfmode=0
M$890 VGND \$1783 \$I24411 VGND sg13_lv_nmos L=0.13u W=0.42u AS=0.1701p
+ AD=0.0378p PS=1.65u PD=0.6u rfmode=0
M$891 \$I24411 \$I24401 \$I24404 VGND sg13_lv_nmos L=0.13u W=0.42u AS=0.0378p
+ AD=0.1428p PS=0.6u PD=1.52u rfmode=0
M$892 \$I24409 \$I24413 \$I24415 VPWR sg13_lv_pmos L=0.13u W=0.42u AS=0.2048p
+ AD=0.09345p PS=1.63u PD=0.865u rfmode=0
M$893 \$I24415 \$I24406 VPWR VPWR sg13_lv_pmos L=0.13u W=0.42u AS=0.09345p
+ AD=0.204p PS=0.865u PD=1.835u rfmode=0
M$894 VPWR \$1783 \$I24406 VPWR sg13_lv_pmos L=0.13u W=0.42u AS=0.204p
+ AD=0.0798p PS=1.835u PD=0.8u rfmode=0
M$895 \$I24406 \$I24409 VPWR VPWR sg13_lv_pmos L=0.13u W=0.42u AS=0.0798p
+ AD=0.4659p PS=0.8u PD=3.65u rfmode=0
M$896 \$I24401 \$I24402 \$I24409 VPWR sg13_lv_pmos L=0.13u W=1u AS=0.34p
+ AD=0.2048p PS=2.68u PD=1.63u rfmode=0
M$897 \$I24407 \$I24409 VPWR VPWR sg13_lv_pmos L=0.13u W=1.12u AS=0.3864p
+ AD=0.2128p PS=2.93u PD=1.5u rfmode=0
M$898 VPWR \$I24407 \$1776 VPWR sg13_lv_pmos L=0.13u W=1.12u AS=0.2128p
+ AD=0.3808p PS=1.5u PD=2.92u rfmode=0
M$899 VPWR \$1831 \$I24403 VPWR sg13_lv_pmos L=0.13u W=0.42u AS=0.1428p
+ AD=0.0798p PS=1.52u PD=0.8u rfmode=0
M$900 VPWR \$1783 \$I24403 VPWR sg13_lv_pmos L=0.13u W=0.42u AS=0.3623875p
+ AD=0.0798p PS=2.605u PD=0.8u rfmode=0
M$901 VPWR \$I24408 \$I24401 VPWR sg13_lv_pmos L=0.13u W=1u AS=0.3623875p
+ AD=0.34p PS=2.605u PD=2.68u rfmode=0
M$902 \$I24413 \$I24402 VPWR VPWR sg13_lv_pmos L=0.13u W=1.12u AS=0.3864p
+ AD=0.41165p PS=2.93u PD=2.12u rfmode=0
M$903 VPWR \$1781 \$I24402 VPWR sg13_lv_pmos L=0.13u W=1.12u AS=0.41165p
+ AD=0.4088p PS=2.12u PD=2.97u rfmode=0
M$904 \$I24408 \$1783 VPWR VPWR sg13_lv_pmos L=0.13u W=0.42u AS=0.147p
+ AD=0.1563p PS=1.54u PD=1.22u rfmode=0
M$905 VPWR \$I24401 \$I24414 VPWR sg13_lv_pmos L=0.13u W=0.42u AS=0.1563p
+ AD=0.063p PS=1.22u PD=0.72u rfmode=0
M$906 \$I24414 \$I24402 \$I24408 VPWR sg13_lv_pmos L=0.13u W=0.42u AS=0.063p
+ AD=0.0798p PS=0.72u PD=0.8u rfmode=0
M$907 \$I24408 \$I24413 \$I24403 VPWR sg13_lv_pmos L=0.13u W=0.42u AS=0.0798p
+ AD=0.1428p PS=0.8u PD=1.52u rfmode=0
M$908 \$2131 \$2131 \$2131 VAPWR sg13_hv_pmos L=0.5u W=4u AS=1.36p AD=1.36p
+ PS=8.68u PD=8.68u rfmode=0
M$909 \$2133 \$2133 \$2133 VAPWR sg13_hv_pmos L=0.5u W=4u AS=1.36p AD=1.36p
+ PS=8.68u PD=8.68u rfmode=0
M$910 \$3131 \$3131 \$3131 VAPWR sg13_hv_pmos L=0.5u W=12u AS=4.08p AD=4.08p
+ PS=26.04u PD=26.04u rfmode=0
M$912 \$3125 \$3029 \$3131 VAPWR sg13_hv_pmos L=0.5u W=16u AS=5.44p AD=5.44p
+ PS=34.72u PD=34.72u rfmode=0
M$914 \$3124 \$3124 \$3124 VAPWR sg13_hv_pmos L=0.5u W=4u AS=1.36p AD=1.36p
+ PS=8.68u PD=8.68u rfmode=0
M$915 \$3124 analog_1 \$3131 VAPWR sg13_hv_pmos L=0.5u W=16u AS=5.44p AD=5.44p
+ PS=34.72u PD=34.72u rfmode=0
M$916 \$3124 \$3124 VGND VGND sg13_hv_nmos L=0.5u W=8u AS=2.72p AD=2.72p
+ PS=18.72u PD=18.72u rfmode=0
M$917 \$3125 \$3125 \$3125 VAPWR sg13_hv_pmos L=0.5u W=4u AS=1.36p AD=1.36p
+ PS=8.68u PD=8.68u rfmode=0
M$923 \$3125 \$3124 VGND VGND sg13_hv_nmos L=0.5u W=8u AS=2.72p AD=2.72p
+ PS=18.72u PD=18.72u rfmode=0
M$932 \$3124 \$3124 \$3124 VGND sg13_hv_nmos L=0.5u W=2u AS=0.68p AD=0.68p
+ PS=4.68u PD=4.68u rfmode=0
R$933 \$2041 \$3029 VGND rhigh w=2u l=1.4u ps=0u b=0 m=1
R$934 \$1266 \$2041 VGND rhigh w=2u l=1.4u ps=0u b=0 m=1
M$935 \$3125 \$3125 \$3125 VGND sg13_hv_nmos L=0.5u W=2u AS=0.68p AD=0.68p
+ PS=4.68u PD=4.68u rfmode=0
R$936 \$247 VGND VGND rhigh w=2u l=13.71u ps=0.18u b=8 m=1
R$937 \$3026 VGND VGND rhigh w=2u l=13.71u ps=0.18u b=8 m=1
R$938 \$1263 VGND VGND rhigh w=2u l=13.71u ps=0.18u b=8 m=1
R$939 \$2038 VGND VGND rhigh w=2u l=13.71u ps=0.18u b=8 m=1
R$940 \$1607 \$1479 VGND rsil w=0.5u l=0.5u ps=0u b=0 m=1
R$941 VGND \$4233 VGND rhigh w=2u l=10u ps=0u b=0 m=1
R$942 VGND \$4128 VGND rhigh w=2u l=8u ps=0u b=0 m=1
M$943 analog_1 analog_1 \$4128 \$4128 sg13_hv_pmos L=0.5u W=20u AS=4.1p AD=4.1p
+ PS=26.1u PD=26.1u rfmode=0
R$953 \$2787 \$1648 VGND rhigh w=2u l=9.96u ps=0.18u b=3 m=1
R$954 \$4404 \$3500 VGND rhigh w=2u l=9.96u ps=0.18u b=3 m=1
R$955 \$944 analog_2 VGND rhigh w=2u l=9.96u ps=0.18u b=3 m=1
R$956 VGND \$254 VGND rhigh w=2u l=4.95u ps=0.18u b=2 m=1
R$957 VGND \$4562 VGND rhigh w=2u l=4.95u ps=0.18u b=2 m=1
R$958 VGND \$1459 VGND rhigh w=2u l=4.95u ps=0.18u b=2 m=1
R$959 VGND \$3135 VGND rhigh w=2u l=4.95u ps=0.18u b=2 m=1
R$960 VGND \$4021 VGND rhigh w=2u l=4.95u ps=0.18u b=2 m=1
R$961 VGND \$2045 VGND rhigh w=2u l=4.95u ps=0.18u b=2 m=1
R$962 VAPWR \$1925 VGND rhigh w=2u l=19.995u ps=0.18u b=9 m=1
R$963 VAPWR \$4022 VGND rhigh w=2u l=19.995u ps=0.18u b=9 m=1
R$964 VAPWR \$255 VGND rhigh w=2u l=19.995u ps=0.18u b=9 m=1
R$965 VAPWR \$3029 VGND rhigh w=2u l=28.8u ps=0u b=0 m=1
R$966 VGND \$252 VGND rhigh w=2u l=9.27u ps=0.18u b=15 m=1
R$967 VGND \$3030 VGND rhigh w=2u l=9.27u ps=0.18u b=15 m=1
R$968 VGND \$2043 VGND rhigh w=2u l=9.27u ps=0.18u b=15 m=1
R$969 VGND \$1267 VGND rhigh w=2u l=9.27u ps=0.18u b=15 m=1
M$970 VGND q3 \$I24416 VGND sg13_lv_nmos L=0.13u W=0.55u AS=0.14875p AD=0.187p
+ PS=1.16u PD=1.78u rfmode=0
M$971 VGND \$I24416 \$4512 VGND sg13_lv_nmos L=0.13u W=0.74u AS=0.14875p
+ AD=0.2886p PS=1.16u PD=2.26u rfmode=0
M$972 VPWR q3 \$I24416 VPWR sg13_lv_pmos L=0.13u W=0.84u AS=0.2114p AD=0.2856p
+ PS=1.54u PD=2.36u rfmode=0
M$973 VPWR \$I24416 \$4512 VPWR sg13_lv_pmos L=0.13u W=1.12u AS=0.2114p
+ AD=0.42p PS=1.54u PD=2.99u rfmode=0
M$974 VGND q2 \$I24417 VGND sg13_lv_nmos L=0.13u W=0.55u AS=0.14875p AD=0.187p
+ PS=1.16u PD=1.78u rfmode=0
M$975 VGND \$I24417 \$3606 VGND sg13_lv_nmos L=0.13u W=0.74u AS=0.14875p
+ AD=0.2886p PS=1.16u PD=2.26u rfmode=0
M$976 VPWR q2 \$I24417 VPWR sg13_lv_pmos L=0.13u W=0.84u AS=0.2114p AD=0.2856p
+ PS=1.54u PD=2.36u rfmode=0
M$977 VPWR \$I24417 \$3606 VPWR sg13_lv_pmos L=0.13u W=1.12u AS=0.2114p
+ AD=0.42p PS=1.54u PD=2.99u rfmode=0
M$978 VGND \$1927 \$I24418 VGND sg13_lv_nmos L=0.13u W=0.55u AS=0.14875p
+ AD=0.187p PS=1.16u PD=1.78u rfmode=0
M$979 VGND \$I24418 q2_d VGND sg13_lv_nmos L=0.13u W=0.74u AS=0.14875p
+ AD=0.2886p PS=1.16u PD=2.26u rfmode=0
M$980 VPWR \$1927 \$I24418 VPWR sg13_lv_pmos L=0.13u W=0.84u AS=0.2114p
+ AD=0.2856p PS=1.54u PD=2.36u rfmode=0
M$981 VPWR \$I24418 q2_d VPWR sg13_lv_pmos L=0.13u W=1.12u AS=0.2114p AD=0.42p
+ PS=1.54u PD=2.99u rfmode=0
M$982 VGND \$1768 \$I24419 VGND sg13_lv_nmos L=0.13u W=0.55u AS=0.14875p
+ AD=0.187p PS=1.16u PD=1.78u rfmode=0
M$983 VGND \$I24419 q1_d VGND sg13_lv_nmos L=0.13u W=0.74u AS=0.14875p
+ AD=0.2886p PS=1.16u PD=2.26u rfmode=0
M$984 VPWR \$1768 \$I24419 VPWR sg13_lv_pmos L=0.13u W=0.84u AS=0.2114p
+ AD=0.2856p PS=1.54u PD=2.36u rfmode=0
M$985 VPWR \$I24419 q1_d VPWR sg13_lv_pmos L=0.13u W=1.12u AS=0.2114p AD=0.42p
+ PS=1.54u PD=2.99u rfmode=0
M$986 VGND \$718 \$I24420 VGND sg13_lv_nmos L=0.13u W=0.55u AS=0.14875p
+ AD=0.187p PS=1.16u PD=1.78u rfmode=0
M$987 VGND \$I24420 q0_d VGND sg13_lv_nmos L=0.13u W=0.74u AS=0.14875p
+ AD=0.2886p PS=1.16u PD=2.26u rfmode=0
M$988 VPWR \$718 \$I24420 VPWR sg13_lv_pmos L=0.13u W=0.84u AS=0.2114p
+ AD=0.2856p PS=1.54u PD=2.36u rfmode=0
M$989 VPWR \$I24420 q0_d VPWR sg13_lv_pmos L=0.13u W=1.12u AS=0.2114p AD=0.42p
+ PS=1.54u PD=2.99u rfmode=0
M$990 VGND \$1716 \$I24421 VGND sg13_lv_nmos L=0.13u W=0.55u AS=0.14875p
+ AD=0.187p PS=1.16u PD=1.78u rfmode=0
M$991 VGND \$I24421 \$1651 VGND sg13_lv_nmos L=0.13u W=0.74u AS=0.14875p
+ AD=0.2886p PS=1.16u PD=2.26u rfmode=0
M$992 VPWR \$1716 \$I24421 VPWR sg13_lv_pmos L=0.13u W=0.84u AS=0.2114p
+ AD=0.2856p PS=1.54u PD=2.36u rfmode=0
M$993 VPWR \$I24421 \$1651 VPWR sg13_lv_pmos L=0.13u W=1.12u AS=0.2114p
+ AD=0.42p PS=1.54u PD=2.99u rfmode=0
M$994 VGND data_in_tx \$I24422 VGND sg13_lv_nmos L=0.13u W=0.55u AS=0.14875p
+ AD=0.187p PS=1.16u PD=1.78u rfmode=0
M$995 VGND \$I24422 \$3760 VGND sg13_lv_nmos L=0.13u W=0.74u AS=0.14875p
+ AD=0.2886p PS=1.16u PD=2.26u rfmode=0
M$996 VPWR data_in_tx \$I24422 VPWR sg13_lv_pmos L=0.13u W=0.84u AS=0.2114p
+ AD=0.2856p PS=1.54u PD=2.36u rfmode=0
M$997 VPWR \$I24422 \$3760 VPWR sg13_lv_pmos L=0.13u W=1.12u AS=0.2114p
+ AD=0.42p PS=1.54u PD=2.99u rfmode=0
M$998 VGND \$835 \$I24423 VGND sg13_lv_nmos L=0.13u W=0.55u AS=0.14875p
+ AD=0.187p PS=1.16u PD=1.78u rfmode=0
M$999 VGND \$I24423 vctrl_in VGND sg13_lv_nmos L=0.13u W=0.74u AS=0.14875p
+ AD=0.2886p PS=1.16u PD=2.26u rfmode=0
M$1000 VPWR \$835 \$I24423 VPWR sg13_lv_pmos L=0.13u W=0.84u AS=0.2114p
+ AD=0.2856p PS=1.54u PD=2.36u rfmode=0
M$1001 VPWR \$I24423 vctrl_in VPWR sg13_lv_pmos L=0.13u W=1.12u AS=0.2114p
+ AD=0.42p PS=1.54u PD=2.99u rfmode=0
M$1002 VGND \$2399 \$I24424 VGND sg13_lv_nmos L=0.13u W=0.55u AS=0.14875p
+ AD=0.187p PS=1.16u PD=1.78u rfmode=0
M$1003 VGND \$I24424 q3_d VGND sg13_lv_nmos L=0.13u W=0.74u AS=0.14875p
+ AD=0.2886p PS=1.16u PD=2.26u rfmode=0
M$1004 VPWR \$2399 \$I24424 VPWR sg13_lv_pmos L=0.13u W=0.84u AS=0.2114p
+ AD=0.2856p PS=1.54u PD=2.36u rfmode=0
M$1005 VPWR \$I24424 q3_d VPWR sg13_lv_pmos L=0.13u W=1.12u AS=0.2114p AD=0.42p
+ PS=1.54u PD=2.99u rfmode=0
M$1006 VGND q1 \$I24425 VGND sg13_lv_nmos L=0.13u W=0.55u AS=0.14875p AD=0.187p
+ PS=1.16u PD=1.78u rfmode=0
M$1007 VGND \$I24425 \$3367 VGND sg13_lv_nmos L=0.13u W=0.74u AS=0.14875p
+ AD=0.2886p PS=1.16u PD=2.26u rfmode=0
M$1008 VPWR q1 \$I24425 VPWR sg13_lv_pmos L=0.13u W=0.84u AS=0.2114p AD=0.2856p
+ PS=1.54u PD=2.36u rfmode=0
M$1009 VPWR \$I24425 \$3367 VPWR sg13_lv_pmos L=0.13u W=1.12u AS=0.2114p
+ AD=0.42p PS=1.54u PD=2.99u rfmode=0
M$1010 VGND q0 \$I24426 VGND sg13_lv_nmos L=0.13u W=0.55u AS=0.14875p AD=0.187p
+ PS=1.16u PD=1.78u rfmode=0
M$1011 VGND \$I24426 \$2917 VGND sg13_lv_nmos L=0.13u W=0.74u AS=0.14875p
+ AD=0.2886p PS=1.16u PD=2.26u rfmode=0
M$1012 VPWR q0 \$I24426 VPWR sg13_lv_pmos L=0.13u W=0.84u AS=0.2114p AD=0.2856p
+ PS=1.54u PD=2.36u rfmode=0
M$1013 VPWR \$I24426 \$2917 VPWR sg13_lv_pmos L=0.13u W=1.12u AS=0.2114p
+ AD=0.42p PS=1.54u PD=2.99u rfmode=0
M$1014 VGND \$1680 \$I24427 VGND sg13_lv_nmos L=0.13u W=0.55u AS=0.14875p
+ AD=0.187p PS=1.16u PD=1.78u rfmode=0
M$1015 VGND \$I24427 \$2062 VGND sg13_lv_nmos L=0.13u W=0.74u AS=0.14875p
+ AD=0.2886p PS=1.16u PD=2.26u rfmode=0
M$1016 VPWR \$1680 \$I24427 VPWR sg13_lv_pmos L=0.13u W=0.84u AS=0.2114p
+ AD=0.2856p PS=1.54u PD=2.36u rfmode=0
M$1017 VPWR \$I24427 \$2062 VPWR sg13_lv_pmos L=0.13u W=1.12u AS=0.2114p
+ AD=0.42p PS=1.54u PD=2.99u rfmode=0
M$1018 VGND \$2062 \$I24428 VGND sg13_lv_nmos L=0.13u W=0.55u AS=0.14875p
+ AD=0.187p PS=1.16u PD=1.78u rfmode=0
M$1019 VGND \$I24428 rst_n VGND sg13_lv_nmos L=0.13u W=0.74u AS=0.14875p
+ AD=0.2886p PS=1.16u PD=2.26u rfmode=0
M$1020 VPWR \$2062 \$I24428 VPWR sg13_lv_pmos L=0.13u W=0.84u AS=0.2114p
+ AD=0.2856p PS=1.54u PD=2.36u rfmode=0
M$1021 VPWR \$I24428 rst_n VPWR sg13_lv_pmos L=0.13u W=1.12u AS=0.2114p
+ AD=0.42p PS=1.54u PD=2.99u rfmode=0
M$1022 VGND \$1651 \$I24429 VGND sg13_lv_nmos L=0.13u W=0.55u AS=0.14875p
+ AD=0.187p PS=1.16u PD=1.78u rfmode=0
M$1023 VGND \$I24429 clk_ref VGND sg13_lv_nmos L=0.13u W=0.74u AS=0.14875p
+ AD=0.2886p PS=1.16u PD=2.26u rfmode=0
M$1024 VPWR \$1651 \$I24429 VPWR sg13_lv_pmos L=0.13u W=0.84u AS=0.2114p
+ AD=0.2856p PS=1.54u PD=2.36u rfmode=0
M$1025 VPWR \$I24429 clk_ref VPWR sg13_lv_pmos L=0.13u W=1.12u AS=0.2114p
+ AD=0.42p PS=1.54u PD=2.99u rfmode=0
M$1026 VGND rst_n_in \$I24430 VGND sg13_lv_nmos L=0.13u W=0.55u AS=0.14875p
+ AD=0.187p PS=1.16u PD=1.78u rfmode=0
M$1027 VGND \$I24430 \$1680 VGND sg13_lv_nmos L=0.13u W=0.74u AS=0.14875p
+ AD=0.2886p PS=1.16u PD=2.26u rfmode=0
M$1028 VPWR rst_n_in \$I24430 VPWR sg13_lv_pmos L=0.13u W=0.84u AS=0.2114p
+ AD=0.2856p PS=1.54u PD=2.36u rfmode=0
M$1029 VPWR \$I24430 \$1680 VPWR sg13_lv_pmos L=0.13u W=1.12u AS=0.2114p
+ AD=0.42p PS=1.54u PD=2.99u rfmode=0
M$1030 VGND \$604 \$I24431 VGND sg13_lv_nmos L=0.13u W=0.55u AS=0.14875p
+ AD=0.187p PS=1.16u PD=1.78u rfmode=0
M$1031 VGND \$I24431 vctrl_b_in VGND sg13_lv_nmos L=0.13u W=0.74u AS=0.14875p
+ AD=0.2886p PS=1.16u PD=2.26u rfmode=0
M$1032 VPWR \$604 \$I24431 VPWR sg13_lv_pmos L=0.13u W=0.84u AS=0.2114p
+ AD=0.2856p PS=1.54u PD=2.36u rfmode=0
M$1033 VPWR \$I24431 vctrl_b_in VPWR sg13_lv_pmos L=0.13u W=1.12u AS=0.2114p
+ AD=0.42p PS=1.54u PD=2.99u rfmode=0
M$1034 VGND \$I24433 \$I24432 VGND sg13_lv_nmos L=0.5u W=0.42u AS=0.1426p
+ AD=0.1428p PS=1.16u PD=1.52u rfmode=0
M$1035 VGND \$I24432 \$2103 VGND sg13_lv_nmos L=0.13u W=0.74u AS=0.1426p
+ AD=0.2516p PS=1.16u PD=2.16u rfmode=0
M$1036 \$I24434 \$2104 VGND VGND sg13_lv_nmos L=0.13u W=0.42u AS=0.1428p
+ AD=0.0798p PS=1.52u PD=0.8u rfmode=0
M$1037 VGND \$I24434 \$I24433 VGND sg13_lv_nmos L=0.5u W=0.42u AS=0.0798p
+ AD=0.1428p PS=0.8u PD=1.52u rfmode=0
M$1038 \$I24432 \$I24433 VPWR VPWR sg13_lv_pmos L=0.5u W=1u AS=0.34p AD=0.2254p
+ PS=2.68u PD=1.53u rfmode=0
M$1039 VPWR \$I24432 \$2103 VPWR sg13_lv_pmos L=0.13u W=1.12u AS=0.2254p
+ AD=0.4256p PS=1.53u PD=3u rfmode=0
M$1040 VPWR \$2104 \$I24434 VPWR sg13_lv_pmos L=0.13u W=0.42u AS=0.1523p
+ AD=0.1428p PS=1.38u PD=1.52u rfmode=0
M$1041 VPWR \$I24434 \$I24433 VPWR sg13_lv_pmos L=0.5u W=1u AS=0.1523p AD=0.34p
+ PS=1.38u PD=2.68u rfmode=0
M$1042 VGND \$I24436 \$I24435 VGND sg13_lv_nmos L=0.5u W=0.42u AS=0.1426p
+ AD=0.1428p PS=1.16u PD=1.52u rfmode=0
M$1043 VGND \$I24435 \$2098 VGND sg13_lv_nmos L=0.13u W=0.74u AS=0.1426p
+ AD=0.2516p PS=1.16u PD=2.16u rfmode=0
M$1044 \$I24437 \$2095 VGND VGND sg13_lv_nmos L=0.13u W=0.42u AS=0.1428p
+ AD=0.0798p PS=1.52u PD=0.8u rfmode=0
M$1045 VGND \$I24437 \$I24436 VGND sg13_lv_nmos L=0.5u W=0.42u AS=0.0798p
+ AD=0.1428p PS=0.8u PD=1.52u rfmode=0
M$1046 \$I24435 \$I24436 VPWR VPWR sg13_lv_pmos L=0.5u W=1u AS=0.34p AD=0.2254p
+ PS=2.68u PD=1.53u rfmode=0
M$1047 VPWR \$I24435 \$2098 VPWR sg13_lv_pmos L=0.13u W=1.12u AS=0.2254p
+ AD=0.4256p PS=1.53u PD=3u rfmode=0
M$1048 VPWR \$2095 \$I24437 VPWR sg13_lv_pmos L=0.13u W=0.42u AS=0.1523p
+ AD=0.1428p PS=1.38u PD=1.52u rfmode=0
M$1049 VPWR \$I24437 \$I24436 VPWR sg13_lv_pmos L=0.5u W=1u AS=0.1523p AD=0.34p
+ PS=1.38u PD=2.68u rfmode=0
M$1050 VGND \$I24439 \$I24438 VGND sg13_lv_nmos L=0.5u W=0.42u AS=0.1426p
+ AD=0.1428p PS=1.16u PD=1.52u rfmode=0
M$1051 VGND \$I24438 \$1778 VGND sg13_lv_nmos L=0.13u W=0.74u AS=0.1426p
+ AD=0.2516p PS=1.16u PD=2.16u rfmode=0
M$1052 \$I24440 \$1774 VGND VGND sg13_lv_nmos L=0.13u W=0.42u AS=0.1428p
+ AD=0.0798p PS=1.52u PD=0.8u rfmode=0
M$1053 VGND \$I24440 \$I24439 VGND sg13_lv_nmos L=0.5u W=0.42u AS=0.0798p
+ AD=0.1428p PS=0.8u PD=1.52u rfmode=0
M$1054 \$I24438 \$I24439 VPWR VPWR sg13_lv_pmos L=0.5u W=1u AS=0.34p AD=0.2254p
+ PS=2.68u PD=1.53u rfmode=0
M$1055 VPWR \$I24438 \$1778 VPWR sg13_lv_pmos L=0.13u W=1.12u AS=0.2254p
+ AD=0.4256p PS=1.53u PD=3u rfmode=0
M$1056 VPWR \$1774 \$I24440 VPWR sg13_lv_pmos L=0.13u W=0.42u AS=0.1523p
+ AD=0.1428p PS=1.38u PD=1.52u rfmode=0
M$1057 VPWR \$I24440 \$I24439 VPWR sg13_lv_pmos L=0.5u W=1u AS=0.1523p AD=0.34p
+ PS=1.38u PD=2.68u rfmode=0
M$1058 VGND \$I24442 \$I24441 VGND sg13_lv_nmos L=0.5u W=0.42u AS=0.1426p
+ AD=0.1428p PS=1.16u PD=1.52u rfmode=0
M$1059 VGND \$I24441 \$4092 VGND sg13_lv_nmos L=0.13u W=0.74u AS=0.1426p
+ AD=0.2516p PS=1.16u PD=2.16u rfmode=0
M$1060 \$I24443 \$4205 VGND VGND sg13_lv_nmos L=0.13u W=0.42u AS=0.1428p
+ AD=0.0798p PS=1.52u PD=0.8u rfmode=0
M$1061 VGND \$I24443 \$I24442 VGND sg13_lv_nmos L=0.5u W=0.42u AS=0.0798p
+ AD=0.1428p PS=0.8u PD=1.52u rfmode=0
M$1062 \$I24441 \$I24442 VPWR VPWR sg13_lv_pmos L=0.5u W=1u AS=0.34p AD=0.2254p
+ PS=2.68u PD=1.53u rfmode=0
M$1063 VPWR \$I24441 \$4092 VPWR sg13_lv_pmos L=0.13u W=1.12u AS=0.2254p
+ AD=0.4256p PS=1.53u PD=3u rfmode=0
M$1064 VPWR \$4205 \$I24443 VPWR sg13_lv_pmos L=0.13u W=0.42u AS=0.1523p
+ AD=0.1428p PS=1.38u PD=1.52u rfmode=0
M$1065 VPWR \$I24443 \$I24442 VPWR sg13_lv_pmos L=0.5u W=1u AS=0.1523p AD=0.34p
+ PS=1.38u PD=2.68u rfmode=0
M$1066 VGND \$I24445 \$I24444 VGND sg13_lv_nmos L=0.5u W=0.42u AS=0.1426p
+ AD=0.1428p PS=1.16u PD=1.52u rfmode=0
M$1067 VGND \$I24444 \$1769 VGND sg13_lv_nmos L=0.13u W=0.74u AS=0.1426p
+ AD=0.2516p PS=1.16u PD=2.16u rfmode=0
M$1068 \$I24446 \$2013 VGND VGND sg13_lv_nmos L=0.13u W=0.42u AS=0.1428p
+ AD=0.0798p PS=1.52u PD=0.8u rfmode=0
M$1069 VGND \$I24446 \$I24445 VGND sg13_lv_nmos L=0.5u W=0.42u AS=0.0798p
+ AD=0.1428p PS=0.8u PD=1.52u rfmode=0
M$1070 \$I24444 \$I24445 VPWR VPWR sg13_lv_pmos L=0.5u W=1u AS=0.34p AD=0.2254p
+ PS=2.68u PD=1.53u rfmode=0
M$1071 VPWR \$I24444 \$1769 VPWR sg13_lv_pmos L=0.13u W=1.12u AS=0.2254p
+ AD=0.4256p PS=1.53u PD=3u rfmode=0
M$1072 VPWR \$2013 \$I24446 VPWR sg13_lv_pmos L=0.13u W=0.42u AS=0.1523p
+ AD=0.1428p PS=1.38u PD=1.52u rfmode=0
M$1073 VPWR \$I24446 \$I24445 VPWR sg13_lv_pmos L=0.5u W=1u AS=0.1523p AD=0.34p
+ PS=1.38u PD=2.68u rfmode=0
M$1074 VGND \$I24448 \$I24447 VGND sg13_lv_nmos L=0.5u W=0.42u AS=0.1426p
+ AD=0.1428p PS=1.16u PD=1.52u rfmode=0
M$1075 VGND \$I24447 \$2559 VGND sg13_lv_nmos L=0.13u W=0.74u AS=0.1426p
+ AD=0.2516p PS=1.16u PD=2.16u rfmode=0
M$1076 \$I24449 \$2622 VGND VGND sg13_lv_nmos L=0.13u W=0.42u AS=0.1428p
+ AD=0.0798p PS=1.52u PD=0.8u rfmode=0
M$1077 VGND \$I24449 \$I24448 VGND sg13_lv_nmos L=0.5u W=0.42u AS=0.0798p
+ AD=0.1428p PS=0.8u PD=1.52u rfmode=0
M$1078 \$I24447 \$I24448 VPWR VPWR sg13_lv_pmos L=0.5u W=1u AS=0.34p AD=0.2254p
+ PS=2.68u PD=1.53u rfmode=0
M$1079 VPWR \$I24447 \$2559 VPWR sg13_lv_pmos L=0.13u W=1.12u AS=0.2254p
+ AD=0.4256p PS=1.53u PD=3u rfmode=0
M$1080 VPWR \$2622 \$I24449 VPWR sg13_lv_pmos L=0.13u W=0.42u AS=0.1523p
+ AD=0.1428p PS=1.38u PD=1.52u rfmode=0
M$1081 VPWR \$I24449 \$I24448 VPWR sg13_lv_pmos L=0.5u W=1u AS=0.1523p AD=0.34p
+ PS=1.38u PD=2.68u rfmode=0
M$1082 VGND \$I24451 \$I24450 VGND sg13_lv_nmos L=0.5u W=0.42u AS=0.1426p
+ AD=0.1428p PS=1.16u PD=1.52u rfmode=0
M$1083 VGND \$I24450 \$2264 VGND sg13_lv_nmos L=0.13u W=0.74u AS=0.1426p
+ AD=0.2516p PS=1.16u PD=2.16u rfmode=0
M$1084 \$I24452 \$2138 VGND VGND sg13_lv_nmos L=0.13u W=0.42u AS=0.1428p
+ AD=0.0798p PS=1.52u PD=0.8u rfmode=0
M$1085 VGND \$I24452 \$I24451 VGND sg13_lv_nmos L=0.5u W=0.42u AS=0.0798p
+ AD=0.1428p PS=0.8u PD=1.52u rfmode=0
M$1086 \$I24450 \$I24451 VPWR VPWR sg13_lv_pmos L=0.5u W=1u AS=0.34p AD=0.2254p
+ PS=2.68u PD=1.53u rfmode=0
M$1087 VPWR \$I24450 \$2264 VPWR sg13_lv_pmos L=0.13u W=1.12u AS=0.2254p
+ AD=0.4256p PS=1.53u PD=3u rfmode=0
M$1088 VPWR \$2138 \$I24452 VPWR sg13_lv_pmos L=0.13u W=0.42u AS=0.1523p
+ AD=0.1428p PS=1.38u PD=1.52u rfmode=0
M$1089 VPWR \$I24452 \$I24451 VPWR sg13_lv_pmos L=0.5u W=1u AS=0.1523p AD=0.34p
+ PS=1.38u PD=2.68u rfmode=0
M$1090 VGND \$I24454 \$I24453 VGND sg13_lv_nmos L=0.5u W=0.42u AS=0.1426p
+ AD=0.1428p PS=1.16u PD=1.52u rfmode=0
M$1091 VGND \$I24453 \$2136 VGND sg13_lv_nmos L=0.13u W=0.74u AS=0.1426p
+ AD=0.2516p PS=1.16u PD=2.16u rfmode=0
M$1092 \$I24455 \$2204 VGND VGND sg13_lv_nmos L=0.13u W=0.42u AS=0.1428p
+ AD=0.0798p PS=1.52u PD=0.8u rfmode=0
M$1093 VGND \$I24455 \$I24454 VGND sg13_lv_nmos L=0.5u W=0.42u AS=0.0798p
+ AD=0.1428p PS=0.8u PD=1.52u rfmode=0
M$1094 \$I24453 \$I24454 VPWR VPWR sg13_lv_pmos L=0.5u W=1u AS=0.34p AD=0.2254p
+ PS=2.68u PD=1.53u rfmode=0
M$1095 VPWR \$I24453 \$2136 VPWR sg13_lv_pmos L=0.13u W=1.12u AS=0.2254p
+ AD=0.4256p PS=1.53u PD=3u rfmode=0
M$1096 VPWR \$2204 \$I24455 VPWR sg13_lv_pmos L=0.13u W=0.42u AS=0.1523p
+ AD=0.1428p PS=1.38u PD=1.52u rfmode=0
M$1097 VPWR \$I24455 \$I24454 VPWR sg13_lv_pmos L=0.5u W=1u AS=0.1523p AD=0.34p
+ PS=1.38u PD=2.68u rfmode=0
M$1098 VGND \$I24457 \$I24456 VGND sg13_lv_nmos L=0.5u W=0.42u AS=0.1426p
+ AD=0.1428p PS=1.16u PD=1.52u rfmode=0
M$1099 VGND \$I24456 \$2056 VGND sg13_lv_nmos L=0.13u W=0.74u AS=0.1426p
+ AD=0.2516p PS=1.16u PD=2.16u rfmode=0
M$1100 \$I24458 \$1939 VGND VGND sg13_lv_nmos L=0.13u W=0.42u AS=0.1428p
+ AD=0.0798p PS=1.52u PD=0.8u rfmode=0
M$1101 VGND \$I24458 \$I24457 VGND sg13_lv_nmos L=0.5u W=0.42u AS=0.0798p
+ AD=0.1428p PS=0.8u PD=1.52u rfmode=0
M$1102 \$I24456 \$I24457 VPWR VPWR sg13_lv_pmos L=0.5u W=1u AS=0.34p AD=0.2254p
+ PS=2.68u PD=1.53u rfmode=0
M$1103 VPWR \$I24456 \$2056 VPWR sg13_lv_pmos L=0.13u W=1.12u AS=0.2254p
+ AD=0.4256p PS=1.53u PD=3u rfmode=0
M$1104 VPWR \$1939 \$I24458 VPWR sg13_lv_pmos L=0.13u W=0.42u AS=0.1523p
+ AD=0.1428p PS=1.38u PD=1.52u rfmode=0
M$1105 VPWR \$I24458 \$I24457 VPWR sg13_lv_pmos L=0.5u W=1u AS=0.1523p AD=0.34p
+ PS=1.38u PD=2.68u rfmode=0
M$1106 VGND \$I24460 \$I24459 VGND sg13_lv_nmos L=0.5u W=0.42u AS=0.1426p
+ AD=0.1428p PS=1.16u PD=1.52u rfmode=0
M$1107 VGND \$I24459 \$2865 VGND sg13_lv_nmos L=0.13u W=0.74u AS=0.1426p
+ AD=0.2516p PS=1.16u PD=2.16u rfmode=0
M$1108 \$I24461 \$3253 VGND VGND sg13_lv_nmos L=0.13u W=0.42u AS=0.1428p
+ AD=0.0798p PS=1.52u PD=0.8u rfmode=0
M$1109 VGND \$I24461 \$I24460 VGND sg13_lv_nmos L=0.5u W=0.42u AS=0.0798p
+ AD=0.1428p PS=0.8u PD=1.52u rfmode=0
M$1110 \$I24459 \$I24460 VPWR VPWR sg13_lv_pmos L=0.5u W=1u AS=0.34p AD=0.2254p
+ PS=2.68u PD=1.53u rfmode=0
M$1111 VPWR \$I24459 \$2865 VPWR sg13_lv_pmos L=0.13u W=1.12u AS=0.2254p
+ AD=0.4256p PS=1.53u PD=3u rfmode=0
M$1112 VPWR \$3253 \$I24461 VPWR sg13_lv_pmos L=0.13u W=0.42u AS=0.1523p
+ AD=0.1428p PS=1.38u PD=1.52u rfmode=0
M$1113 VPWR \$I24461 \$I24460 VPWR sg13_lv_pmos L=0.5u W=1u AS=0.1523p AD=0.34p
+ PS=1.38u PD=2.68u rfmode=0
M$1114 VGND \$I24463 \$I24462 VGND sg13_lv_nmos L=0.5u W=0.42u AS=0.1426p
+ AD=0.1428p PS=1.16u PD=1.52u rfmode=0
M$1115 VGND \$I24462 \$2209 VGND sg13_lv_nmos L=0.13u W=0.74u AS=0.1426p
+ AD=0.2516p PS=1.16u PD=2.16u rfmode=0
M$1116 \$I24464 \$2412 VGND VGND sg13_lv_nmos L=0.13u W=0.42u AS=0.1428p
+ AD=0.0798p PS=1.52u PD=0.8u rfmode=0
M$1117 VGND \$I24464 \$I24463 VGND sg13_lv_nmos L=0.5u W=0.42u AS=0.0798p
+ AD=0.1428p PS=0.8u PD=1.52u rfmode=0
M$1118 \$I24462 \$I24463 VPWR VPWR sg13_lv_pmos L=0.5u W=1u AS=0.34p AD=0.2254p
+ PS=2.68u PD=1.53u rfmode=0
M$1119 VPWR \$I24462 \$2209 VPWR sg13_lv_pmos L=0.13u W=1.12u AS=0.2254p
+ AD=0.4256p PS=1.53u PD=3u rfmode=0
M$1120 VPWR \$2412 \$I24464 VPWR sg13_lv_pmos L=0.13u W=0.42u AS=0.1523p
+ AD=0.1428p PS=1.38u PD=1.52u rfmode=0
M$1121 VPWR \$I24464 \$I24463 VPWR sg13_lv_pmos L=0.5u W=1u AS=0.1523p AD=0.34p
+ PS=1.38u PD=2.68u rfmode=0
M$1122 VGND \$I24466 \$I24465 VGND sg13_lv_nmos L=0.5u W=0.42u AS=0.1426p
+ AD=0.1428p PS=1.16u PD=1.52u rfmode=0
M$1123 VGND \$I24465 \$2051 VGND sg13_lv_nmos L=0.13u W=0.74u AS=0.1426p
+ AD=0.2516p PS=1.16u PD=2.16u rfmode=0
M$1124 \$I24467 \$1929 VGND VGND sg13_lv_nmos L=0.13u W=0.42u AS=0.1428p
+ AD=0.0798p PS=1.52u PD=0.8u rfmode=0
M$1125 VGND \$I24467 \$I24466 VGND sg13_lv_nmos L=0.5u W=0.42u AS=0.0798p
+ AD=0.1428p PS=0.8u PD=1.52u rfmode=0
M$1126 \$I24465 \$I24466 VPWR VPWR sg13_lv_pmos L=0.5u W=1u AS=0.34p AD=0.2254p
+ PS=2.68u PD=1.53u rfmode=0
M$1127 VPWR \$I24465 \$2051 VPWR sg13_lv_pmos L=0.13u W=1.12u AS=0.2254p
+ AD=0.4256p PS=1.53u PD=3u rfmode=0
M$1128 VPWR \$1929 \$I24467 VPWR sg13_lv_pmos L=0.13u W=0.42u AS=0.1523p
+ AD=0.1428p PS=1.38u PD=1.52u rfmode=0
M$1129 VPWR \$I24467 \$I24466 VPWR sg13_lv_pmos L=0.5u W=1u AS=0.1523p AD=0.34p
+ PS=1.38u PD=2.68u rfmode=0
M$1130 VGND \$I24469 \$I24468 VGND sg13_lv_nmos L=0.5u W=0.42u AS=0.1426p
+ AD=0.1428p PS=1.16u PD=1.52u rfmode=0
M$1131 VGND \$I24468 \$2016 VGND sg13_lv_nmos L=0.13u W=0.74u AS=0.1426p
+ AD=0.2516p PS=1.16u PD=2.16u rfmode=0
M$1132 \$I24470 \$2101 VGND VGND sg13_lv_nmos L=0.13u W=0.42u AS=0.1428p
+ AD=0.0798p PS=1.52u PD=0.8u rfmode=0
M$1133 VGND \$I24470 \$I24469 VGND sg13_lv_nmos L=0.5u W=0.42u AS=0.0798p
+ AD=0.1428p PS=0.8u PD=1.52u rfmode=0
M$1134 \$I24468 \$I24469 VPWR VPWR sg13_lv_pmos L=0.5u W=1u AS=0.34p AD=0.2254p
+ PS=2.68u PD=1.53u rfmode=0
M$1135 VPWR \$I24468 \$2016 VPWR sg13_lv_pmos L=0.13u W=1.12u AS=0.2254p
+ AD=0.4256p PS=1.53u PD=3u rfmode=0
M$1136 VPWR \$2101 \$I24470 VPWR sg13_lv_pmos L=0.13u W=0.42u AS=0.1523p
+ AD=0.1428p PS=1.38u PD=1.52u rfmode=0
M$1137 VPWR \$I24470 \$I24469 VPWR sg13_lv_pmos L=0.5u W=1u AS=0.1523p AD=0.34p
+ PS=1.38u PD=2.68u rfmode=0
M$1138 VGND \$I24472 \$I24471 VGND sg13_lv_nmos L=0.5u W=0.42u AS=0.1426p
+ AD=0.1428p PS=1.16u PD=1.52u rfmode=0
M$1139 VGND \$I24471 \$3318 VGND sg13_lv_nmos L=0.13u W=0.74u AS=0.1426p
+ AD=0.2516p PS=1.16u PD=2.16u rfmode=0
M$1140 \$I24473 \$3317 VGND VGND sg13_lv_nmos L=0.13u W=0.42u AS=0.1428p
+ AD=0.0798p PS=1.52u PD=0.8u rfmode=0
M$1141 VGND \$I24473 \$I24472 VGND sg13_lv_nmos L=0.5u W=0.42u AS=0.0798p
+ AD=0.1428p PS=0.8u PD=1.52u rfmode=0
M$1142 \$I24471 \$I24472 VPWR VPWR sg13_lv_pmos L=0.5u W=1u AS=0.34p AD=0.2254p
+ PS=2.68u PD=1.53u rfmode=0
M$1143 VPWR \$I24471 \$3318 VPWR sg13_lv_pmos L=0.13u W=1.12u AS=0.2254p
+ AD=0.4256p PS=1.53u PD=3u rfmode=0
M$1144 VPWR \$3317 \$I24473 VPWR sg13_lv_pmos L=0.13u W=0.42u AS=0.1523p
+ AD=0.1428p PS=1.38u PD=1.52u rfmode=0
M$1145 VPWR \$I24473 \$I24472 VPWR sg13_lv_pmos L=0.5u W=1u AS=0.1523p AD=0.34p
+ PS=1.38u PD=2.68u rfmode=0
M$1146 VGND \$I24475 \$I24474 VGND sg13_lv_nmos L=0.5u W=0.42u AS=0.1426p
+ AD=0.1428p PS=1.16u PD=1.52u rfmode=0
M$1147 VGND \$I24474 \$1831 VGND sg13_lv_nmos L=0.13u W=0.74u AS=0.1426p
+ AD=0.2516p PS=1.16u PD=2.16u rfmode=0
M$1148 \$I24476 \$1818 VGND VGND sg13_lv_nmos L=0.13u W=0.42u AS=0.1428p
+ AD=0.0798p PS=1.52u PD=0.8u rfmode=0
M$1149 VGND \$I24476 \$I24475 VGND sg13_lv_nmos L=0.5u W=0.42u AS=0.0798p
+ AD=0.1428p PS=0.8u PD=1.52u rfmode=0
M$1150 \$I24474 \$I24475 VPWR VPWR sg13_lv_pmos L=0.5u W=1u AS=0.34p AD=0.2254p
+ PS=2.68u PD=1.53u rfmode=0
M$1151 VPWR \$I24474 \$1831 VPWR sg13_lv_pmos L=0.13u W=1.12u AS=0.2254p
+ AD=0.4256p PS=1.53u PD=3u rfmode=0
M$1152 VPWR \$1818 \$I24476 VPWR sg13_lv_pmos L=0.13u W=0.42u AS=0.1523p
+ AD=0.1428p PS=1.38u PD=1.52u rfmode=0
M$1153 VPWR \$I24476 \$I24475 VPWR sg13_lv_pmos L=0.5u W=1u AS=0.1523p AD=0.34p
+ PS=1.38u PD=2.68u rfmode=0
M$1154 VGND \$1684 \$I24479 VGND sg13_lv_nmos L=0.13u W=0.74u AS=0.2516p
+ AD=0.1406p PS=2.16u PD=1.12u rfmode=0
M$1155 \$I24479 \$2101 \$I24478 VGND sg13_lv_nmos L=0.13u W=0.74u AS=0.1406p
+ AD=0.1406p PS=1.12u PD=1.12u rfmode=0
M$1156 \$I24478 \$2095 \$I24477 VGND sg13_lv_nmos L=0.13u W=0.74u AS=0.1406p
+ AD=0.1406p PS=1.12u PD=1.12u rfmode=0
M$1157 \$I24477 \$2209 \$1890 VGND sg13_lv_nmos L=0.13u W=0.74u AS=0.1406p
+ AD=0.2516p PS=1.12u PD=2.16u rfmode=0
M$1158 VPWR \$1684 \$1890 VPWR sg13_lv_pmos L=0.13u W=1.12u AS=0.3808p
+ AD=0.2128p PS=2.92u PD=1.5u rfmode=0
M$1159 \$1890 \$2101 VPWR VPWR sg13_lv_pmos L=0.13u W=1.12u AS=0.2128p
+ AD=0.2128p PS=1.5u PD=1.5u rfmode=0
M$1160 VPWR \$2095 \$1890 VPWR sg13_lv_pmos L=0.13u W=1.12u AS=0.2128p
+ AD=0.2128p PS=1.5u PD=1.5u rfmode=0
M$1161 \$1890 \$2209 VPWR VPWR sg13_lv_pmos L=0.13u W=1.12u AS=0.2128p
+ AD=0.3808p PS=1.5u PD=2.92u rfmode=0
M$1162 VGND \$1684 \$I24480 VGND sg13_lv_nmos L=0.13u W=0.74u AS=0.2516p
+ AD=0.1406p PS=2.16u PD=1.12u rfmode=0
M$1163 \$I24480 \$2101 \$2406 VGND sg13_lv_nmos L=0.13u W=0.74u AS=0.1406p
+ AD=0.2516p PS=1.12u PD=2.16u rfmode=0
M$1164 VPWR \$1684 \$2406 VPWR sg13_lv_pmos L=0.13u W=1.12u AS=0.3808p
+ AD=0.2128p PS=2.92u PD=1.5u rfmode=0
M$1165 \$2406 \$2101 VPWR VPWR sg13_lv_pmos L=0.13u W=1.12u AS=0.2128p
+ AD=0.3808p PS=1.5u PD=2.92u rfmode=0
M$1166 VGND \$1680 \$1775 VGND sg13_lv_nmos L=0.13u W=0.74u AS=0.2516p
+ AD=0.2516p PS=2.16u PD=2.16u rfmode=0
M$1167 VPWR \$1680 \$1775 VPWR sg13_lv_pmos L=0.13u W=1.12u AS=0.3808p
+ AD=0.3808p PS=2.92u PD=2.92u rfmode=0
M$1168 VGND \$2209 \$2203 VGND sg13_lv_nmos L=0.13u W=0.74u AS=0.2516p
+ AD=0.2516p PS=2.16u PD=2.16u rfmode=0
M$1169 VPWR \$2209 \$2203 VPWR sg13_lv_pmos L=0.13u W=1.12u AS=0.3808p
+ AD=0.3808p PS=2.92u PD=2.92u rfmode=0
M$1170 VGND \$1769 \$1771 VGND sg13_lv_nmos L=0.13u W=0.74u AS=0.2516p
+ AD=0.2516p PS=2.16u PD=2.16u rfmode=0
M$1171 VPWR \$1769 \$1771 VPWR sg13_lv_pmos L=0.13u W=1.12u AS=0.3808p
+ AD=0.3808p PS=2.92u PD=2.92u rfmode=0
M$1172 VGND \$2098 \$1894 VGND sg13_lv_nmos L=0.13u W=0.74u AS=0.2516p
+ AD=0.2516p PS=2.16u PD=2.16u rfmode=0
M$1173 VPWR \$2098 \$1894 VPWR sg13_lv_pmos L=0.13u W=1.12u AS=0.3808p
+ AD=0.3808p PS=2.92u PD=2.92u rfmode=0
M$1174 VGND \$1778 \$1679 VGND sg13_lv_nmos L=0.13u W=0.74u AS=0.2516p
+ AD=0.2516p PS=2.16u PD=2.16u rfmode=0
M$1175 VPWR \$1778 \$1679 VPWR sg13_lv_pmos L=0.13u W=1.12u AS=0.3808p
+ AD=0.3808p PS=2.92u PD=2.92u rfmode=0
M$1176 VGND VPWR VGND VGND sg13_lv_nmos L=1u W=2020.2u AS=536.424p AD=536.424p
+ PS=5591.84u PD=5591.84u rfmode=0
M$1177 VPWR VGND VPWR VPWR sg13_lv_pmos L=1u W=4810u AS=1277.2p AD=1277.2p
+ PS=9786.4u PD=9786.4u rfmode=0
R$10796 \$4297 \$1607 VGND rhigh w=1u l=61.395u ps=0.18u b=2 m=1
R$10797 \$4507 VAPWR VGND rhigh w=2u l=22.72u ps=0.18u b=10 m=1
R$10798 \$3039 VAPWR VGND rhigh w=2u l=22.72u ps=0.18u b=10 m=1
R$10799 \$1274 VAPWR VGND rhigh w=2u l=22.72u ps=0.18u b=10 m=1
R$10800 \$4404 VAPWR VGND rhigh w=2u l=19.995u ps=0.18u b=9 m=1
R$10801 \$2787 VAPWR VGND rhigh w=2u l=19.995u ps=0.18u b=9 m=1
R$10802 \$944 VAPWR VGND rhigh w=2u l=19.995u ps=0.18u b=9 m=1
M$10807 \$56 \$56 \$56 VPWR sg13_lv_pmos L=0.13u W=2u AS=0.68p AD=0.68p
+ PS=4.68u PD=4.68u rfmode=0
M$10808 VPWR VPWR VPWR VPWR sg13_lv_pmos L=0.13u W=10.25u AS=3.485p AD=3.485p
+ PS=26.62u PD=26.62u rfmode=0
M$10809 \$56 \$322 VPWR VPWR sg13_lv_pmos L=0.13u W=40u AS=7.9p AD=7.9p
+ PS=49.9u PD=49.9u rfmode=0
M$10829 \$462 \$462 \$462 VGND sg13_lv_nmos L=0.13u W=2.4u AS=0.816p AD=0.816p
+ PS=6.16u PD=6.16u rfmode=0
M$10830 VGND VGND VGND VGND sg13_lv_nmos L=0.13u W=11u AS=3.74p AD=3.74p
+ PS=28.12u PD=28.12u rfmode=0
M$10831 \$462 \$495 VGND VGND sg13_lv_nmos L=0.13u W=6u AS=1.32p AD=1.32p
+ PS=9.4u PD=9.4u rfmode=0
M$10836 \$462 \$462 \$462 VPWR sg13_lv_pmos L=0.13u W=2.6u AS=0.884p AD=0.884p
+ PS=6.56u PD=6.56u rfmode=0
M$10838 \$462 \$495 VPWR VPWR sg13_lv_pmos L=0.13u W=13.5u AS=2.7675p
+ AD=2.7675p PS=18.95u PD=18.95u rfmode=0
M$10848 \$1095 \$1095 \$1095 VPWR sg13_lv_pmos L=0.13u W=0.95u AS=0.323p
+ AD=0.323p PS=3.26u PD=3.26u rfmode=0
M$10849 \$940 \$940 \$940 VPWR sg13_lv_pmos L=0.13u W=0.45u AS=0.153p AD=0.153p
+ PS=1.58u PD=1.58u rfmode=0
M$10850 \$940 \$1015 \$1095 VPWR sg13_lv_pmos L=0.13u W=4.5u AS=0.9225p
+ AD=0.9225p PS=9.05u PD=9.05u rfmode=0
M$10861 \$495 \$495 \$495 VPWR sg13_lv_pmos L=0.13u W=0.45u AS=0.153p AD=0.153p
+ PS=1.58u PD=1.58u rfmode=0
M$10862 \$495 \$940 VPWR VPWR sg13_lv_pmos L=0.13u W=4.5u AS=0.9225p AD=0.9225p
+ PS=9.05u PD=9.05u rfmode=0
M$10874 \$1095 \$1112 VPWR VPWR sg13_lv_pmos L=0.13u W=5u AS=1.025p AD=1.025p
+ PS=9.6u PD=9.6u rfmode=0
M$10885 \$1097 \$1097 \$1097 VGND sg13_lv_nmos L=0.13u W=1u AS=0.34p AD=0.34p
+ PS=3.36u PD=3.36u rfmode=0
M$10886 \$1097 \$1025 VGND VGND sg13_lv_nmos L=0.13u W=3u AS=0.66p AD=0.66p
+ PS=5.8u PD=5.8u rfmode=0
M$10892 analog_0 analog_0 analog_0 VGND sg13_lv_nmos L=0.13u W=4u AS=1.36p
+ AD=1.36p PS=8.68u PD=8.68u rfmode=0
M$10893 analog_0 \$56 VGND VGND sg13_lv_nmos L=0.13u W=80u AS=15.8p AD=15.8p
+ PS=91.9u PD=91.9u rfmode=0
M$10914 \$56 \$56 \$56 VGND sg13_lv_nmos L=0.13u W=1.8u AS=0.612p AD=0.612p
+ PS=4.28u PD=4.28u rfmode=0
M$10915 \$56 \$322 VGND VGND sg13_lv_nmos L=0.13u W=18u AS=3.69p AD=3.69p
+ PS=23.9u PD=23.9u rfmode=0
M$10925 \$495 \$495 \$495 VGND sg13_lv_nmos L=0.13u W=0.4u AS=0.136p AD=0.136p
+ PS=1.48u PD=1.48u rfmode=0
M$10927 \$495 \$940 VGND VGND sg13_lv_nmos L=0.13u W=2u AS=0.44p AD=0.44p
+ PS=4.6u PD=4.6u rfmode=0
M$10932 \$940 \$940 \$940 VGND sg13_lv_nmos L=0.13u W=0.4u AS=0.136p AD=0.136p
+ PS=1.48u PD=1.48u rfmode=0
M$10934 \$940 \$1015 \$1097 VGND sg13_lv_nmos L=0.13u W=2u AS=0.44p AD=0.44p
+ PS=4.6u PD=4.6u rfmode=0
M$10939 VAPWR VAPWR VAPWR VAPWR sg13_hv_pmos L=4u W=8u AS=2.72p AD=2.72p
+ PS=18.72u PD=18.72u rfmode=0
M$10940 \$468 \$312 VAPWR VAPWR sg13_hv_pmos L=4u W=2u AS=0.68p AD=0.68p
+ PS=4.68u PD=4.68u rfmode=0
M$10941 \$468 \$468 \$468 VAPWR sg13_hv_pmos L=4u W=2u AS=0.68p AD=0.68p
+ PS=4.68u PD=4.68u rfmode=0
M$10942 \$322 \$322 \$322 VGND sg13_lv_nmos L=0.13u W=2.4u AS=0.816p AD=0.816p
+ PS=6.16u PD=6.16u rfmode=0
M$10944 \$322 \$408 VGND VGND sg13_lv_nmos L=0.13u W=6u AS=1.32p AD=1.32p
+ PS=9.4u PD=9.4u rfmode=0
M$10949 \$322 \$322 \$322 VPWR sg13_lv_pmos L=0.13u W=2.6u AS=0.884p AD=0.884p
+ PS=6.56u PD=6.56u rfmode=0
M$10950 VGND VGND VGND VPWR sg13_lv_pmos L=0.13u W=1.3u AS=0.442p AD=0.442p
+ PS=3.28u PD=3.28u rfmode=0
M$10951 \$322 \$414 VGND VPWR sg13_lv_pmos L=0.13u W=13.5u AS=2.7675p
+ AD=2.7675p PS=18.95u PD=18.95u rfmode=0
M$10963 \$322 \$414 \$462 VGND sg13_lv_nmos L=0.13u W=6u AS=1.32p AD=1.32p
+ PS=9.4u PD=9.4u rfmode=0
M$10968 VGND VGND VGND VGND sg13_hv_nmos L=4u W=8u AS=2.72p AD=2.72p PS=18.72u
+ PD=18.72u rfmode=0
M$10969 q0 \$468 VGND VGND sg13_hv_nmos L=4u W=2u AS=0.68p AD=0.68p PS=4.68u
+ PD=4.68u rfmode=0
M$10970 q0 q0 q0 VGND sg13_hv_nmos L=4u W=2u AS=0.68p AD=0.68p PS=4.68u
+ PD=4.68u rfmode=0
M$10971 VPWR VPWR VPWR VPWR sg13_hv_pmos L=4u W=8u AS=2.72p AD=2.72p PS=18.72u
+ PD=18.72u rfmode=0
M$10972 q0 \$468 VPWR VPWR sg13_hv_pmos L=4u W=2u AS=0.68p AD=0.68p PS=4.68u
+ PD=4.68u rfmode=0
M$10973 q0 q0 q0 VPWR sg13_hv_pmos L=4u W=2u AS=0.68p AD=0.68p PS=4.68u
+ PD=4.68u rfmode=0
M$10974 \$247 \$247 \$247 VGND sg13_hv_nmos L=4u W=2u AS=0.68p AD=0.68p
+ PS=4.68u PD=4.68u rfmode=0
M$10975 \$468 \$312 \$247 VGND sg13_hv_nmos L=4u W=2u AS=0.68p AD=0.68p
+ PS=4.68u PD=4.68u rfmode=0
M$10976 \$468 \$468 \$468 VGND sg13_hv_nmos L=4u W=2u AS=0.68p AD=0.68p
+ PS=4.68u PD=4.68u rfmode=0
M$10979 \$322 \$408 \$462 VPWR sg13_lv_pmos L=0.13u W=13.5u AS=2.7675p
+ AD=2.7675p PS=18.95u PD=18.95u rfmode=0
M$10989 analog_0 analog_0 analog_0 VPWR sg13_lv_pmos L=0.13u W=4u AS=1.36p
+ AD=1.36p PS=8.68u PD=8.68u rfmode=0
M$10991 analog_0 \$56 VPWR VPWR sg13_lv_pmos L=0.13u W=200u AS=38.6p AD=38.6p
+ PS=223.3u PD=223.3u rfmode=0
M$11042 \$1262 \$1262 \$1262 VGND sg13_lv_nmos L=0.13u W=1u AS=0.34p AD=0.34p
+ PS=3.36u PD=3.36u rfmode=0
M$11043 \$1262 \$1025 VGND VGND sg13_lv_nmos L=0.13u W=3u AS=0.66p AD=0.66p
+ PS=5.8u PD=5.8u rfmode=0
M$11049 \$1112 \$1112 \$1112 VPWR sg13_lv_pmos L=0.13u W=0.5u AS=0.17p AD=0.17p
+ PS=1.68u PD=1.68u rfmode=0
M$11050 VPWR \$1112 \$1112 VPWR sg13_lv_pmos L=0.13u W=5u AS=1.025p AD=1.025p
+ PS=9.6u PD=9.6u rfmode=0
M$11060 \$1259 \$1259 \$1259 VPWR sg13_lv_pmos L=0.13u W=0.95u AS=0.323p
+ AD=0.323p PS=3.26u PD=3.26u rfmode=0
M$11061 \$1184 \$1184 \$1184 VPWR sg13_lv_pmos L=0.13u W=0.45u AS=0.153p
+ AD=0.153p PS=1.58u PD=1.58u rfmode=0
M$11062 \$1184 \$940 \$1259 VPWR sg13_lv_pmos L=0.13u W=4.5u AS=0.9225p
+ AD=0.9225p PS=9.05u PD=9.05u rfmode=0
M$11072 \$1025 \$1025 \$1025 VPWR sg13_lv_pmos L=0.13u W=0.5u AS=0.17p AD=0.17p
+ PS=1.68u PD=1.68u rfmode=0
M$11074 \$1025 \$1112 VPWR VPWR sg13_lv_pmos L=0.13u W=5u AS=1.025p AD=1.025p
+ PS=9.6u PD=9.6u rfmode=0
M$11086 \$1259 \$1112 VPWR VPWR sg13_lv_pmos L=0.13u W=5u AS=1.025p AD=1.025p
+ PS=9.6u PD=9.6u rfmode=0
M$11096 \$1112 \$1112 \$1112 VGND sg13_lv_nmos L=0.13u W=2u AS=0.68p AD=0.68p
+ PS=4.68u PD=4.68u rfmode=0
M$11097 \$1186 \$1186 \$1186 VGND sg13_lv_nmos L=0.13u W=2u AS=0.68p AD=0.68p
+ PS=4.68u PD=4.68u rfmode=0
M$11098 \$1186 \$1479 \$1112 VGND sg13_lv_nmos L=0.13u W=40u AS=7.9p AD=7.9p
+ PS=49.9u PD=49.9u rfmode=0
M$11118 \$1184 \$1184 \$1184 VGND sg13_lv_nmos L=0.13u W=0.4u AS=0.136p
+ AD=0.136p PS=1.48u PD=1.48u rfmode=0
M$11120 \$1184 \$940 \$1262 VGND sg13_lv_nmos L=0.13u W=2u AS=0.44p AD=0.44p
+ PS=4.6u PD=4.6u rfmode=0
M$11126 \$1025 \$1025 \$1025 VGND sg13_lv_nmos L=0.13u W=0.6u AS=0.204p
+ AD=0.204p PS=1.88u PD=1.88u rfmode=0
M$11127 \$1025 \$1025 VGND VGND sg13_lv_nmos L=0.13u W=3u AS=0.66p AD=0.66p
+ PS=5.8u PD=5.8u rfmode=0
M$11132 \$1182 \$1182 \$1182 VPWR sg13_lv_pmos L=0.13u W=0.95u AS=0.323p
+ AD=0.323p PS=3.26u PD=3.26u rfmode=0
M$11134 \$1182 \$1112 VPWR VPWR sg13_lv_pmos L=0.13u W=5u AS=1.025p AD=1.025p
+ PS=9.6u PD=9.6u rfmode=0
M$11145 \$1015 \$1015 \$1015 VPWR sg13_lv_pmos L=0.13u W=0.45u AS=0.153p
+ AD=0.153p PS=1.58u PD=1.58u rfmode=0
M$11146 \$1015 \$1184 \$1182 VPWR sg13_lv_pmos L=0.13u W=4.5u AS=0.9225p
+ AD=0.9225p PS=9.05u PD=9.05u rfmode=0
M$11157 \$1527 \$1371 VAPWR VAPWR sg13_hv_pmos L=4u W=2u AS=0.68p AD=0.68p
+ PS=4.68u PD=4.68u rfmode=0
M$11158 \$1527 \$1527 \$1527 VAPWR sg13_hv_pmos L=4u W=2u AS=0.68p AD=0.68p
+ PS=4.68u PD=4.68u rfmode=0
M$11159 \$1263 \$1263 \$1263 VGND sg13_hv_nmos L=4u W=2u AS=0.68p AD=0.68p
+ PS=4.68u PD=4.68u rfmode=0
M$11160 \$1527 \$1371 \$1263 VGND sg13_hv_nmos L=4u W=2u AS=0.68p AD=0.68p
+ PS=4.68u PD=4.68u rfmode=0
M$11161 \$1527 \$1527 \$1527 VGND sg13_hv_nmos L=4u W=2u AS=0.68p AD=0.68p
+ PS=4.68u PD=4.68u rfmode=0
M$11163 q1 \$1527 VPWR VPWR sg13_hv_pmos L=4u W=2u AS=0.68p AD=0.68p PS=4.68u
+ PD=4.68u rfmode=0
M$11164 q1 q1 q1 VPWR sg13_hv_pmos L=4u W=2u AS=0.68p AD=0.68p PS=4.68u
+ PD=4.68u rfmode=0
M$11166 q1 \$1527 VGND VGND sg13_hv_nmos L=4u W=2u AS=0.68p AD=0.68p PS=4.68u
+ PD=4.68u rfmode=0
M$11167 q1 q1 q1 VGND sg13_hv_nmos L=4u W=2u AS=0.68p AD=0.68p PS=4.68u
+ PD=4.68u rfmode=0
M$11168 \$1015 \$1015 \$1015 VGND sg13_lv_nmos L=0.13u W=0.4u AS=0.136p
+ AD=0.136p PS=1.48u PD=1.48u rfmode=0
M$11169 \$1185 \$1185 \$1185 VGND sg13_lv_nmos L=0.13u W=1u AS=0.34p AD=0.34p
+ PS=3.36u PD=3.36u rfmode=0
M$11170 \$1015 \$1184 \$1185 VGND sg13_lv_nmos L=0.13u W=2u AS=0.44p AD=0.44p
+ PS=4.6u PD=4.6u rfmode=0
M$11177 \$1185 \$1025 VGND VGND sg13_lv_nmos L=0.13u W=3u AS=0.66p AD=0.66p
+ PS=5.8u PD=5.8u rfmode=0
M$11182 \$2043 \$2043 \$2043 VAPWR sg13_hv_pmos L=0.5u W=4u AS=1.36p AD=1.36p
+ PS=8.68u PD=8.68u rfmode=0
M$11183 \$3030 \$3030 \$3030 VAPWR sg13_hv_pmos L=0.5u W=4u AS=1.36p AD=1.36p
+ PS=8.68u PD=8.68u rfmode=0
M$11184 \$1267 \$1267 \$1267 VAPWR sg13_hv_pmos L=0.5u W=4u AS=1.36p AD=1.36p
+ PS=8.68u PD=8.68u rfmode=0
M$11185 \$252 \$252 \$252 VAPWR sg13_hv_pmos L=0.5u W=4u AS=1.36p AD=1.36p
+ PS=8.68u PD=8.68u rfmode=0
M$11186 \$2043 \$2043 VAPWR VAPWR sg13_hv_pmos L=0.5u W=4u AS=1.36p AD=1.36p
+ PS=8.68u PD=8.68u rfmode=0
M$11187 \$3030 \$3030 VAPWR VAPWR sg13_hv_pmos L=0.5u W=4u AS=1.36p AD=1.36p
+ PS=8.68u PD=8.68u rfmode=0
M$11188 \$1267 \$1267 VAPWR VAPWR sg13_hv_pmos L=0.5u W=4u AS=1.36p AD=1.36p
+ PS=8.68u PD=8.68u rfmode=0
M$11189 \$252 \$252 VAPWR VAPWR sg13_hv_pmos L=0.5u W=4u AS=1.36p AD=1.36p
+ PS=8.68u PD=8.68u rfmode=0
M$11190 VAPWR VAPWR VAPWR VAPWR sg13_hv_pmos L=0.5u W=60u AS=20.4p AD=20.4p
+ PS=134.96u PD=134.96u rfmode=0
M$11195 q3 \$3241 VGND VGND sg13_hv_nmos L=4u W=2u AS=0.68p AD=0.68p PS=4.68u
+ PD=4.68u rfmode=0
M$11196 q3 q3 q3 VGND sg13_hv_nmos L=4u W=2u AS=0.68p AD=0.68p PS=4.68u
+ PD=4.68u rfmode=0
M$11198 \$3241 \$3125 VAPWR VAPWR sg13_hv_pmos L=4u W=2u AS=0.68p AD=0.68p
+ PS=4.68u PD=4.68u rfmode=0
M$11199 \$3241 \$3241 \$3241 VAPWR sg13_hv_pmos L=4u W=2u AS=0.68p AD=0.68p
+ PS=4.68u PD=4.68u rfmode=0
M$11200 \$3026 \$3026 \$3026 VGND sg13_hv_nmos L=4u W=2u AS=0.68p AD=0.68p
+ PS=4.68u PD=4.68u rfmode=0
M$11201 \$3241 \$3125 \$3026 VGND sg13_hv_nmos L=4u W=2u AS=0.68p AD=0.68p
+ PS=4.68u PD=4.68u rfmode=0
M$11202 \$3241 \$3241 \$3241 VGND sg13_hv_nmos L=4u W=2u AS=0.68p AD=0.68p
+ PS=4.68u PD=4.68u rfmode=0
M$11204 q3 \$3241 VPWR VPWR sg13_hv_pmos L=4u W=2u AS=0.68p AD=0.68p PS=4.68u
+ PD=4.68u rfmode=0
M$11205 q3 q3 q3 VPWR sg13_hv_pmos L=4u W=2u AS=0.68p AD=0.68p PS=4.68u
+ PD=4.68u rfmode=0
M$11206 \$4233 \$4233 \$4233 VAPWR sg13_hv_pmos L=0.5u W=2u AS=0.68p AD=0.68p
+ PS=4.68u PD=4.68u rfmode=0
M$11208 \$4233 \$4233 VAPWR VAPWR sg13_hv_pmos L=0.5u W=14u AS=2.96p AD=2.96p
+ PS=18.96u PD=18.96u rfmode=0
M$11215 \$4128 \$4128 \$4128 VAPWR sg13_hv_pmos L=0.5u W=2u AS=0.68p AD=0.68p
+ PS=4.68u PD=4.68u rfmode=0
M$11217 \$4128 \$4233 VAPWR VAPWR sg13_hv_pmos L=0.5u W=14u AS=2.96p AD=2.96p
+ PS=18.96u PD=18.96u rfmode=0
M$11224 \$1274 \$1274 \$1274 VGND sg13_hv_nmos L=0.5u W=0.5u AS=0.17p AD=0.17p
+ PS=1.68u PD=1.68u rfmode=0
M$11225 \$4507 \$4507 \$4507 VGND sg13_hv_nmos L=0.5u W=0.5u AS=0.17p AD=0.17p
+ PS=1.68u PD=1.68u rfmode=0
M$11226 \$3039 \$3039 \$3039 VGND sg13_hv_nmos L=0.5u W=0.5u AS=0.17p AD=0.17p
+ PS=1.68u PD=1.68u rfmode=0
M$11227 \$1274 \$1274 VGND VGND sg13_hv_nmos L=0.5u W=0.5u AS=0.17p AD=0.17p
+ PS=1.68u PD=1.68u rfmode=0
M$11228 \$4507 \$4507 VGND VGND sg13_hv_nmos L=0.5u W=0.5u AS=0.17p AD=0.17p
+ PS=1.68u PD=1.68u rfmode=0
M$11229 \$3039 \$3039 VGND VGND sg13_hv_nmos L=0.5u W=0.5u AS=0.17p AD=0.17p
+ PS=1.68u PD=1.68u rfmode=0
M$11233 \$4562 \$4562 \$4562 VAPWR sg13_hv_pmos L=0.5u W=2u AS=0.68p AD=0.68p
+ PS=4.68u PD=4.68u rfmode=0
M$11234 \$3135 \$3135 \$3135 VAPWR sg13_hv_pmos L=0.5u W=2u AS=0.68p AD=0.68p
+ PS=4.68u PD=4.68u rfmode=0
M$11235 \$1459 \$1459 \$1459 VAPWR sg13_hv_pmos L=0.5u W=2u AS=0.68p AD=0.68p
+ PS=4.68u PD=4.68u rfmode=0
M$11239 \$4562 \$4562 VAPWR VAPWR sg13_hv_pmos L=0.5u W=14u AS=2.96p AD=2.96p
+ PS=18.96u PD=18.96u rfmode=0
M$11246 \$3135 \$3135 VAPWR VAPWR sg13_hv_pmos L=0.5u W=14u AS=2.96p AD=2.96p
+ PS=18.96u PD=18.96u rfmode=0
M$11253 \$1459 \$1459 VAPWR VAPWR sg13_hv_pmos L=0.5u W=14u AS=2.96p AD=2.96p
+ PS=18.96u PD=18.96u rfmode=0
M$11260 \$1099 \$1099 \$1099 VGND sg13_hv_nmos L=0.5u W=1.5u AS=0.51p AD=0.51p
+ PS=4.36u PD=4.36u rfmode=0
M$11261 \$2915 \$2915 \$2915 VGND sg13_hv_nmos L=0.5u W=1.5u AS=0.51p AD=0.51p
+ PS=4.36u PD=4.36u rfmode=0
M$11262 \$4308 \$4308 \$4308 VGND sg13_hv_nmos L=0.5u W=1.5u AS=0.51p AD=0.51p
+ PS=4.36u PD=4.36u rfmode=0
M$11263 \$1099 \$1274 VGND VGND sg13_hv_nmos L=0.5u W=0.5u AS=0.17p AD=0.17p
+ PS=1.68u PD=1.68u rfmode=0
M$11264 \$2915 \$3039 VGND VGND sg13_hv_nmos L=0.5u W=0.5u AS=0.17p AD=0.17p
+ PS=1.68u PD=1.68u rfmode=0
M$11265 \$4308 \$4507 VGND VGND sg13_hv_nmos L=0.5u W=0.5u AS=0.17p AD=0.17p
+ PS=1.68u PD=1.68u rfmode=0
M$11269 \$2915 \$2915 \$2915 VAPWR sg13_hv_pmos L=0.5u W=2.7u AS=0.918p
+ AD=0.918p PS=6.76u PD=6.76u rfmode=0
M$11270 \$4308 \$4308 \$4308 VAPWR sg13_hv_pmos L=0.5u W=2.7u AS=0.918p
+ AD=0.918p PS=6.76u PD=6.76u rfmode=0
M$11271 \$1099 \$1099 \$1099 VAPWR sg13_hv_pmos L=0.5u W=2.7u AS=0.918p
+ AD=0.918p PS=6.76u PD=6.76u rfmode=0
M$11275 \$2915 \$3135 VAPWR VAPWR sg13_hv_pmos L=0.5u W=14u AS=2.96p AD=2.96p
+ PS=18.96u PD=18.96u rfmode=0
M$11282 \$4308 \$4562 VAPWR VAPWR sg13_hv_pmos L=0.5u W=14u AS=2.96p AD=2.96p
+ PS=18.96u PD=18.96u rfmode=0
M$11289 \$1099 \$1459 VAPWR VAPWR sg13_hv_pmos L=0.5u W=14u AS=2.96p AD=2.96p
+ PS=18.96u PD=18.96u rfmode=0
M$11296 \$797 \$797 \$797 VGND sg13_hv_nmos L=0.5u W=0.5u AS=0.17p AD=0.17p
+ PS=1.68u PD=1.68u rfmode=0
M$11297 \$4314 \$4314 \$4314 VGND sg13_hv_nmos L=0.5u W=0.5u AS=0.17p AD=0.17p
+ PS=1.68u PD=1.68u rfmode=0
M$11298 \$2553 \$2553 \$2553 VGND sg13_hv_nmos L=0.5u W=0.5u AS=0.17p AD=0.17p
+ PS=1.68u PD=1.68u rfmode=0
M$11299 \$797 \$1099 VGND VGND sg13_hv_nmos L=0.5u W=0.5u AS=0.17p AD=0.17p
+ PS=1.68u PD=1.68u rfmode=0
M$11300 \$4314 \$4308 VGND VGND sg13_hv_nmos L=0.5u W=0.5u AS=0.17p AD=0.17p
+ PS=1.68u PD=1.68u rfmode=0
M$11301 \$2553 \$2915 VGND VGND sg13_hv_nmos L=0.5u W=0.5u AS=0.17p AD=0.17p
+ PS=1.68u PD=1.68u rfmode=0
M$11305 VGND VGND VGND VAPWR sg13_hv_pmos L=0.5u W=2.1u AS=0.714p AD=0.714p
+ PS=6.24u PD=6.24u rfmode=0
M$11308 VGND \$398 \$1099 VAPWR sg13_hv_pmos L=0.5u W=0.7u AS=0.238p AD=0.238p
+ PS=2.08u PD=2.08u rfmode=0
M$11309 VGND \$4133 \$4308 VAPWR sg13_hv_pmos L=0.5u W=0.7u AS=0.238p AD=0.238p
+ PS=2.08u PD=2.08u rfmode=0
M$11310 VGND \$2048 \$2915 VAPWR sg13_hv_pmos L=0.5u W=0.7u AS=0.238p AD=0.238p
+ PS=2.08u PD=2.08u rfmode=0
M$11314 \$4502 \$4502 \$4502 VGND sg13_hv_nmos L=0.5u W=2u AS=0.68p AD=0.68p
+ PS=5.36u PD=5.36u rfmode=0
M$11315 \$3033 \$3033 \$3033 VGND sg13_hv_nmos L=0.5u W=2u AS=0.68p AD=0.68p
+ PS=5.36u PD=5.36u rfmode=0
M$11316 \$1271 \$1271 \$1271 VGND sg13_hv_nmos L=0.5u W=2u AS=0.68p AD=0.68p
+ PS=5.36u PD=5.36u rfmode=0
M$11320 \$4308 VAPWR \$4502 VGND sg13_hv_nmos L=0.5u W=2u AS=0.53p AD=0.53p
+ PS=4.06u PD=4.06u rfmode=0
M$11322 \$2915 VAPWR \$3033 VGND sg13_hv_nmos L=0.5u W=2u AS=0.53p AD=0.53p
+ PS=4.06u PD=4.06u rfmode=0
M$11324 \$1099 VAPWR \$1271 VGND sg13_hv_nmos L=0.5u W=2u AS=0.53p AD=0.53p
+ PS=4.06u PD=4.06u rfmode=0
M$11332 \$1271 analog_2 VGND VGND sg13_hv_nmos L=0.5u W=18u AS=3.57p AD=3.57p
+ PS=26.14u PD=26.14u rfmode=0
M$11350 \$4502 \$3500 VGND VGND sg13_hv_nmos L=0.5u W=18u AS=3.57p AD=3.57p
+ PS=26.14u PD=26.14u rfmode=0
M$11368 \$3033 \$1648 VGND VGND sg13_hv_nmos L=0.5u W=18u AS=3.57p AD=3.57p
+ PS=26.14u PD=26.14u rfmode=0
M$11386 \$944 \$944 \$944 VGND sg13_hv_nmos L=0.5u W=1u AS=0.34p AD=0.34p
+ PS=2.68u PD=2.68u rfmode=0
M$11387 \$2787 \$2787 \$2787 VGND sg13_hv_nmos L=0.5u W=1u AS=0.34p AD=0.34p
+ PS=2.68u PD=2.68u rfmode=0
M$11388 \$4404 \$4404 \$4404 VGND sg13_hv_nmos L=0.5u W=1u AS=0.34p AD=0.34p
+ PS=2.68u PD=2.68u rfmode=0
M$11392 \$944 \$944 VGND VGND sg13_hv_nmos L=0.5u W=2u AS=0.53p AD=0.53p
+ PS=4.06u PD=4.06u rfmode=0
M$11394 \$2787 \$2787 VGND VGND sg13_hv_nmos L=0.5u W=2u AS=0.53p AD=0.53p
+ PS=4.06u PD=4.06u rfmode=0
M$11396 \$4404 \$4404 VGND VGND sg13_hv_nmos L=0.5u W=2u AS=0.53p AD=0.53p
+ PS=4.06u PD=4.06u rfmode=0
M$11398 VAPWR VAPWR VAPWR VGND sg13_hv_nmos L=0.5u W=4.5u AS=1.53p AD=1.53p
+ PS=11.04u PD=11.04u rfmode=0
M$11401 VAPWR \$4314 \$4133 VGND sg13_hv_nmos L=0.5u W=1.5u AS=0.51p AD=0.51p
+ PS=3.68u PD=3.68u rfmode=0
M$11402 VAPWR \$2553 \$2048 VGND sg13_hv_nmos L=0.5u W=1.5u AS=0.51p AD=0.51p
+ PS=3.68u PD=3.68u rfmode=0
M$11403 VAPWR \$797 \$398 VGND sg13_hv_nmos L=0.5u W=1.5u AS=0.51p AD=0.51p
+ PS=3.68u PD=3.68u rfmode=0
M$11404 \$4133 \$4133 \$4133 VGND sg13_hv_nmos L=0.5u W=3.5u AS=1.19p AD=1.19p
+ PS=8.36u PD=8.36u rfmode=0
M$11405 \$2048 \$2048 \$2048 VGND sg13_hv_nmos L=0.5u W=3.5u AS=1.19p AD=1.19p
+ PS=8.36u PD=8.36u rfmode=0
M$11406 \$398 \$398 \$398 VGND sg13_hv_nmos L=0.5u W=3.5u AS=1.19p AD=1.19p
+ PS=8.36u PD=8.36u rfmode=0
M$11410 \$255 \$255 \$255 VGND sg13_hv_nmos L=0.5u W=2u AS=0.68p AD=0.68p
+ PS=4.68u PD=4.68u rfmode=0
M$11411 \$4022 \$4022 \$4022 VGND sg13_hv_nmos L=0.5u W=2u AS=0.68p AD=0.68p
+ PS=4.68u PD=4.68u rfmode=0
M$11412 \$1925 \$1925 \$1925 VGND sg13_hv_nmos L=0.5u W=2u AS=0.68p AD=0.68p
+ PS=4.68u PD=4.68u rfmode=0
M$11413 \$255 \$255 VGND VGND sg13_hv_nmos L=0.5u W=10u AS=2.2p AD=2.2p
+ PS=14.2u PD=14.2u rfmode=0
M$11418 \$4022 \$4022 VGND VGND sg13_hv_nmos L=0.5u W=10u AS=2.2p AD=2.2p
+ PS=14.2u PD=14.2u rfmode=0
M$11423 \$1925 \$1925 VGND VGND sg13_hv_nmos L=0.5u W=10u AS=2.2p AD=2.2p
+ PS=14.2u PD=14.2u rfmode=0
M$11434 \$398 \$255 VGND VGND sg13_hv_nmos L=0.5u W=10u AS=2.2p AD=2.2p
+ PS=14.2u PD=14.2u rfmode=0
M$11439 \$2048 \$1925 VGND VGND sg13_hv_nmos L=0.5u W=10u AS=2.2p AD=2.2p
+ PS=14.2u PD=14.2u rfmode=0
M$11444 \$4133 \$4022 VGND VGND sg13_hv_nmos L=0.5u W=10u AS=2.2p AD=2.2p
+ PS=14.2u PD=14.2u rfmode=0
M$11450 \$2247 \$2131 VAPWR VAPWR sg13_hv_pmos L=4u W=2u AS=0.68p AD=0.68p
+ PS=4.68u PD=4.68u rfmode=0
M$11451 \$2247 \$2247 \$2247 VAPWR sg13_hv_pmos L=4u W=2u AS=0.68p AD=0.68p
+ PS=4.68u PD=4.68u rfmode=0
M$11455 \$2553 \$2553 \$2553 VAPWR sg13_hv_pmos L=0.5u W=2u AS=0.68p AD=0.68p
+ PS=4.68u PD=4.68u rfmode=0
M$11456 \$4314 \$4314 \$4314 VAPWR sg13_hv_pmos L=0.5u W=2u AS=0.68p AD=0.68p
+ PS=4.68u PD=4.68u rfmode=0
M$11457 \$797 \$797 \$797 VAPWR sg13_hv_pmos L=0.5u W=2u AS=0.68p AD=0.68p
+ PS=4.68u PD=4.68u rfmode=0
M$11458 \$2553 \$2045 VAPWR VAPWR sg13_hv_pmos L=0.5u W=14u AS=2.96p AD=2.96p
+ PS=18.96u PD=18.96u rfmode=0
M$11465 \$4314 \$4021 VAPWR VAPWR sg13_hv_pmos L=0.5u W=14u AS=2.96p AD=2.96p
+ PS=18.96u PD=18.96u rfmode=0
M$11472 \$797 \$254 VAPWR VAPWR sg13_hv_pmos L=0.5u W=14u AS=2.96p AD=2.96p
+ PS=18.96u PD=18.96u rfmode=0
M$11479 \$4021 \$4021 \$4021 VAPWR sg13_hv_pmos L=0.5u W=2u AS=0.68p AD=0.68p
+ PS=4.68u PD=4.68u rfmode=0
M$11480 \$2045 \$2045 \$2045 VAPWR sg13_hv_pmos L=0.5u W=2u AS=0.68p AD=0.68p
+ PS=4.68u PD=4.68u rfmode=0
M$11481 \$254 \$254 \$254 VAPWR sg13_hv_pmos L=0.5u W=2u AS=0.68p AD=0.68p
+ PS=4.68u PD=4.68u rfmode=0
M$11485 \$4021 \$4021 VAPWR VAPWR sg13_hv_pmos L=0.5u W=14u AS=2.96p AD=2.96p
+ PS=18.96u PD=18.96u rfmode=0
M$11492 \$2045 \$2045 VAPWR VAPWR sg13_hv_pmos L=0.5u W=14u AS=2.96p AD=2.96p
+ PS=18.96u PD=18.96u rfmode=0
M$11499 \$254 \$254 VAPWR VAPWR sg13_hv_pmos L=0.5u W=14u AS=2.96p AD=2.96p
+ PS=18.96u PD=18.96u rfmode=0
M$11507 q2 \$2247 VGND VGND sg13_hv_nmos L=4u W=2u AS=0.68p AD=0.68p PS=4.68u
+ PD=4.68u rfmode=0
M$11508 q2 q2 q2 VGND sg13_hv_nmos L=4u W=2u AS=0.68p AD=0.68p PS=4.68u
+ PD=4.68u rfmode=0
M$11509 \$2038 \$2038 \$2038 VGND sg13_hv_nmos L=4u W=2u AS=0.68p AD=0.68p
+ PS=4.68u PD=4.68u rfmode=0
M$11510 \$2247 \$2131 \$2038 VGND sg13_hv_nmos L=4u W=2u AS=0.68p AD=0.68p
+ PS=4.68u PD=4.68u rfmode=0
M$11511 \$2247 \$2247 \$2247 VGND sg13_hv_nmos L=4u W=2u AS=0.68p AD=0.68p
+ PS=4.68u PD=4.68u rfmode=0
M$11513 q2 \$2247 VPWR VPWR sg13_hv_pmos L=4u W=2u AS=0.68p AD=0.68p PS=4.68u
+ PD=4.68u rfmode=0
M$11514 q2 q2 q2 VPWR sg13_hv_pmos L=4u W=2u AS=0.68p AD=0.68p PS=4.68u
+ PD=4.68u rfmode=0
M$11519 \$2134 \$2043 VAPWR VAPWR sg13_hv_pmos L=0.5u W=4u AS=1.36p AD=1.36p
+ PS=8.68u PD=8.68u rfmode=0
M$11520 \$1372 \$1267 VAPWR VAPWR sg13_hv_pmos L=0.5u W=4u AS=1.36p AD=1.36p
+ PS=8.68u PD=8.68u rfmode=0
M$11521 \$3131 \$3030 VAPWR VAPWR sg13_hv_pmos L=0.5u W=4u AS=1.36p AD=1.36p
+ PS=8.68u PD=8.68u rfmode=0
M$11522 \$313 \$252 VAPWR VAPWR sg13_hv_pmos L=0.5u W=4u AS=1.36p AD=1.36p
+ PS=8.68u PD=8.68u rfmode=0
.ENDS heichips26_ook_top

.SUBCKT sg13cmos5l_or4_1 VDD VSS B D A C X
M$1 VSS D \$7 VSS sg13_lv_nmos L=0.13u W=0.55u AS=0.187p AD=0.1045p PS=1.78u
+ PD=0.93u rfmode=0
M$2 VSS C \$7 VSS sg13_lv_nmos L=0.13u W=0.55u AS=0.16755p AD=0.1045p PS=1.165u
+ PD=0.93u rfmode=0
M$3 VSS B \$7 VSS sg13_lv_nmos L=0.13u W=0.55u AS=0.16755p AD=0.1045p PS=1.165u
+ PD=0.93u rfmode=0
M$4 VSS A \$7 VSS sg13_lv_nmos L=0.13u W=0.55u AS=0.14135p AD=0.1045p PS=1.14u
+ PD=0.93u rfmode=0
M$5 VSS \$7 X VSS sg13_lv_nmos L=0.13u W=0.74u AS=0.14135p AD=0.2516p PS=1.14u
+ PD=2.16u rfmode=0
M$6 \$7 D \$11 VDD sg13_lv_pmos L=0.13u W=1u AS=0.34p AD=0.19p PS=2.68u
+ PD=1.38u rfmode=0
M$7 \$11 C \$10 VDD sg13_lv_pmos L=0.13u W=1u AS=0.19p AD=0.2925p PS=1.38u
+ PD=1.585u rfmode=0
M$8 \$10 B \$9 VDD sg13_lv_pmos L=0.13u W=1u AS=0.2925p AD=0.19p PS=1.585u
+ PD=1.38u rfmode=0
M$9 VDD A \$9 VDD sg13_lv_pmos L=0.13u W=1u AS=0.2144p AD=0.19p PS=1.52u
+ PD=1.38u rfmode=0
M$10 VDD \$7 X VDD sg13_lv_pmos L=0.13u W=1.12u AS=0.2144p AD=0.3808p PS=1.52u
+ PD=2.92u rfmode=0
.ENDS sg13cmos5l_or4_1

.SUBCKT sg13cmos5l_tielo L_LO VDD VSS
M$1 VSS \$5 \$4 VSS sg13_lv_nmos L=0.13u W=0.385u AS=0.305425p AD=0.1309p
+ PS=2.07u PD=1.45u rfmode=0
M$2 VSS \$1 L_LO VSS sg13_lv_nmos L=0.13u W=0.88u AS=0.305425p AD=0.2992p
+ PS=2.07u PD=2.44u rfmode=0
M$3 VDD \$5 \$5 VDD sg13_lv_pmos L=0.13u W=0.3u AS=0.326925p AD=0.102p
+ PS=2.255u PD=1.28u rfmode=0
M$4 VDD \$4 \$1 VDD sg13_lv_pmos L=0.13u W=1.045u AS=0.326925p AD=0.3553p
+ PS=2.255u PD=2.77u rfmode=0
.ENDS sg13cmos5l_tielo

.SUBCKT sg13cmos5l_nand4_1 VDD A VSS Y B C D
M$1 VSS D \$10 VSS sg13_lv_nmos L=0.13u W=0.74u AS=0.2516p AD=0.1406p PS=2.16u
+ PD=1.12u rfmode=0
M$2 \$10 C \$9 VSS sg13_lv_nmos L=0.13u W=0.74u AS=0.1406p AD=0.1406p PS=1.12u
+ PD=1.12u rfmode=0
M$3 \$9 B \$8 VSS sg13_lv_nmos L=0.13u W=0.74u AS=0.1406p AD=0.1406p PS=1.12u
+ PD=1.12u rfmode=0
M$4 \$8 A Y VSS sg13_lv_nmos L=0.13u W=0.74u AS=0.1406p AD=0.2516p PS=1.12u
+ PD=2.16u rfmode=0
M$5 VDD D Y VDD sg13_lv_pmos L=0.13u W=1.12u AS=0.3808p AD=0.2128p PS=2.92u
+ PD=1.5u rfmode=0
M$6 Y C VDD VDD sg13_lv_pmos L=0.13u W=1.12u AS=0.2128p AD=0.2128p PS=1.5u
+ PD=1.5u rfmode=0
M$7 VDD B Y VDD sg13_lv_pmos L=0.13u W=1.12u AS=0.2128p AD=0.2128p PS=1.5u
+ PD=1.5u rfmode=0
M$8 Y A VDD VDD sg13_lv_pmos L=0.13u W=1.12u AS=0.2128p AD=0.3808p PS=1.5u
+ PD=2.92u rfmode=0
.ENDS sg13cmos5l_nand4_1

.SUBCKT sg13cmos5l_mux2_1 VSS X S A1 A0 VDD
M$1 VSS S \$2 VSS sg13_lv_nmos L=0.13u W=0.55u AS=0.18945p AD=0.187p PS=1.27u
+ PD=1.78u rfmode=0
M$2 VSS S \$8 VSS sg13_lv_nmos L=0.13u W=0.74u AS=0.18945p AD=0.13135p PS=1.27u
+ PD=1.095u rfmode=0
M$3 \$8 A1 \$3 VSS sg13_lv_nmos L=0.13u W=0.74u AS=0.13135p AD=0.1628p
+ PS=1.095u PD=1.18u rfmode=0
M$4 \$3 A0 \$9 VSS sg13_lv_nmos L=0.13u W=0.74u AS=0.1628p AD=0.3367p PS=1.18u
+ PD=1.65u rfmode=0
M$5 \$9 \$2 VSS VSS sg13_lv_nmos L=0.13u W=0.74u AS=0.3367p AD=0.148p PS=1.65u
+ PD=1.14u rfmode=0
M$6 VSS \$3 X VSS sg13_lv_nmos L=0.13u W=0.74u AS=0.148p AD=0.4033p PS=1.14u
+ PD=2.57u rfmode=0
M$7 \$2 S VDD VDD sg13_lv_pmos L=0.13u W=0.84u AS=0.2856p AD=0.253p PS=2.36u
+ PD=1.53u rfmode=0
M$8 VDD S \$10 VDD sg13_lv_pmos L=0.13u W=1u AS=0.253p AD=0.3325p PS=1.53u
+ PD=1.665u rfmode=0
M$9 \$10 A0 \$3 VDD sg13_lv_pmos L=0.13u W=1u AS=0.3325p AD=0.2225p PS=1.665u
+ PD=1.445u rfmode=0
M$10 \$3 A1 \$11 VDD sg13_lv_pmos L=0.13u W=1u AS=0.2225p AD=0.2975p PS=1.445u
+ PD=1.595u rfmode=0
M$11 \$11 \$2 VDD VDD sg13_lv_pmos L=0.13u W=1u AS=0.2975p AD=0.2198p PS=1.595u
+ PD=1.52u rfmode=0
M$12 VDD \$3 X VDD sg13_lv_pmos L=0.13u W=1.12u AS=0.2198p AD=0.6048p PS=1.52u
+ PD=3.32u rfmode=0
.ENDS sg13cmos5l_mux2_1

.SUBCKT sg13cmos5l_nand3_1 VDD VSS Y B C A
M$1 VSS C \$8 VSS sg13_lv_nmos L=0.13u W=0.74u AS=0.2886p AD=0.1406p PS=2.26u
+ PD=1.12u rfmode=0
M$2 \$8 B \$7 VSS sg13_lv_nmos L=0.13u W=0.74u AS=0.1406p AD=0.1406p PS=1.12u
+ PD=1.12u rfmode=0
M$3 \$7 A Y VSS sg13_lv_nmos L=0.13u W=0.74u AS=0.1406p AD=0.2516p PS=1.12u
+ PD=2.16u rfmode=0
M$4 VDD C Y VDD sg13_lv_pmos L=0.13u W=1.12u AS=0.3808p AD=0.2128p PS=2.92u
+ PD=1.5u rfmode=0
M$5 Y B VDD VDD sg13_lv_pmos L=0.13u W=1.12u AS=0.2128p AD=0.2128p PS=1.5u
+ PD=1.5u rfmode=0
M$6 VDD A Y VDD sg13_lv_pmos L=0.13u W=1.12u AS=0.2128p AD=0.3808p PS=1.5u
+ PD=2.92u rfmode=0
.ENDS sg13cmos5l_nand3_1

.SUBCKT sg13cmos5l_nor4_1 VDD VSS B A C D Y
M$1 VSS A Y VSS sg13_lv_nmos L=0.13u W=0.74u AS=0.2516p AD=0.1406p PS=2.16u
+ PD=1.12u rfmode=0
M$2 Y B VSS VSS sg13_lv_nmos L=0.13u W=0.74u AS=0.1406p AD=0.1406p PS=1.12u
+ PD=1.12u rfmode=0
M$3 VSS C Y VSS sg13_lv_nmos L=0.13u W=0.74u AS=0.1406p AD=0.1406p PS=1.12u
+ PD=1.12u rfmode=0
M$4 Y D VSS VSS sg13_lv_nmos L=0.13u W=0.74u AS=0.1406p AD=0.237575p PS=1.12u
+ PD=2.16u rfmode=0
M$5 VDD A \$9 VDD sg13_lv_pmos L=0.13u W=1.12u AS=0.3808p AD=0.2128p PS=2.92u
+ PD=1.5u rfmode=0
M$6 \$9 B \$8 VDD sg13_lv_pmos L=0.13u W=1.12u AS=0.2128p AD=0.2128p PS=1.5u
+ PD=1.5u rfmode=0
M$7 \$8 C \$10 VDD sg13_lv_pmos L=0.13u W=1.12u AS=0.2128p AD=0.2128p PS=1.5u
+ PD=1.5u rfmode=0
M$8 \$10 D Y VDD sg13_lv_pmos L=0.13u W=1.12u AS=0.2128p AD=0.4368p PS=1.5u
+ PD=3.02u rfmode=0
.ENDS sg13cmos5l_nor4_1

.SUBCKT sg13cmos5l_or2_1 A X B VDD VSS
M$1 VSS B \$6 VSS sg13_lv_nmos L=0.13u W=0.55u AS=0.187p AD=0.1045p PS=1.78u
+ PD=0.93u rfmode=0
M$2 \$6 A VSS VSS sg13_lv_nmos L=0.13u W=0.55u AS=0.1045p AD=0.1469p PS=0.93u
+ PD=1.155u rfmode=0
M$3 VSS \$6 X VSS sg13_lv_nmos L=0.13u W=0.74u AS=0.1469p AD=0.2516p PS=1.155u
+ PD=2.16u rfmode=0
M$4 \$6 B \$7 VDD sg13_lv_pmos L=0.13u W=0.84u AS=0.2856p AD=0.1596p PS=2.36u
+ PD=1.22u rfmode=0
M$5 VDD A \$7 VDD sg13_lv_pmos L=0.13u W=0.84u AS=0.2226p AD=0.1596p PS=1.535u
+ PD=1.22u rfmode=0
M$6 VDD \$6 X VDD sg13_lv_pmos L=0.13u W=1.12u AS=0.2226p AD=0.3976p PS=1.535u
+ PD=2.95u rfmode=0
.ENDS sg13cmos5l_or2_1

.SUBCKT sg13cmos5l_nor2b_1 VSS VDD Y A B_N
M$1 VSS B_N \$5 VSS sg13_lv_nmos L=0.13u W=0.55u AS=0.17255p AD=0.187p PS=1.25u
+ PD=1.78u rfmode=0
M$2 VSS \$5 Y VSS sg13_lv_nmos L=0.13u W=0.74u AS=0.17255p AD=0.1406p PS=1.25u
+ PD=1.12u rfmode=0
M$3 Y A VSS VSS sg13_lv_nmos L=0.13u W=0.74u AS=0.1406p AD=0.2516p PS=1.12u
+ PD=2.16u rfmode=0
M$4 \$5 B_N VDD VDD sg13_lv_pmos L=0.13u W=0.84u AS=0.2856p AD=0.2618p PS=2.36u
+ PD=1.63u rfmode=0
M$5 VDD \$5 \$7 VDD sg13_lv_pmos L=0.13u W=1.12u AS=0.2618p AD=0.1176p PS=1.63u
+ PD=1.33u rfmode=0
M$6 \$7 A Y VDD sg13_lv_pmos L=0.13u W=1.12u AS=0.1176p AD=0.3808p PS=1.33u
+ PD=2.92u rfmode=0
.ENDS sg13cmos5l_nor2b_1

.SUBCKT sg13cmos5l_and2_1 VDD VSS X A B
M$1 \$4 A \$7 VSS sg13_lv_nmos L=0.13u W=0.64u AS=0.2176p AD=0.1216p PS=1.96u
+ PD=1.02u rfmode=0
M$2 VSS B \$7 VSS sg13_lv_nmos L=0.13u W=0.64u AS=0.1331p AD=0.1216p PS=1.12u
+ PD=1.02u rfmode=0
M$3 VSS \$4 X VSS sg13_lv_nmos L=0.13u W=0.74u AS=0.1331p AD=0.2516p PS=1.12u
+ PD=2.16u rfmode=0
M$4 VDD A \$4 VDD sg13_lv_pmos L=0.13u W=0.84u AS=0.2856p AD=0.1596p PS=2.36u
+ PD=1.22u rfmode=0
M$5 VDD B \$4 VDD sg13_lv_pmos L=0.13u W=0.84u AS=0.1918p AD=0.1596p PS=1.5u
+ PD=1.22u rfmode=0
M$6 VDD \$4 X VDD sg13_lv_pmos L=0.13u W=1.12u AS=0.1918p AD=0.3808p PS=1.5u
+ PD=2.92u rfmode=0
.ENDS sg13cmos5l_and2_1

.SUBCKT sg13cmos5l_nor3_1 VDD VSS C Y B A
M$1 VSS A Y VSS sg13_lv_nmos L=0.13u W=0.77u AS=0.2618p AD=0.1694p PS=2.22u
+ PD=1.21u rfmode=0
M$2 Y B VSS VSS sg13_lv_nmos L=0.13u W=0.77u AS=0.1694p AD=0.1463p PS=1.21u
+ PD=1.15u rfmode=0
M$3 VSS C Y VSS sg13_lv_nmos L=0.13u W=0.77u AS=0.1463p AD=0.2618p PS=1.15u
+ PD=2.22u rfmode=0
M$4 VDD A \$8 VDD sg13_lv_pmos L=0.13u W=1.12u AS=0.3808p AD=0.2464p PS=2.92u
+ PD=1.56u rfmode=0
M$5 \$8 B \$7 VDD sg13_lv_pmos L=0.13u W=1.12u AS=0.2464p AD=0.2128p PS=1.56u
+ PD=1.5u rfmode=0
M$6 \$7 C Y VDD sg13_lv_pmos L=0.13u W=1.12u AS=0.2128p AD=0.3808p PS=1.5u
+ PD=2.92u rfmode=0
.ENDS sg13cmos5l_nor3_1

.SUBCKT sg13cmos5l_buf_8 VSS A X VDD
M$1 \$2 A VSS VSS sg13_lv_nmos L=0.13u W=2.22u AS=0.5365p AD=0.4218p PS=4.41u
+ PD=3.36u rfmode=0
M$4 VSS \$2 X VSS sg13_lv_nmos L=0.13u W=5.92u AS=1.1248p AD=1.2358p PS=8.96u
+ PD=10u rfmode=0
M$12 \$2 A VDD VDD sg13_lv_pmos L=0.13u W=3.36u AS=0.8064p AD=0.6384p PS=5.92u
+ PD=4.5u rfmode=0
M$15 VDD \$2 X VDD sg13_lv_pmos L=0.13u W=8.96u AS=1.7024p AD=1.876p PS=12u
+ PD=13.43u rfmode=0
.ENDS sg13cmos5l_buf_8

.SUBCKT sg13cmos5l_a22oi_1 Y VSS VDD A2 B2 B1 A1
M$1 VSS B1 \$10 VSS sg13_lv_nmos L=0.13u W=0.74u AS=0.2553p AD=0.13875p
+ PS=2.17u PD=1.115u rfmode=0
M$2 \$10 B2 Y VSS sg13_lv_nmos L=0.13u W=0.74u AS=0.13875p AD=0.2664p PS=1.115u
+ PD=1.46u rfmode=0
M$3 Y A1 \$9 VSS sg13_lv_nmos L=0.13u W=0.74u AS=0.2664p AD=0.0962p PS=1.46u
+ PD=1u rfmode=0
M$4 \$9 A2 VSS VSS sg13_lv_nmos L=0.13u W=0.74u AS=0.0962p AD=0.2516p PS=1u
+ PD=2.16u rfmode=0
M$5 VDD A1 \$5 VDD sg13_lv_pmos L=0.13u W=1.12u AS=0.3808p AD=0.2716p PS=2.92u
+ PD=1.605u rfmode=0
M$6 \$5 B1 Y VDD sg13_lv_pmos L=0.13u W=1.12u AS=0.2716p AD=0.2128p PS=1.605u
+ PD=1.5u rfmode=0
M$7 Y B2 \$5 VDD sg13_lv_pmos L=0.13u W=1.12u AS=0.2128p AD=0.2744p PS=1.5u
+ PD=1.61u rfmode=0
M$8 \$5 A2 VDD VDD sg13_lv_pmos L=0.13u W=1.12u AS=0.2744p AD=0.3808p PS=1.61u
+ PD=2.92u rfmode=0
.ENDS sg13cmos5l_a22oi_1

.SUBCKT sg13cmos5l_decap_4 VDD VSS
M$1 VSS VDD VSS VSS sg13_lv_nmos L=1u W=0.42u AS=0.1428p AD=0.1428p PS=1.52u
+ PD=1.52u rfmode=0
M$2 VDD VSS VDD VDD sg13_lv_pmos L=1u W=1u AS=0.34p AD=0.34p PS=2.68u PD=2.68u
+ rfmode=0
.ENDS sg13cmos5l_decap_4

.SUBCKT sg13cmos5l_xnor2_1 VDD VSS Y B A
M$1 VSS A \$8 VSS sg13_lv_nmos L=0.13u W=0.64u AS=0.2272p AD=0.0784p PS=1.99u
+ PD=0.885u rfmode=0
M$2 \$8 B \$7 VSS sg13_lv_nmos L=0.13u W=0.64u AS=0.0784p AD=0.2176p PS=0.885u
+ PD=1.96u rfmode=0
M$3 VSS A \$3 VSS sg13_lv_nmos L=0.13u W=0.74u AS=0.1898p AD=0.2516p PS=1.36u
+ PD=2.16u rfmode=0
M$4 VSS B \$3 VSS sg13_lv_nmos L=0.13u W=0.74u AS=0.1898p AD=0.1406p PS=1.36u
+ PD=1.12u rfmode=0
M$5 \$3 \$7 Y VSS sg13_lv_nmos L=0.13u W=0.74u AS=0.1406p AD=0.2516p PS=1.12u
+ PD=2.16u rfmode=0
M$6 VDD A \$7 VDD sg13_lv_pmos L=0.13u W=0.84u AS=0.4536p AD=0.1596p PS=2.76u
+ PD=1.22u rfmode=0
M$7 VDD B \$7 VDD sg13_lv_pmos L=0.13u W=0.84u AS=0.2891p AD=0.1596p PS=1.695u
+ PD=1.22u rfmode=0
M$8 VDD A \$9 VDD sg13_lv_pmos L=0.13u W=1.12u AS=0.2891p AD=0.1428p PS=1.695u
+ PD=1.375u rfmode=0
M$9 \$9 B Y VDD sg13_lv_pmos L=0.13u W=1.12u AS=0.1428p AD=0.2408p PS=1.375u
+ PD=1.55u rfmode=0
M$10 Y \$7 VDD VDD sg13_lv_pmos L=0.13u W=1.12u AS=0.2408p AD=0.3808p PS=1.55u
+ PD=2.92u rfmode=0
.ENDS sg13cmos5l_xnor2_1

.SUBCKT sg13cmos5l_a221oi_1 VSS B1 VDD Y B2 C1 A1 A2
M$1 Y A1 \$11 VSS sg13_lv_nmos L=0.13u W=0.74u AS=0.2516p AD=0.1406p PS=2.16u
+ PD=1.12u rfmode=0
M$2 \$11 A2 VSS VSS sg13_lv_nmos L=0.13u W=0.74u AS=0.1406p AD=0.2516p PS=1.12u
+ PD=2.16u rfmode=0
M$3 Y C1 VSS VSS sg13_lv_nmos L=0.13u W=0.74u AS=0.2516p AD=0.1406p PS=2.16u
+ PD=1.12u rfmode=0
M$4 VSS B2 \$12 VSS sg13_lv_nmos L=0.13u W=0.74u AS=0.1406p AD=0.1406p PS=1.12u
+ PD=1.12u rfmode=0
M$5 \$12 B1 Y VSS sg13_lv_nmos L=0.13u W=0.74u AS=0.1406p AD=0.2516p PS=1.12u
+ PD=2.16u rfmode=0
M$6 VDD A1 \$9 VDD sg13_lv_pmos L=0.13u W=1.12u AS=0.3808p AD=0.2128p PS=2.92u
+ PD=1.5u rfmode=0
M$7 \$9 A2 VDD VDD sg13_lv_pmos L=0.13u W=1.12u AS=0.2128p AD=0.3808p PS=1.5u
+ PD=2.92u rfmode=0
M$8 Y C1 \$6 VDD sg13_lv_pmos L=0.13u W=1.12u AS=0.3808p AD=0.2128p PS=2.92u
+ PD=1.5u rfmode=0
M$9 \$6 B2 \$9 VDD sg13_lv_pmos L=0.13u W=1.12u AS=0.2128p AD=0.2128p PS=1.5u
+ PD=1.5u rfmode=0
M$10 \$9 B1 \$6 VDD sg13_lv_pmos L=0.13u W=1.12u AS=0.2128p AD=0.3808p PS=1.5u
+ PD=2.92u rfmode=0
.ENDS sg13cmos5l_a221oi_1

.SUBCKT sg13cmos5l_or3_1 VDD VSS C A B X
M$1 \$6 C VSS VSS sg13_lv_nmos L=0.13u W=0.55u AS=0.187p AD=0.1045p PS=1.78u
+ PD=0.93u rfmode=0
M$2 VSS B \$6 VSS sg13_lv_nmos L=0.13u W=0.55u AS=0.1045p AD=0.198p PS=0.93u
+ PD=1.27u rfmode=0
M$3 \$6 A VSS VSS sg13_lv_nmos L=0.13u W=0.55u AS=0.198p AD=0.13395p PS=1.27u
+ PD=1.12u rfmode=0
M$4 VSS \$6 X VSS sg13_lv_nmos L=0.13u W=0.74u AS=0.13395p AD=0.2516p PS=1.12u
+ PD=2.16u rfmode=0
M$5 \$6 C \$9 VDD sg13_lv_pmos L=0.13u W=1u AS=0.34p AD=0.19p PS=2.68u PD=1.38u
+ rfmode=0
M$6 \$9 B \$8 VDD sg13_lv_pmos L=0.13u W=1u AS=0.19p AD=0.1575p PS=1.38u
+ PD=1.315u rfmode=0
M$7 \$8 A VDD VDD sg13_lv_pmos L=0.13u W=1u AS=0.1575p AD=0.3822p PS=1.315u
+ PD=1.84u rfmode=0
M$8 VDD \$6 X VDD sg13_lv_pmos L=0.13u W=1.12u AS=0.3822p AD=0.3808p PS=1.84u
+ PD=2.92u rfmode=0
.ENDS sg13cmos5l_or3_1

.SUBCKT sg13cmos5l_decap_8 VDD VSS
M$1 VSS VDD VSS VSS sg13_lv_nmos L=1u W=0.84u AS=0.2226p AD=0.2226p PS=2.32u
+ PD=2.32u rfmode=0
M$3 VDD VSS VDD VDD sg13_lv_pmos L=1u W=2u AS=0.53p AD=0.53p PS=4.06u PD=4.06u
+ rfmode=0
.ENDS sg13cmos5l_decap_8

.SUBCKT sg13cmos5l_nand2_1 VDD VSS Y A B
M$1 VSS B \$6 VSS sg13_lv_nmos L=0.13u W=0.74u AS=0.2516p AD=0.1406p PS=2.16u
+ PD=1.12u rfmode=0
M$2 \$6 A Y VSS sg13_lv_nmos L=0.13u W=0.74u AS=0.1406p AD=0.2516p PS=1.12u
+ PD=2.16u rfmode=0
M$3 VDD B Y VDD sg13_lv_pmos L=0.13u W=1.12u AS=0.3808p AD=0.2128p PS=2.92u
+ PD=1.5u rfmode=0
M$4 Y A VDD VDD sg13_lv_pmos L=0.13u W=1.12u AS=0.2128p AD=0.3808p PS=1.5u
+ PD=2.92u rfmode=0
.ENDS sg13cmos5l_nand2_1

.SUBCKT sg13cmos5l_tiehi L_HI VDD VSS
M$1 VSS \$5 \$5 VSS sg13_lv_nmos L=0.13u W=0.3u AS=0.2043375p AD=0.111p
+ PS=1.585u PD=1.34u rfmode=0
M$2 VSS \$3 \$1 VSS sg13_lv_nmos L=0.13u W=0.795u AS=0.2043375p AD=0.274275p
+ PS=1.585u PD=2.28u rfmode=0
M$3 \$3 \$5 VDD VDD sg13_lv_pmos L=0.13u W=0.66u AS=0.2442p AD=0.4657125p
+ PS=2.06u PD=2.54u rfmode=0
M$4 VDD \$1 L_HI VDD sg13_lv_pmos L=0.13u W=1.155u AS=0.4657125p AD=0.3927p
+ PS=2.54u PD=2.99u rfmode=0
.ENDS sg13cmos5l_tiehi

.SUBCKT sg13cmos5l_dfrbpq_1 VSS RESET_B Q D CLK VDD
M$1 VSS \$4 \$19 VSS sg13_lv_nmos L=0.13u W=0.74u AS=0.317325p AD=0.2516p
+ PS=1.805u PD=2.16u rfmode=0
M$2 VSS CLK \$4 VSS sg13_lv_nmos L=0.13u W=0.74u AS=0.317325p AD=0.2516p
+ PS=1.805u PD=2.16u rfmode=0
M$3 \$14 \$4 \$7 VSS sg13_lv_nmos L=0.13u W=0.42u AS=0.12665p AD=0.1428p
+ PS=1.145u PD=1.52u rfmode=0
M$4 \$3 \$19 \$14 VSS sg13_lv_nmos L=0.13u W=0.74u AS=0.3473p AD=0.12665p
+ PS=2.71u PD=1.145u rfmode=0
M$5 \$5 D \$15 VSS sg13_lv_nmos L=0.13u W=0.42u AS=0.1428p AD=0.0609p PS=1.52u
+ PD=0.71u rfmode=0
M$6 \$15 RESET_B VSS VSS sg13_lv_nmos L=0.13u W=0.42u AS=0.0609p AD=0.1626p
+ PS=0.71u PD=1.415u rfmode=0
M$7 VSS \$12 \$3 VSS sg13_lv_nmos L=0.13u W=0.74u AS=0.1626p AD=0.2516p
+ PS=1.415u PD=2.16u rfmode=0
M$8 \$9 \$14 VSS VSS sg13_lv_nmos L=0.13u W=0.74u AS=0.2516p AD=0.1406p
+ PS=2.16u PD=1.12u rfmode=0
M$9 VSS \$9 Q VSS sg13_lv_nmos L=0.13u W=0.74u AS=0.1406p AD=0.2516p PS=1.12u
+ PD=2.16u rfmode=0
M$10 \$5 \$4 \$12 VSS sg13_lv_nmos L=0.13u W=0.42u AS=0.1296p AD=0.0798p
+ PS=1.52u PD=0.8u rfmode=0
M$11 \$12 \$19 \$6 VSS sg13_lv_nmos L=0.13u W=0.42u AS=0.0798p AD=0.2373p
+ PS=0.8u PD=1.97u rfmode=0
M$12 \$7 \$8 VSS VSS sg13_lv_nmos L=0.13u W=0.42u AS=0.1428p AD=0.0798p
+ PS=1.52u PD=0.8u rfmode=0
M$13 VSS RESET_B \$17 VSS sg13_lv_nmos L=0.13u W=0.42u AS=0.0798p AD=0.0378p
+ PS=0.8u PD=0.6u rfmode=0
M$14 \$17 \$14 \$8 VSS sg13_lv_nmos L=0.13u W=0.42u AS=0.0378p AD=0.1428p
+ PS=0.6u PD=1.52u rfmode=0
M$15 VSS RESET_B \$16 VSS sg13_lv_nmos L=0.13u W=0.42u AS=0.1701p AD=0.0378p
+ PS=1.65u PD=0.6u rfmode=0
M$16 \$16 \$3 \$6 VSS sg13_lv_nmos L=0.13u W=0.42u AS=0.0378p AD=0.1428p
+ PS=0.6u PD=1.52u rfmode=0
M$17 \$14 \$19 \$21 VDD sg13_lv_pmos L=0.13u W=0.42u AS=0.2048p AD=0.09345p
+ PS=1.63u PD=0.865u rfmode=0
M$18 \$21 \$8 VDD VDD sg13_lv_pmos L=0.13u W=0.42u AS=0.09345p AD=0.204p
+ PS=0.865u PD=1.835u rfmode=0
M$19 VDD RESET_B \$8 VDD sg13_lv_pmos L=0.13u W=0.42u AS=0.204p AD=0.0798p
+ PS=1.835u PD=0.8u rfmode=0
M$20 \$8 \$14 VDD VDD sg13_lv_pmos L=0.13u W=0.42u AS=0.0798p AD=0.4659p
+ PS=0.8u PD=3.65u rfmode=0
M$21 \$3 \$4 \$14 VDD sg13_lv_pmos L=0.13u W=1u AS=0.34p AD=0.2048p PS=2.68u
+ PD=1.63u rfmode=0
M$22 \$9 \$14 VDD VDD sg13_lv_pmos L=0.13u W=1.12u AS=0.3864p AD=0.2128p
+ PS=2.93u PD=1.5u rfmode=0
M$23 VDD \$9 Q VDD sg13_lv_pmos L=0.13u W=1.12u AS=0.2128p AD=0.3808p PS=1.5u
+ PD=2.92u rfmode=0
M$24 VDD D \$5 VDD sg13_lv_pmos L=0.13u W=0.42u AS=0.1428p AD=0.0798p PS=1.52u
+ PD=0.8u rfmode=0
M$25 VDD RESET_B \$5 VDD sg13_lv_pmos L=0.13u W=0.42u AS=0.3623875p AD=0.0798p
+ PS=2.605u PD=0.8u rfmode=0
M$26 VDD \$12 \$3 VDD sg13_lv_pmos L=0.13u W=1u AS=0.3623875p AD=0.34p
+ PS=2.605u PD=2.68u rfmode=0
M$27 \$19 \$4 VDD VDD sg13_lv_pmos L=0.13u W=1.12u AS=0.3864p AD=0.41165p
+ PS=2.93u PD=2.12u rfmode=0
M$28 VDD CLK \$4 VDD sg13_lv_pmos L=0.13u W=1.12u AS=0.41165p AD=0.4088p
+ PS=2.12u PD=2.97u rfmode=0
M$29 \$12 RESET_B VDD VDD sg13_lv_pmos L=0.13u W=0.42u AS=0.147p AD=0.1563p
+ PS=1.54u PD=1.22u rfmode=0
M$30 VDD \$3 \$20 VDD sg13_lv_pmos L=0.13u W=0.42u AS=0.1563p AD=0.063p
+ PS=1.22u PD=0.72u rfmode=0
M$31 \$20 \$4 \$12 VDD sg13_lv_pmos L=0.13u W=0.42u AS=0.063p AD=0.0798p
+ PS=0.72u PD=0.8u rfmode=0
M$32 \$12 \$19 \$5 VDD sg13_lv_pmos L=0.13u W=0.42u AS=0.0798p AD=0.1428p
+ PS=0.8u PD=1.52u rfmode=0
.ENDS sg13cmos5l_dfrbpq_1

.SUBCKT sg13cmos5l_o21ai_1 VSS Y VDD B1 A2 A1
M$1 \$2 A1 VSS VSS sg13_lv_nmos L=0.15u W=0.74u AS=0.2516p AD=0.1406p PS=2.16u
+ PD=1.12u rfmode=0
M$2 VSS A2 \$2 VSS sg13_lv_nmos L=0.15u W=0.74u AS=0.1406p AD=0.1406p PS=1.12u
+ PD=1.12u rfmode=0
M$3 \$2 B1 Y VSS sg13_lv_nmos L=0.15u W=0.74u AS=0.1406p AD=0.2516p PS=1.12u
+ PD=2.16u rfmode=0
M$4 VDD A1 \$8 VDD sg13_lv_pmos L=0.15u W=1.12u AS=0.3808p AD=0.2128p PS=2.92u
+ PD=1.5u rfmode=0
M$5 \$8 A2 Y VDD sg13_lv_pmos L=0.15u W=1.12u AS=0.2128p AD=0.2128p PS=1.5u
+ PD=1.5u rfmode=0
M$6 Y B1 VDD VDD sg13_lv_pmos L=0.15u W=1.12u AS=0.2128p AD=0.3808p PS=1.5u
+ PD=2.92u rfmode=0
.ENDS sg13cmos5l_o21ai_1

.SUBCKT sg13cmos5l_nand3b_1 VDD VSS Y B C A_N
M$1 VSS A_N \$6 VSS sg13_lv_nmos L=0.13u W=0.55u AS=0.18575p AD=0.187p PS=1.26u
+ PD=1.78u rfmode=0
M$2 VSS C \$9 VSS sg13_lv_nmos L=0.13u W=0.74u AS=0.18575p AD=0.1406p PS=1.26u
+ PD=1.12u rfmode=0
M$3 \$9 B \$8 VSS sg13_lv_nmos L=0.13u W=0.74u AS=0.1406p AD=0.1406p PS=1.12u
+ PD=1.12u rfmode=0
M$4 \$8 \$6 Y VSS sg13_lv_nmos L=0.13u W=0.74u AS=0.1406p AD=0.3404p PS=1.12u
+ PD=2.4u rfmode=0
M$5 \$6 A_N VDD VDD sg13_lv_pmos L=0.13u W=0.84u AS=0.2856p AD=0.2198p PS=2.36u
+ PD=1.53u rfmode=0
M$6 VDD C Y VDD sg13_lv_pmos L=0.13u W=1.12u AS=0.2198p AD=0.2128p PS=1.53u
+ PD=1.5u rfmode=0
M$7 Y B VDD VDD sg13_lv_pmos L=0.13u W=1.12u AS=0.2128p AD=0.2128p PS=1.5u
+ PD=1.5u rfmode=0
M$8 VDD \$6 Y VDD sg13_lv_pmos L=0.13u W=1.12u AS=0.2128p AD=0.3808p PS=1.5u
+ PD=2.92u rfmode=0
.ENDS sg13cmos5l_nand3b_1

.SUBCKT sg13cmos5l_inv_1 VDD VSS A Y
M$1 VSS A Y VSS sg13_lv_nmos L=0.13u W=0.74u AS=0.2516p AD=0.2516p PS=2.16u
+ PD=2.16u rfmode=0
M$2 VDD A Y VDD sg13_lv_pmos L=0.13u W=1.12u AS=0.3808p AD=0.3808p PS=2.92u
+ PD=2.92u rfmode=0
.ENDS sg13cmos5l_inv_1

.SUBCKT sg13cmos5l_nor2_1 VDD VSS B A Y
M$1 VSS A Y VSS sg13_lv_nmos L=0.13u W=0.74u AS=0.2516p AD=0.1406p PS=2.16u
+ PD=1.12u rfmode=0
M$2 Y B VSS VSS sg13_lv_nmos L=0.13u W=0.74u AS=0.1406p AD=0.2516p PS=1.12u
+ PD=2.16u rfmode=0
M$3 VDD A \$6 VDD sg13_lv_pmos L=0.13u W=1.12u AS=0.4032p AD=0.1176p PS=2.96u
+ PD=1.33u rfmode=0
M$4 \$6 B Y VDD sg13_lv_pmos L=0.13u W=1.12u AS=0.1176p AD=0.3808p PS=1.33u
+ PD=2.92u rfmode=0
.ENDS sg13cmos5l_nor2_1

.SUBCKT sg13cmos5l_dlygate4sd3_1 VDD VSS X A
M$1 VSS \$5 \$4 VSS sg13_lv_nmos L=0.5u W=0.42u AS=0.1426p AD=0.1428p PS=1.16u
+ PD=1.52u rfmode=0
M$2 VSS \$4 X VSS sg13_lv_nmos L=0.13u W=0.74u AS=0.1426p AD=0.2516p PS=1.16u
+ PD=2.16u rfmode=0
M$3 \$6 A VSS VSS sg13_lv_nmos L=0.13u W=0.42u AS=0.1428p AD=0.0798p PS=1.52u
+ PD=0.8u rfmode=0
M$4 VSS \$6 \$5 VSS sg13_lv_nmos L=0.5u W=0.42u AS=0.0798p AD=0.1428p PS=0.8u
+ PD=1.52u rfmode=0
M$5 \$4 \$5 VDD VDD sg13_lv_pmos L=0.5u W=1u AS=0.34p AD=0.2254p PS=2.68u
+ PD=1.53u rfmode=0
M$6 VDD \$4 X VDD sg13_lv_pmos L=0.13u W=1.12u AS=0.2254p AD=0.4256p PS=1.53u
+ PD=3u rfmode=0
M$7 VDD A \$6 VDD sg13_lv_pmos L=0.13u W=0.42u AS=0.1523p AD=0.1428p PS=1.38u
+ PD=1.52u rfmode=0
M$8 VDD \$6 \$5 VDD sg13_lv_pmos L=0.5u W=1u AS=0.1523p AD=0.34p PS=1.38u
+ PD=2.68u rfmode=0
.ENDS sg13cmos5l_dlygate4sd3_1

.SUBCKT sg13cmos5l_and3_1 VDD VSS A C B X
M$1 \$7 A \$9 VSS sg13_lv_nmos L=0.13u W=0.64u AS=0.2176p AD=0.1216p PS=1.96u
+ PD=1.02u rfmode=0
M$2 \$9 B \$8 VSS sg13_lv_nmos L=0.13u W=0.64u AS=0.1216p AD=0.1216p PS=1.02u
+ PD=1.02u rfmode=0
M$3 VSS C \$8 VSS sg13_lv_nmos L=0.13u W=0.64u AS=0.1371p AD=0.1216p PS=1.12u
+ PD=1.02u rfmode=0
M$4 VSS \$7 X VSS sg13_lv_nmos L=0.13u W=0.74u AS=0.1371p AD=0.2516p PS=1.12u
+ PD=2.16u rfmode=0
M$5 \$7 A VDD VDD sg13_lv_pmos L=0.13u W=0.84u AS=0.2856p AD=0.1596p PS=2.36u
+ PD=1.22u rfmode=0
M$6 VDD B \$7 VDD sg13_lv_pmos L=0.13u W=0.84u AS=0.1596p AD=0.1596p PS=1.22u
+ PD=1.22u rfmode=0
M$7 VDD C \$7 VDD sg13_lv_pmos L=0.13u W=0.84u AS=0.36195p AD=0.1596p PS=1.84u
+ PD=1.22u rfmode=0
M$8 VDD \$7 X VDD sg13_lv_pmos L=0.13u W=1.12u AS=0.36195p AD=0.3808p PS=1.84u
+ PD=2.92u rfmode=0
.ENDS sg13cmos5l_and3_1

.SUBCKT sg13cmos5l_a21oi_1 Y VSS A2 VDD A1 B1
M$1 VSS B1 Y VSS sg13_lv_nmos L=0.13u W=0.74u AS=0.2516p AD=0.1406p PS=2.16u
+ PD=1.12u rfmode=0
M$2 Y A1 \$8 VSS sg13_lv_nmos L=0.13u W=0.74u AS=0.1406p AD=0.1406p PS=1.12u
+ PD=1.12u rfmode=0
M$3 \$8 A2 VSS VSS sg13_lv_nmos L=0.13u W=0.74u AS=0.1406p AD=0.2516p PS=1.12u
+ PD=2.16u rfmode=0
M$4 Y B1 \$3 VDD sg13_lv_pmos L=0.13u W=1.12u AS=0.3808p AD=0.2128p PS=2.92u
+ PD=1.5u rfmode=0
M$5 \$3 A1 VDD VDD sg13_lv_pmos L=0.13u W=1.12u AS=0.2128p AD=0.2128p PS=1.5u
+ PD=1.5u rfmode=0
M$6 VDD A2 \$3 VDD sg13_lv_pmos L=0.13u W=1.12u AS=0.2128p AD=0.3808p PS=1.5u
+ PD=2.92u rfmode=0
.ENDS sg13cmos5l_a21oi_1

.SUBCKT sg13cmos5l_buf_1 VSS X VDD A
M$1 VSS A \$1 VSS sg13_lv_nmos L=0.13u W=0.55u AS=0.14875p AD=0.187p PS=1.16u
+ PD=1.78u rfmode=0
M$2 VSS \$1 X VSS sg13_lv_nmos L=0.13u W=0.74u AS=0.14875p AD=0.2886p PS=1.16u
+ PD=2.26u rfmode=0
M$3 VDD A \$1 VDD sg13_lv_pmos L=0.13u W=0.84u AS=0.2114p AD=0.2856p PS=1.54u
+ PD=2.36u rfmode=0
M$4 VDD \$1 X VDD sg13_lv_pmos L=0.13u W=1.12u AS=0.2114p AD=0.42p PS=1.54u
+ PD=2.99u rfmode=0
.ENDS sg13cmos5l_buf_1

.SUBCKT sg13cmos5l_a21o_1 VDD VSS X B1 A1 A2
M$1 X \$6 VSS VSS sg13_lv_nmos L=0.13u W=0.74u AS=0.2351p AD=0.15745p PS=2.16u
+ PD=1.175u rfmode=0
M$2 VSS B1 \$6 VSS sg13_lv_nmos L=0.13u W=0.64u AS=0.15745p AD=0.1216p
+ PS=1.175u PD=1.02u rfmode=0
M$3 \$6 A1 \$9 VSS sg13_lv_nmos L=0.13u W=0.64u AS=0.1216p AD=0.0816p PS=1.02u
+ PD=0.895u rfmode=0
M$4 \$9 A2 VSS VSS sg13_lv_nmos L=0.13u W=0.64u AS=0.0816p AD=0.2176p PS=0.895u
+ PD=1.96u rfmode=0
M$5 \$6 B1 \$5 VDD sg13_lv_pmos L=0.13u W=1u AS=0.35p AD=0.2125p PS=2.7u
+ PD=1.425u rfmode=0
M$6 \$5 A1 VDD VDD sg13_lv_pmos L=0.13u W=1u AS=0.2125p AD=0.19p PS=1.425u
+ PD=1.38u rfmode=0
M$7 VDD A2 \$5 VDD sg13_lv_pmos L=0.13u W=1u AS=0.19p AD=0.34p PS=1.38u
+ PD=2.68u rfmode=0
M$8 X \$6 VDD VDD sg13_lv_pmos L=0.13u W=1.12u AS=0.3808p AD=0.3808p PS=2.92u
+ PD=2.92u rfmode=0
.ENDS sg13cmos5l_a21o_1

.SUBCKT sg13cmos5l_nand2b_1 VDD VSS B A_N Y
M$1 VSS A_N \$6 VSS sg13_lv_nmos L=0.13u W=0.55u AS=0.14505p AD=0.187p PS=1.15u
+ PD=1.78u rfmode=0
M$2 VSS B \$7 VSS sg13_lv_nmos L=0.13u W=0.74u AS=0.14505p AD=0.1406p PS=1.15u
+ PD=1.12u rfmode=0
M$3 \$7 \$6 Y VSS sg13_lv_nmos L=0.13u W=0.74u AS=0.1406p AD=0.333p PS=1.12u
+ PD=2.38u rfmode=0
M$4 \$6 A_N VDD VDD sg13_lv_pmos L=0.13u W=0.84u AS=0.2856p AD=0.2198p PS=2.36u
+ PD=1.53u rfmode=0
M$5 VDD B Y VDD sg13_lv_pmos L=0.13u W=1.12u AS=0.2198p AD=0.2128p PS=1.53u
+ PD=1.5u rfmode=0
M$6 Y \$6 VDD VDD sg13_lv_pmos L=0.13u W=1.12u AS=0.2128p AD=0.3808p PS=1.5u
+ PD=2.92u rfmode=0
.ENDS sg13cmos5l_nand2b_1

.SUBCKT sg13cmos5l_xor2_1 VSS X VDD B A
M$1 VSS A \$1 VSS sg13_lv_nmos L=0.13u W=0.55u AS=0.374p AD=0.174625p PS=2.46u
+ PD=1.185u rfmode=0
M$2 VSS B \$1 VSS sg13_lv_nmos L=0.13u W=0.55u AS=0.15245p AD=0.174625p
+ PS=1.17u PD=1.185u rfmode=0
M$3 VSS A \$8 VSS sg13_lv_nmos L=0.13u W=0.74u AS=0.15245p AD=0.0888p PS=1.17u
+ PD=0.98u rfmode=0
M$4 \$8 B X VSS sg13_lv_nmos L=0.13u W=0.74u AS=0.0888p AD=0.1628p PS=0.98u
+ PD=1.18u rfmode=0
M$5 X \$1 VSS VSS sg13_lv_nmos L=0.13u W=0.74u AS=0.1628p AD=0.3108p PS=1.18u
+ PD=2.32u rfmode=0
M$6 \$3 A VDD VDD sg13_lv_pmos L=0.13u W=1.12u AS=0.3808p AD=0.2128p PS=2.92u
+ PD=1.5u rfmode=0
M$7 VDD B \$3 VDD sg13_lv_pmos L=0.13u W=1.12u AS=0.2128p AD=0.2128p PS=1.5u
+ PD=1.5u rfmode=0
M$8 \$3 \$1 X VDD sg13_lv_pmos L=0.13u W=1.12u AS=0.2128p AD=0.3808p PS=1.5u
+ PD=2.92u rfmode=0
M$9 VDD A \$9 VDD sg13_lv_pmos L=0.13u W=1u AS=0.36p AD=0.1225p PS=2.72u
+ PD=1.245u rfmode=0
M$10 \$9 B \$1 VDD sg13_lv_pmos L=0.13u W=1u AS=0.1225p AD=0.34p PS=1.245u
+ PD=2.68u rfmode=0
.ENDS sg13cmos5l_xor2_1
