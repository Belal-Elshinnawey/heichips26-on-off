* Extracted by KLayout with SG13CMOS5L LVS runset on : 01/10/2026 12:43

.SUBCKT heichips26_ook_top VAPWR VGND VPWR analog_0 analog_1 analog_2 clk rst_n
+ ui_in[0] uio_oe[0] uio_oe[1] uio_oe[2] uio_oe[3] uio_oe[4] uio_oe[5]
+ uio_oe[6] uio_oe[7] uio_out[0] uio_out[1] uio_out[2] uio_out[3] uio_out[4]
+ uio_out[5] uio_out[6] uio_out[7] uo_out[0] uo_out[1] uo_out[2] uo_out[3]
+ uo_out[4] uo_out[5] uo_out[6] uo_out[7]
X$61 VGND VPWR VAPWR analog_0 analog_2 analog_1 uo_out[0] uo_out[1] uo_out[2]
+ clk uo_out[3] \$9 ui_in[0] rst_n heichips26_ook_soc
R$1 uio_oe[7] \$9 VGND rsil w=0.5u l=0.5u ps=0u b=0 m=1
R$2 uo_out[5] \$9 VGND rsil w=0.5u l=0.5u ps=0u b=0 m=1
R$3 uo_out[6] \$9 VGND rsil w=0.5u l=0.5u ps=0u b=0 m=1
R$4 uo_out[7] \$9 VGND rsil w=0.5u l=0.5u ps=0u b=0 m=1
R$5 uio_out[0] \$9 VGND rsil w=0.5u l=0.5u ps=0u b=0 m=1
R$6 uio_out[1] \$9 VGND rsil w=0.5u l=0.5u ps=0u b=0 m=1
R$7 uio_out[2] \$9 VGND rsil w=0.5u l=0.5u ps=0u b=0 m=1
R$8 uio_out[3] \$9 VGND rsil w=0.5u l=0.5u ps=0u b=0 m=1
R$9 uio_out[4] \$9 VGND rsil w=0.5u l=0.5u ps=0u b=0 m=1
R$10 uio_out[5] \$9 VGND rsil w=0.5u l=0.5u ps=0u b=0 m=1
R$11 uio_out[6] \$9 VGND rsil w=0.5u l=0.5u ps=0u b=0 m=1
R$12 uo_out[4] \$9 VGND rsil w=0.5u l=0.5u ps=0u b=0 m=1
R$13 uio_oe[6] \$9 VGND rsil w=0.5u l=0.5u ps=0u b=0 m=1
R$14 uio_oe[5] \$9 VGND rsil w=0.5u l=0.5u ps=0u b=0 m=1
R$15 uio_oe[4] \$9 VGND rsil w=0.5u l=0.5u ps=0u b=0 m=1
R$16 uio_oe[3] \$9 VGND rsil w=0.5u l=0.5u ps=0u b=0 m=1
R$17 uio_oe[2] \$9 VGND rsil w=0.5u l=0.5u ps=0u b=0 m=1
R$18 uio_oe[1] \$9 VGND rsil w=0.5u l=0.5u ps=0u b=0 m=1
R$19 uio_oe[0] \$9 VGND rsil w=0.5u l=0.5u ps=0u b=0 m=1
R$20 uio_out[7] \$9 VGND rsil w=0.5u l=0.5u ps=0u b=0 m=1
.ENDS heichips26_ook_top

.SUBCKT heichips26_ook_soc VGND VPWR VAPWR analog_0 analog_2 analog_1 q0_d q1_d
+ q2_d clk q3_d in_tieoff data_in_tx rst_n_in
X$707 VPWR \$3292 VGND \$2820 \$2955 \$3473 \$3079 sg13cmos5l_nand4_1
X$711 VPWR VGND \$2822 \$2823 \$2756 \$2820 \$2765 sg13cmos5l_or4_1
X$740 VGND \$3986 VPWR \$3340 \$3662 sg13cmos5l_xor2_1
X$741 VGND \$2166 VPWR \$2165 \$2215 sg13cmos5l_xor2_1
X$742 VGND \$1960 VPWR \$1861 \$2164 sg13cmos5l_xor2_1
X$743 VGND \$1622 VPWR \$1592 \$470 sg13cmos5l_xor2_1
X$744 VGND \$3994 VPWR \$4125 \$2949 sg13cmos5l_xor2_1
X$745 VGND \$3972 VPWR \$3847 \$3365 sg13cmos5l_xor2_1
X$746 VGND \$4192 VPWR \$4390 \$4490 sg13cmos5l_xor2_1
X$747 VGND \$4478 VPWR \$3562 \$4332 sg13cmos5l_xor2_1
X$748 VGND \$3482 VPWR \$3481 \$3483 sg13cmos5l_xor2_1
X$749 VGND \$3880 VPWR \$3600 \$3352 sg13cmos5l_xor2_1
X$750 VGND \$2883 VPWR \$2890 \$2955 sg13cmos5l_xor2_1
X$751 VGND \$4112 VPWR \$3986 \$3873 sg13cmos5l_xor2_1
X$752 VGND \$3213 VPWR \$3000 \$2952 sg13cmos5l_xor2_1
X$753 VGND \$3900 VPWR \$3489 \$3361 sg13cmos5l_xor2_1
X$754 VGND \$3622 VPWR \$3011 \$3361 sg13cmos5l_xor2_1
X$755 VGND \$3209 VPWR \$3057 \$3290 sg13cmos5l_xor2_1
X$756 VGND \$4004 VPWR \$3777 \$3430 sg13cmos5l_xor2_1
X$757 VGND \$4243 VPWR \$3352 \$3927 sg13cmos5l_xor2_1
X$758 VGND \$3872 VPWR \$4039 \$2743 sg13cmos5l_xor2_1
X$759 VGND \$3047 VPWR \$2865 \$2623 sg13cmos5l_xor2_1
X$760 VGND \$4490 VPWR \$3365 \$4346 sg13cmos5l_xor2_1
X$761 VGND \$2383 VPWR \$2473 \$1905 sg13cmos5l_xor2_1
X$850 VPWR VGND \$3877 \$3993 \$3352 sg13cmos5l_xnor2_1
X$851 VPWR VGND \$4286 \$3010 \$4202 sg13cmos5l_xnor2_1
X$852 VPWR VGND \$4336 \$3007 \$4334 sg13cmos5l_xnor2_1
X$853 VPWR VGND \$2861 \$2308 \$2786 sg13cmos5l_xnor2_1
X$854 VPWR VGND \$3729 \$3491 \$3364 sg13cmos5l_xnor2_1
X$855 VPWR VGND \$2020 \$2021 \$2066 sg13cmos5l_xnor2_1
X$856 VPWR VGND \$3119 \$3006 \$3079 sg13cmos5l_xnor2_1
X$857 VPWR VGND \$3065 \$2883 \$2881 sg13cmos5l_xnor2_1
X$858 VPWR VGND \$2865 \$705 \$2748 sg13cmos5l_xnor2_1
X$859 VPWR VGND \$2513 \$2439 \$2518 sg13cmos5l_xnor2_1
X$860 VPWR VGND \$2633 \$2517 \$2518 sg13cmos5l_xnor2_1
X$861 VPWR VGND \$2993 \$3066 \$2883 sg13cmos5l_xnor2_1
X$862 VPWR VGND \$1549 \$1736 \$371 sg13cmos5l_xnor2_1
X$863 VPWR VGND \$470 \$1048 \$954 sg13cmos5l_xnor2_1
X$864 VPWR VGND \$3105 \$2316 \$3340 sg13cmos5l_xnor2_1
X$865 VPWR VGND \$4062 \$2949 \$4330 sg13cmos5l_xnor2_1
X$866 VPWR VGND \$3000 \$2958 \$3562 sg13cmos5l_xnor2_1
X$867 VPWR VGND \$4281 \$4351 \$4278 sg13cmos5l_xnor2_1
X$868 VPWR VGND \$4344 \$4489 \$4487 sg13cmos5l_xnor2_1
X$869 VPWR VGND \$3942 \$3947 \$3558 sg13cmos5l_xnor2_1
X$870 VPWR VGND \$3817 \$3752 \$3473 sg13cmos5l_xnor2_1
X$871 VPWR VGND \$4247 \$4215 \$4165 sg13cmos5l_xnor2_1
X$872 VPWR VGND \$3569 \$3119 \$3180 sg13cmos5l_xnor2_1
X$873 VPWR VGND \$3455 \$3105 \$3054 sg13cmos5l_xnor2_1
X$874 VPWR VGND \$4200 \$3870 \$4101 sg13cmos5l_xnor2_1
X$875 VPWR VGND \$3057 \$3212 \$3292 sg13cmos5l_xnor2_1
X$876 VPWR VGND \$2741 \$2577 \$2510 sg13cmos5l_xnor2_1
X$877 VPWR VGND \$4101 \$3914 \$2856 sg13cmos5l_xnor2_1
X$878 VPWR VGND \$4039 \$2879 \$3923 sg13cmos5l_xnor2_1
X$879 VPWR VGND \$3725 \$3589 \$3483 sg13cmos5l_xnor2_1
X$880 VPWR VGND \$2772 \$705 \$2340 sg13cmos5l_xnor2_1
X$881 VPWR VGND \$2075 \$2077 \$2076 sg13cmos5l_xnor2_1
X$882 VPWR VGND \$2113 \$2169 \$298 sg13cmos5l_xnor2_1
X$925 VPWR VGND \$1138 \$246 \$620 \$461 sg13cmos5l_or3_1
X$926 VPWR VGND \$3947 \$3562 \$3007 \$3777 sg13cmos5l_or3_1
X$947 VPWR VGND \$798 \$741 \$247 \$74 sg13cmos5l_nand3_1
X$948 VPWR VGND \$2972 \$3014 \$3011 \$3010 sg13cmos5l_nand3_1
X$949 VPWR VGND \$3278 \$3105 \$2925 \$2748 sg13cmos5l_nand3_1
X$950 VPWR VGND \$3003 \$2845 \$2877 \$3007 sg13cmos5l_nand3_1
X$951 VPWR \$2535 VGND \$2823 \$3002 \$3010 \$3014 sg13cmos5l_nand4_1
X$952 VPWR VGND \$1987 \$910 \$1672 \$1914 sg13cmos5l_nand3_1
X$953 VPWR VGND \$3359 \$3119 \$3177 \$3306 sg13cmos5l_nand3_1
X$954 VPWR VGND \$3664 \$3526 \$2793 \$3403 sg13cmos5l_nand3_1
X$955 VPWR VGND \$2544 \$2658 \$2664 \$2663 sg13cmos5l_nand3_1
X$956 VPWR VGND \$3073 \$3000 \$2996 \$2998 sg13cmos5l_nand3_1
X$957 VPWR VGND \$313 \$620 \$371 \$246 sg13cmos5l_nand3_1
X$958 VPWR VGND \$724 \$899 \$371 \$590 sg13cmos5l_nand3_1
X$959 VPWR VGND \$3295 \$1871 \$2877 \$3352 sg13cmos5l_nand3_1
X$960 VPWR VGND \$2886 \$2534 \$2375 \$2949 sg13cmos5l_nand3_1
X$961 VPWR VGND \$1485 \$1337 \$1189 \$1403 sg13cmos5l_nand3_1
X$962 VPWR VGND \$3752 \$2949 \$3600 \$3292 sg13cmos5l_nand3_1
X$963 VPWR VGND \$2987 \$3057 \$2988 \$3058 sg13cmos5l_nand3_1
X$964 VPWR VGND \$2527 \$2588 \$2315 \$1707 sg13cmos5l_a21o_1
X$965 VPWR VGND \$3062 \$3063 \$2943 \$2993 sg13cmos5l_a21o_1
X$966 VPWR VGND \$3869 \$3632 \$3720 \$3631 sg13cmos5l_a21o_1
X$967 VPWR VGND \$2201 \$1594 \$1620 \$188 sg13cmos5l_a21o_1
X$968 VPWR VGND \$2243 \$2127 \$910 \$1672 sg13cmos5l_a21o_1
X$969 VPWR VGND \$3054 \$2748 \$2308 \$2227 sg13cmos5l_a21o_1
X$970 VPWR VGND \$3882 \$2525 \$3752 \$3603 sg13cmos5l_a21o_1
X$971 VPWR VGND \$2242 \$1620 \$1994 \$2364 sg13cmos5l_a21o_1
X$972 VPWR VGND \$4278 \$4491 \$4490 \$4390 sg13cmos5l_a21o_1
X$973 VPWR VGND \$2664 \$2775 \$2774 \$2773 sg13cmos5l_a21o_1
X$974 VPWR VGND \$2291 \$2464 \$2376 \$2523 sg13cmos5l_a21o_1
X$975 VPWR VGND \$3603 \$2949 \$3292 \$3600 sg13cmos5l_a21o_1
X$976 VPWR VGND \$713 \$675 \$323 \$566 sg13cmos5l_a21o_1
X$977 VPWR VGND \$3177 \$3000 \$2998 \$2996 sg13cmos5l_a21o_1
X$978 VPWR VGND \$2988 \$3105 \$2748 \$2925 sg13cmos5l_a21o_1
X$979 VPWR VGND \$247 \$470 \$471 \$461 sg13cmos5l_a21o_1
X$980 VPWR VGND \$4025 \$4278 \$4202 \$3010 sg13cmos5l_a21o_1
X$981 VPWR VGND \$2514 \$2519 \$2376 \$2636 sg13cmos5l_a21o_1
X$1010 VPWR VGND \$2482 \$2236 \$2200 \$2325 sg13cmos5l_nand3b_1
X$1011 VPWR VGND \$503 \$1138 \$620 \$899 sg13cmos5l_nand3b_1
X$1012 VPWR VGND \$2115 \$1672 \$2490 \$2331 sg13cmos5l_nand3b_1
X$1013 VPWR VGND \$3365 \$3361 \$3085 \$3225 \$3231 sg13cmos5l_nor4_1
X$1014 VPWR VGND \$954 \$590 \$1048 \$1138 \$330 sg13cmos5l_nor4_1
X$1015 VPWR VGND \$3365 \$3430 \$3010 \$3777 \$3013 sg13cmos5l_nor4_1
X$1016 VPWR VGND \$3340 \$2879 \$3352 \$3047 \$4125 sg13cmos5l_nor4_1
X$1017 VPWR VGND \$2822 \$2756 \$2820 \$2823 \$2525 sg13cmos5l_nor4_1
X$1018 VPWR VGND \$979 \$1510 \$1408 \$750 \$1337 sg13cmos5l_nor4_1
X$1019 VPWR VGND \$750 \$1311 \$948 \$1096 \$1142 sg13cmos5l_nor4_1
X$1020 VPWR VGND \$1958 \$2161 \$1861 \$2375 \$2623 sg13cmos5l_nor4_1
X$1021 VPWR VGND \$705 \$378 \$521 \$560 \$782 sg13cmos5l_nor4_1
X$1022 VGND \$3020 \$2490 \$2537 \$3019 VPWR sg13cmos5l_mux2_1
X$1023 VGND \$1005 \$246 \$92 \$373 VPWR sg13cmos5l_mux2_1
X$1024 VGND \$3043 \$2227 \$2861 \$2748 VPWR sg13cmos5l_mux2_1
X$1025 VGND \$3191 \$2490 \$2712 \$3013 VPWR sg13cmos5l_mux2_1
X$1026 VGND \$981 \$611 \$1335 \$673 VPWR sg13cmos5l_mux2_1
X$1027 VGND \$2925 \$2623 \$2865 \$2861 VPWR sg13cmos5l_mux2_1
X$1028 VGND \$1199 \$1256 VPWR sg13cmos5l_buf_8
X$1029 VGND \$1740 \$1696 VPWR sg13cmos5l_buf_8
X$1030 VGND \$1698 \$1499 VPWR sg13cmos5l_buf_8
X$1031 VGND clk_ref \$647 VPWR sg13cmos5l_buf_8
X$1032 VGND \$647 \$79 VPWR sg13cmos5l_buf_8
X$1033 VGND \$647 \$2358 VPWR sg13cmos5l_buf_8
X$1034 VGND \$1317 \$1740 VPWR sg13cmos5l_buf_8
X$1035 VGND \$1698 \$2086 VPWR sg13cmos5l_buf_8
X$1036 VGND \$647 \$3937 VPWR sg13cmos5l_buf_8
X$1037 VGND \$1467 \$606 VPWR sg13cmos5l_buf_8
X$1038 VGND \$1175 \$1742 VPWR sg13cmos5l_buf_8
X$1039 VGND \$1119 \$1865 VPWR sg13cmos5l_buf_8
X$1040 VGND \$1317 \$1316 VPWR sg13cmos5l_buf_8
X$1041 VGND \$1750 \$1698 VPWR sg13cmos5l_buf_8
X$1042 VGND \$1701 VPWR \$1594 \$1048 sg13cmos5l_xor2_1
X$1043 VGND \$1175 \$695 VPWR sg13cmos5l_buf_8
X$1044 VGND \$1119 \$589 VPWR sg13cmos5l_buf_8
X$1045 VGND \$1413 \$1199 VPWR sg13cmos5l_buf_8
X$1046 VGND \$647 \$2174 VPWR sg13cmos5l_buf_8
X$1047 VGND \$1729 \$1119 VPWR sg13cmos5l_buf_8
X$1048 VGND \$1316 \$1175 VPWR sg13cmos5l_buf_8
X$1049 VGND \$1318 \$1729 VPWR sg13cmos5l_buf_8
X$1050 VGND \$1413 \$1750 VPWR sg13cmos5l_buf_8
X$1051 VGND \$1318 \$1467 VPWR sg13cmos5l_buf_8
X$1052 VGND \$647 \$3843 VPWR sg13cmos5l_buf_8
X$1053 VGND \$647 \$1630 VPWR sg13cmos5l_buf_8
X$1054 VGND \$647 \$1277 VPWR sg13cmos5l_buf_8
X$1055 \$3442 VGND VPWR \$2712 \$3371 \$3246 \$2535 sg13cmos5l_a22oi_1
X$1056 \$221 VGND VPWR \$895 \$1048 \$673 \$611 sg13cmos5l_a22oi_1
X$1057 \$823 VGND VPWR \$891 \$445 \$500 \$33 sg13cmos5l_a22oi_1
X$1058 \$900 VGND VPWR \$902 \$1138 \$1123 \$895 sg13cmos5l_a22oi_1
X$1059 \$2168 VGND VPWR \$2247 \$2291 \$2219 \$2220 sg13cmos5l_a22oi_1
X$1060 \$462 VGND VPWR \$467 \$95 \$959 \$217 sg13cmos5l_a22oi_1
X$1061 \$569 VGND VPWR \$673 \$611 \$1020 \$899 sg13cmos5l_a22oi_1
X$1062 \$3371 VGND VPWR \$3368 \$2856 \$2537 \$3242 sg13cmos5l_a22oi_1
X$1063 \$566 VGND VPWR \$221 \$671 \$565 \$383 sg13cmos5l_a22oi_1
X$1064 \$2906 VGND VPWR \$3020 \$2610 \$2970 \$2492 sg13cmos5l_a22oi_1
X$1065 \$2507 VGND VPWR \$2242 \$2514 \$2619 \$2518 sg13cmos5l_a22oi_1
X$1066 \$474 VGND VPWR \$330 \$31 \$614 \$190 sg13cmos5l_a22oi_1
X$1067 \$452 VGND VPWR \$573 \$445 \$749 \$33 sg13cmos5l_a22oi_1
X$1068 VPWR VGND \$750 \$643 \$836 \$908 sg13cmos5l_or3_1
X$1069 \$929 VGND VPWR \$467 \$930 \$959 \$999 sg13cmos5l_a22oi_1
X$1221 \$3403 \$3342 \$2316 VPWR VGND sg13cmos5l_or2_1
X$1222 \$2364 \$2773 \$2896 VPWR VGND sg13cmos5l_or2_1
X$1223 \$3227 \$4191 \$3950 VPWR VGND sg13cmos5l_or2_1
X$1224 \$2748 \$2793 \$2227 VPWR VGND sg13cmos5l_or2_1
X$1225 \$2622 \$2620 \$2437 VPWR VGND sg13cmos5l_or2_1
X$1226 \$33 \$455 \$573 VPWR VGND sg13cmos5l_or2_1
X$1227 \$979 \$1311 \$1339 VPWR VGND sg13cmos5l_or2_1
X$1228 \$2247 \$4008 \$4089 VPWR VGND sg13cmos5l_or2_1
X$1229 \$954 \$1335 \$1048 VPWR VGND sg13cmos5l_or2_1
X$1230 \$298 \$2303 \$503 VPWR VGND sg13cmos5l_or2_1
X$1231 \$986 \$760 \$902 VPWR VGND sg13cmos5l_or2_1
X$1232 \$378 \$555 \$521 VPWR VGND sg13cmos5l_or2_1
X$1233 VGND VPWR \$4329 \$4063 \$4476 sg13cmos5l_nor2b_1
X$1234 VGND VPWR \$4333 \$4480 \$4335 sg13cmos5l_nor2b_1
X$1235 VGND VPWR \$3428 \$3225 \$3359 sg13cmos5l_nor2b_1
X$1236 VGND VPWR \$3166 \$3060 \$2987 sg13cmos5l_nor2b_1
X$1237 VGND VPWR \$338 \$620 \$899 sg13cmos5l_nor2b_1
X$1238 VGND VPWR \$4489 \$4386 \$4385 sg13cmos5l_nor2b_1
X$1239 VGND VPWR \$1123 \$899 \$954 sg13cmos5l_nor2b_1
X$1240 VGND VPWR \$3489 \$2820 \$3600 sg13cmos5l_nor2b_1
X$1241 VGND VPWR \$3875 \$3993 \$4319 sg13cmos5l_nor2b_1
X$1242 VGND VPWR \$3747 \$3600 \$3664 sg13cmos5l_nor2b_1
X$1243 VGND VPWR \$2473 \$2315 \$2077 sg13cmos5l_nor2b_1
X$1244 VGND VPWR \$1586 \$1510 \$778 sg13cmos5l_nor2b_1
X$1310 VGND \$3455 VPWR \$3656 \$3201 \$3203 \$2943 \$3339 sg13cmos5l_a221oi_1
X$1311 VGND \$608 VPWR \$542 \$555 \$560 \$74 \$440 sg13cmos5l_a221oi_1
X$1312 VGND \$3569 VPWR \$3702 \$3322 \$3203 \$2943 \$3428 sg13cmos5l_a221oi_1
X$1313 VGND \$1181 VPWR \$1672 \$879 \$188 \$1485 \$1028 sg13cmos5l_a221oi_1
X$1314 VGND \$3213 VPWR \$3216 \$2364 \$3203 \$2943 \$3219 sg13cmos5l_a221oi_1
X$1315 VGND \$3994 VPWR \$3935 \$2521 \$2639 \$3201 \$3882 sg13cmos5l_a221oi_1
X$1316 VGND \$3043 VPWR \$3267 \$3201 \$3203 \$2925 \$2943 sg13cmos5l_a221oi_1
X$1317 VGND \$3209 VPWR \$3206 \$3201 \$3203 \$2943 \$3166 sg13cmos5l_a221oi_1
X$1318 VGND \$2521 VPWR \$2519 \$2633 \$2639 \$2400 \$2525 sg13cmos5l_a221oi_1
X$1319 VGND \$322 VPWR \$305 \$184 \$251 \$31 \$71 sg13cmos5l_a221oi_1
X$1320 VGND \$3873 VPWR \$3987 \$3986 \$3803 \$3927 \$3352 sg13cmos5l_a221oi_1
X$1321 VGND \$2537 VPWR \$2376 \$2535 \$2397 \$2243 \$1987 sg13cmos5l_a221oi_1
X$1322 VGND \$3725 VPWR \$3715 \$3322 \$3203 \$3229 \$3482 sg13cmos5l_a221oi_1
X$1323 VGND \$1123 VPWR \$1270 \$1121 \$590 \$414 \$338 sg13cmos5l_a221oi_1
X$1324 VGND \$3622 VPWR \$3706 \$3322 \$3203 \$3229 \$3479 sg13cmos5l_a221oi_1
X$1325 VGND \$959 VPWR \$1470 \$1696 \$1691 \$1256 \$1123 sg13cmos5l_a221oi_1
X$1326 VGND \$468 VPWR \$771 \$1470 \$371 \$929 \$1270 sg13cmos5l_a221oi_1
X$1327 VGND \$3972 VPWR \$4089 \$2521 \$2775 \$3322 \$3910 sg13cmos5l_a221oi_1
X$1328 VGND \$3951 VPWR \$3950 \$2521 \$2775 \$3322 \$3834 sg13cmos5l_a221oi_1
X$1329 VGND \$2371 VPWR \$2464 \$2521 \$2639 \$2364 \$2525 sg13cmos5l_a221oi_1
X$1348 VPWR VGND \$343 \$455 \$331 sg13cmos5l_and2_1
X$1349 VPWR VGND \$2521 \$2768 \$2896 sg13cmos5l_and2_1
X$1350 VPWR VGND \$970 \$611 \$470 sg13cmos5l_and2_1
X$1351 VPWR VGND \$3014 \$3361 \$3365 sg13cmos5l_and2_1
X$1352 VPWR VGND \$3521 \$3403 \$2316 sg13cmos5l_and2_1
X$1353 VPWR VGND \$4491 \$4273 \$3365 sg13cmos5l_and2_1
X$1354 VPWR VGND \$2768 \$1672 \$1708 sg13cmos5l_and2_1
X$1355 VPWR VGND \$1619 \$1568 \$1168 sg13cmos5l_and2_1
X$1356 VPWR VGND \$3491 \$3014 \$3489 sg13cmos5l_and2_1
X$1357 VPWR VGND \$644 \$273 \$329 sg13cmos5l_and2_1
X$1358 VPWR VGND \$3803 \$3662 \$3340 sg13cmos5l_and2_1
X$1359 VPWR VGND \$3339 \$2988 \$3278 sg13cmos5l_and2_1
X$1360 VPWR VGND \$329 \$448 \$80 sg13cmos5l_and2_1
X$1361 VPWR VGND \$1024 \$1586 \$1580 sg13cmos5l_and2_1
X$1362 VPWR VGND \$560 \$49 \$724 sg13cmos5l_and2_1
X$1363 VPWR VGND \$467 \$620 \$899 sg13cmos5l_and2_1
X$1364 VPWR VGND \$3219 \$3177 \$3073 sg13cmos5l_and2_1
X$1365 VPWR VGND \$4020 \$2535 \$3013 sg13cmos5l_and2_1
X$1366 VPWR VGND \$353 \$590 \$371 sg13cmos5l_and2_1
X$1367 VPWR VGND \$3175 \$3352 \$3212 sg13cmos5l_and2_1
X$1368 VPWR VGND \$1592 \$1485 \$1028 sg13cmos5l_and2_1
X$1369 VPWR VGND \$2635 \$2622 \$2437 sg13cmos5l_and2_1
X$1370 VPWR VGND \$3085 \$3007 \$3006 sg13cmos5l_and2_1
X$1371 VPWR VGND \$80 \$82 \$36 sg13cmos5l_and2_1
X$1372 VPWR VGND \$1344 \$578 \$1139 sg13cmos5l_and2_1
X$1373 VPWR VGND \$4372 \$4330 \$2949 sg13cmos5l_and2_1
X$1374 VPWR VGND \$36 \$190 \$165 sg13cmos5l_and2_1
X$1375 VPWR VGND \$1708 \$837 \$1024 sg13cmos5l_and2_1
X$1376 VPWR VGND \$1097 \$1058 \$1096 sg13cmos5l_nand2b_1
X$1377 VPWR VGND \$1048 \$954 \$895 sg13cmos5l_nand2b_1
X$1378 VPWR VGND \$2620 \$2635 \$2577 sg13cmos5l_nand2b_1
X$1379 VPWR VGND \$4125 \$2949 \$3947 sg13cmos5l_nand2b_1
X$1380 VPWR VGND \$620 \$899 \$1020 sg13cmos5l_nand2b_1
X$1381 VPWR VGND \$73 \$1803 \$1707 sg13cmos5l_nand2b_1
X$1382 VPWR VGND \$2576 \$2517 \$2371 sg13cmos5l_nand2b_1
X$1383 VPWR VGND \$662 \$49 \$608 sg13cmos5l_nand2b_1
X$1384 VPWR VGND \$74 \$221 \$301 sg13cmos5l_nand2b_1
X$1385 VPWR VGND \$3847 \$3365 \$4017 sg13cmos5l_nand2b_1
X$1386 VPWR VGND \$3429 \$3481 \$3479 sg13cmos5l_nand2b_1
X$1387 VPWR VGND \$2126 \$1914 \$2127 sg13cmos5l_nand2b_1
X$1388 VPWR VGND \$2328 \$2200 \$1707 sg13cmos5l_nand2_1
X$1389 VPWR VGND \$3589 \$3361 \$3011 sg13cmos5l_nand2_1
X$1390 VPWR VGND \$2369 \$1123 \$1592 sg13cmos5l_nand2_1
X$1391 VPWR VGND \$3316 \$2535 \$2537 sg13cmos5l_nand2_1
X$1392 VPWR VGND \$2346 \$1861 \$2247 sg13cmos5l_nand2_1
X$1393 VPWR VGND \$1917 \$2087 \$1707 sg13cmos5l_nand2_1
X$1394 VPWR VGND \$2970 \$2492 \$3191 sg13cmos5l_nand2_1
X$1395 VPWR VGND \$2890 \$2534 \$2375 sg13cmos5l_nand2_1
X$1396 VPWR VGND \$3368 \$3014 \$3011 sg13cmos5l_nand2_1
X$1397 VPWR VGND \$2896 \$3015 \$3013 sg13cmos5l_nand2_1
X$1398 VPWR VGND \$4169 \$3562 \$3227 sg13cmos5l_nand2_1
X$1399 VPWR VGND \$3006 \$2845 \$2877 sg13cmos5l_nand2_1
X$1400 VPWR VGND \$2958 \$2082 \$2877 sg13cmos5l_nand2_1
X$1401 VPWR VGND \$2177 \$2077 \$1707 sg13cmos5l_nand2_1
X$1402 VPWR VGND \$3212 \$1871 \$2877 sg13cmos5l_nand2_1
X$1403 VPWR VGND \$2523 \$2371 \$2943 sg13cmos5l_nand2_1
X$1404 VPWR VGND \$2966 \$2768 \$2896 sg13cmos5l_nand2_1
X$1405 VPWR VGND \$2716 \$2325 \$1707 sg13cmos5l_nand2_1
X$1406 VPWR VGND \$2112 \$2161 \$1958 sg13cmos5l_nand2_1
X$1407 VPWR VGND \$2649 \$2589 \$1707 sg13cmos5l_nand2_1
X$1408 VPWR VGND \$3203 \$2775 \$3316 sg13cmos5l_nand2_1
X$1409 VPWR VGND \$3867 \$2535 \$3914 sg13cmos5l_nand2_1
X$1410 VPWR VGND \$891 \$741 \$955 sg13cmos5l_nand2_1
X$1411 VPWR VGND \$2169 \$1594 \$2368 sg13cmos5l_nand2_1
X$1412 VPWR VGND \$3760 \$2949 \$3227 sg13cmos5l_nand2_1
X$1413 VPWR VGND \$4294 \$4332 \$3562 sg13cmos5l_nand2_1
X$1414 VPWR VGND \$3306 \$3562 \$2958 sg13cmos5l_nand2_1
X$1415 VPWR VGND \$366 \$383 \$247 sg13cmos5l_nand2_1
X$1416 VPWR VGND \$358 \$190 \$569 sg13cmos5l_nand2_1
X$1417 VPWR VGND \$479 \$478 \$305 \$456 \$539 sg13cmos5l_nor4_1
X$1418 VPWR VGND \$2636 \$2943 \$2633 sg13cmos5l_nand2_1
X$1419 VPWR VGND \$471 \$590 \$371 sg13cmos5l_nand2_1
X$1420 VPWR VGND \$1994 \$910 \$1672 sg13cmos5l_nand2_1
X$1421 VPWR VGND \$2400 \$1672 \$1708 sg13cmos5l_nand2_1
X$1422 VPWR VGND \$1139 \$611 \$338 sg13cmos5l_nand2_1
X$1423 VPWR VGND \$2658 \$2772 \$2376 sg13cmos5l_nand2_1
X$1424 VPWR VGND \$341 \$372 \$338 sg13cmos5l_nand2_1
X$1425 VPWR VGND \$4083 \$3365 \$2247 sg13cmos5l_nand2_1
X$1426 VPWR VGND \$750 \$760 \$778 sg13cmos5l_nand2_1
X$1427 VPWR VGND \$2511 \$2066 \$2021 sg13cmos5l_nand2_1
X$1428 VPWR VGND \$3693 \$3390 \$3227 sg13cmos5l_nand2_1
X$1429 VPWR VGND \$2399 \$2343 \$1707 sg13cmos5l_nand2_1
X$1430 VPWR VGND \$3309 \$3102 \$3227 sg13cmos5l_nand2_1
X$1431 VPWR VGND \$614 \$902 \$1020 sg13cmos5l_nand2_1
X$1432 VPWR VGND \$3735 \$3292 \$3227 sg13cmos5l_nand2_1
X$1433 VPWR VGND \$314 \$139 \$313 sg13cmos5l_nand2_1
X$1434 VPWR VGND \$4358 \$3923 \$2879 sg13cmos5l_nand2_1
X$1435 VPWR VGND \$3951 \$3777 \$3949 sg13cmos5l_nand2_1
X$1436 VPWR VGND \$4131 \$3007 \$3227 sg13cmos5l_nand2_1
X$1437 VPWR VGND \$2215 \$2164 \$1861 sg13cmos5l_nand2_1
X$1438 VPWR VGND \$902 \$471 \$461 sg13cmos5l_nand2_1
X$1439 VPWR VGND \$2998 \$2955 \$2890 sg13cmos5l_nand2_1
X$1440 VPWR VGND \$3058 \$3340 \$2316 sg13cmos5l_nand2_1
X$1441 VPWR VGND \$3526 \$2879 \$2877 sg13cmos5l_nand2_1
X$1442 VPWR VGND \$4385 \$4342 \$3430 sg13cmos5l_nand2_1
X$1443 VPWR VGND \$1972 \$1905 \$1707 sg13cmos5l_nand2_1
X$1444 VPWR VGND \$500 \$461 \$503 sg13cmos5l_nand2_1
X$1445 VPWR VGND \$468 \$606 \$467 sg13cmos5l_nand2_1
X$1446 VGND \$355 \$611 \$470 \$461 VPWR sg13cmos5l_mux2_1
X$1447 VPWR VGND \$3631 \$2775 \$3442 sg13cmos5l_nand2_1
X$1448 VPWR VGND \$3840 \$3361 \$3227 sg13cmos5l_nand2_1
X$1585 VGND \$2546 VPWR \$2346 \$2544 \$2665 sg13cmos5l_o21ai_1
X$1586 VGND \$2774 VPWR \$2772 \$2765 \$2768 sg13cmos5l_o21ai_1
X$1587 VGND \$3753 VPWR \$3760 \$3677 \$3935 sg13cmos5l_o21ai_1
X$1588 VGND \$3739 VPWR \$2663 \$3800 \$2639 sg13cmos5l_o21ai_1
X$1589 VGND \$3888 VPWR \$3758 \$3942 \$2966 sg13cmos5l_o21ai_1
X$1590 VGND \$477 VPWR \$474 \$563 \$542 sg13cmos5l_o21ai_1
X$1591 VGND \$2952 VPWR \$2886 \$2883 \$2881 sg13cmos5l_o21ai_1
X$1592 VGND \$3011 VPWR \$3003 \$3178 \$3180 sg13cmos5l_o21ai_1
X$1593 VGND \$2235 VPWR \$2328 \$2319 \$2115 sg13cmos5l_o21ai_1
X$1594 VGND \$672 VPWR \$31 \$673 \$747 sg13cmos5l_o21ai_1
X$1595 VPWR VGND \$675 \$741 \$672 \$358 sg13cmos5l_nand3_1
X$1596 VGND \$3865 VPWR \$3867 \$3870 \$3984 sg13cmos5l_o21ai_1
X$1597 VGND \$563 VPWR \$366 \$614 \$31 sg13cmos5l_o21ai_1
X$1598 VGND \$3870 VPWR \$4025 \$3010 \$4202 sg13cmos5l_o21ai_1
X$1599 VGND \$3901 VPWR \$4080 \$4004 \$2966 sg13cmos5l_o21ai_1
X$1600 VGND \$2125 VPWR \$1972 \$2197 \$2115 sg13cmos5l_o21ai_1
X$1601 VGND \$2996 VPWR \$2883 \$3060 \$3175 sg13cmos5l_o21ai_1
X$1602 VGND \$3899 VPWR \$2663 \$3901 \$2775 sg13cmos5l_o21ai_1
X$1603 VGND \$3800 VPWR \$3804 \$3875 \$2966 sg13cmos5l_o21ai_1
X$1604 VGND \$2319 VPWR \$2482 \$2236 \$2200 sg13cmos5l_o21ai_1
X$1605 VGND \$2317 VPWR \$2649 \$2709 \$2115 sg13cmos5l_o21ai_1
X$1606 VGND \$3290 VPWR \$3342 \$3521 \$3054 sg13cmos5l_o21ai_1
X$1607 VGND \$905 VPWR \$190 \$705 \$970 sg13cmos5l_o21ai_1
X$1608 VGND \$837 VPWR \$889 \$539 \$677 sg13cmos5l_o21ai_1
X$1609 VGND \$3429 VPWR \$3430 \$3225 \$3085 sg13cmos5l_o21ai_1
X$1610 VGND \$3873 VPWR \$4358 \$4039 \$2743 sg13cmos5l_o21ai_1
X$1611 VGND \$4476 VPWR \$4062 \$3987 \$4061 sg13cmos5l_o21ai_1
X$1612 VGND \$3879 VPWR \$3201 \$3880 \$2525 sg13cmos5l_o21ai_1
X$1613 VGND \$977 VPWR \$578 \$895 \$471 sg13cmos5l_o21ai_1
X$1614 VGND \$1580 VPWR \$760 \$1408 \$1344 sg13cmos5l_o21ai_1
X$1615 VGND \$2398 VPWR \$2399 \$2400 \$1803 sg13cmos5l_o21ai_1
X$1616 VGND \$3804 VPWR \$3201 \$3747 \$2525 sg13cmos5l_o21ai_1
X$1617 VGND \$4080 VPWR \$3322 \$3900 \$2525 sg13cmos5l_o21ai_1
X$1618 VGND \$3157 VPWR \$3309 \$3267 \$3513 sg13cmos5l_o21ai_1
X$1619 VGND \$3246 VPWR \$2768 \$3231 \$3242 sg13cmos5l_o21ai_1
X$1620 VGND \$1691 VPWR \$590 \$895 \$1458 sg13cmos5l_o21ai_1
X$1621 VGND \$4187 VPWR \$4131 \$4191 \$3702 sg13cmos5l_o21ai_1
X$1622 VGND \$2316 VPWR \$2116 \$503 \$298 sg13cmos5l_o21ai_1
X$1623 VGND \$3758 VPWR \$3201 \$3817 \$2525 sg13cmos5l_o21ai_1
X$1624 VGND \$3395 VPWR \$3201 \$3160 \$2525 sg13cmos5l_o21ai_1
X$1625 VGND \$1762 VPWR \$1577 \$1619 \$1617 sg13cmos5l_o21ai_1
X$1626 VGND \$3834 VPWR \$2765 \$3762 \$3489 sg13cmos5l_o21ai_1
X$1627 VGND \$4335 VPWR \$4478 \$4063 \$4372 sg13cmos5l_o21ai_1
X$1628 VGND \$1736 VPWR \$1594 \$1608 \$1961 sg13cmos5l_o21ai_1
X$1629 VGND \$3513 VPWR \$2663 \$3335 \$2639 sg13cmos5l_o21ai_1
X$1630 VGND \$182 VPWR \$45 \$52 \$49 sg13cmos5l_o21ai_1
X$1631 VGND \$2308 VPWR \$2311 \$503 \$298 sg13cmos5l_o21ai_1
X$1632 VGND \$3910 VPWR \$2765 \$3772 \$3491 sg13cmos5l_o21ai_1
X$1633 VGND \$3797 VPWR \$2663 \$3929 \$2639 sg13cmos5l_o21ai_1
X$1634 VGND \$2368 VPWR \$2369 \$1592 \$895 sg13cmos5l_o21ai_1
X$1635 VGND \$3646 VPWR \$3693 \$3656 \$3739 sg13cmos5l_o21ai_1
X$1636 VGND \$836 VPWR \$911 \$981 \$84 sg13cmos5l_o21ai_1
X$1637 VGND \$937 VPWR \$774 \$1005 \$503 sg13cmos5l_o21ai_1
X$1638 VGND \$2576 VPWR \$1958 \$2375 \$1861 sg13cmos5l_o21ai_1
X$1639 VGND \$1765 VPWR \$1917 \$1994 \$1803 sg13cmos5l_o21ai_1
X$1640 VGND \$831 VPWR \$798 \$900 \$671 sg13cmos5l_o21ai_1
X$1641 VGND \$1966 VPWR \$2177 \$2119 \$2115 sg13cmos5l_o21ai_1
X$1642 VGND \$322 VPWR \$178 \$321 \$283 sg13cmos5l_o21ai_1
X$1643 VGND \$3794 VPWR \$3735 \$3206 \$3797 sg13cmos5l_o21ai_1
X$1644 VGND \$4390 VPWR \$4385 \$4386 \$4488 sg13cmos5l_o21ai_1
X$1645 VGND \$4170 VPWR \$4169 \$4067 \$3216 sg13cmos5l_o21ai_1
X$1646 VGND \$3677 VPWR \$2663 \$3062 \$3203 sg13cmos5l_o21ai_1
X$1647 VGND \$4010 VPWR \$4083 \$3715 \$4008 sg13cmos5l_o21ai_1
X$1648 VGND \$3955 VPWR \$3840 \$3899 \$3706 sg13cmos5l_o21ai_1
X$1649 VGND \$3335 VPWR \$3395 \$2966 \$3047 sg13cmos5l_o21ai_1
X$1650 VGND \$4067 VPWR \$2663 \$3888 \$2639 sg13cmos5l_o21ai_1
X$1651 VGND \$3929 VPWR \$3879 \$3877 \$2966 sg13cmos5l_o21ai_1
X$1652 VGND \$1403 VPWR \$977 \$836 \$822 sg13cmos5l_o21ai_1
X$1653 VGND \$4319 VPWR \$3340 \$3047 \$2879 sg13cmos5l_o21ai_1
X$1654 VGND \$2510 VPWR \$2511 \$2020 \$2215 sg13cmos5l_o21ai_1
X$1655 VGND \$1189 VPWR \$1142 \$821 \$1114 sg13cmos5l_o21ai_1
X$1656 VGND \$910 VPWR \$1024 \$908 \$533 sg13cmos5l_o21ai_1
X$1657 VGND \$861 VPWR \$841 \$644 \$682 sg13cmos5l_o21ai_1
X$1658 VGND \$323 VPWR \$301 \$321 \$283 sg13cmos5l_o21ai_1
X$1659 VGND \$3949 VPWR \$3007 \$3947 \$3562 sg13cmos5l_o21ai_1
X$1660 VGND \$903 VPWR \$832 \$831 \$881 sg13cmos5l_o21ai_1
X$1661 VGND \$1097 VPWR \$84 \$981 \$705 sg13cmos5l_o21ai_1
X$1662 VPWR VGND \$1062 \$1139 \$578 sg13cmos5l_xnor2_1
X$2476 VPWR VGND \$1619 \$1618 \$1595 \$73 sg13cmos5l_nor3_1
X$2477 VPWR VGND \$2375 \$2517 \$1861 \$1958 sg13cmos5l_nor3_1
X$2478 VPWR VGND \$3987 \$4063 \$4062 \$4061 sg13cmos5l_nor3_1
X$2479 VPWR VGND \$3225 \$3481 \$3085 \$3361 sg13cmos5l_nor3_1
X$2480 VPWR VGND \$705 \$971 \$970 \$190 sg13cmos5l_nor3_1
X$2481 VPWR VGND \$329 \$100 \$290 \$26 sg13cmos5l_nor3_1
X$2482 VPWR VGND \$1168 \$1147 \$1148 \$73 sg13cmos5l_nor3_1
X$2483 VPWR VGND \$644 \$443 \$524 \$26 sg13cmos5l_nor3_1
X$2484 VPWR VGND \$1339 \$1408 \$979 \$1097 sg13cmos5l_nor3_1
X$2485 VPWR VGND \$1592 \$1961 \$895 \$298 sg13cmos5l_nor3_1
X$2486 VPWR VGND \$3047 \$3993 \$3340 \$2879 sg13cmos5l_nor3_1
X$2487 VPWR VGND \$2189 \$2588 \$2115 \$2315 sg13cmos5l_nor3_1
X$2488 VPWR VGND \$730 \$881 \$739 \$782 sg13cmos5l_nor3_1
X$2489 VPWR VGND \$3627 \$4022 \$3913 \$2775 sg13cmos5l_nor3_1
X$2490 VPWR VGND \$52 \$233 \$139 \$26 sg13cmos5l_nor3_1
X$2491 VGND \$314 VPWR \$321 \$355 \$378 \$28 \$245 sg13cmos5l_a221oi_1
X$2492 VPWR VGND \$165 \$163 \$126 \$26 sg13cmos5l_nor3_1
X$2493 VPWR VGND \$371 \$673 \$620 \$246 sg13cmos5l_nor3_1
X$2494 VPWR VGND \$330 \$456 \$353 \$190 sg13cmos5l_nor3_1
X$2495 \$104 \$331 \$330 VPWR VGND sg13cmos5l_or2_1
X$2496 VPWR VGND \$4478 \$4480 \$4063 \$4372 sg13cmos5l_nor3_1
X$2497 VPWR VGND \$2375 \$2439 \$1860 \$2220 sg13cmos5l_nor3_1
X$2498 VPWR VGND \$981 \$1058 \$1056 \$84 sg13cmos5l_nor3_1
X$2499 VPWR VGND \$66 \$185 \$169 \$26 sg13cmos5l_nor3_1
X$2500 VPWR VGND \$2856 \$2712 \$2775 \$2665 sg13cmos5l_and3_1
X$2501 VPWR VGND \$2589 \$2473 \$1871 \$2236 sg13cmos5l_and3_1
X$2502 VPWR VGND \$590 \$371 \$899 \$662 sg13cmos5l_and3_1
X$2503 VPWR VGND \$1018 \$644 \$578 \$1168 sg13cmos5l_and3_1
X$2504 VPWR VGND \$590 \$1592 \$1123 \$1608 sg13cmos5l_and3_1
X$2505 VPWR VGND \$3242 \$3231 \$2768 \$2712 sg13cmos5l_and3_1
X$2506 VPWR VGND \$2200 \$2236 \$2325 \$2189 sg13cmos5l_and3_1
X$2507 VPWR VGND \$4294 \$4336 \$4335 \$4337 sg13cmos5l_and3_1
X$2508 VPWR VGND \$823 \$821 sg13cmos5l_inv_1
X$2509 VPWR VGND \$414 \$415 sg13cmos5l_inv_1
X$2510 VPWR VGND \$422 \$373 sg13cmos5l_inv_1
X$2511 VPWR VGND \$3119 \$3178 sg13cmos5l_inv_1
X$2512 VPWR VGND \$1415 \$1458 sg13cmos5l_inv_1
X$2513 VPWR VGND \$3295 \$3291 sg13cmos5l_inv_1
X$2514 VPWR VGND \$3010 \$3242 sg13cmos5l_inv_1
X$2515 VPWR VGND \$1861 \$1860 sg13cmos5l_inv_1
X$2516 VPWR VGND \$2076 \$2311 sg13cmos5l_inv_1
X$2517 VPWR VGND \$1806 \$1995 sg13cmos5l_inv_1
X$2518 VPWR VGND \$74 \$383 sg13cmos5l_inv_1
X$2519 VPWR VGND \$861 \$932 sg13cmos5l_inv_1
X$2520 VPWR VGND \$372 \$416 sg13cmos5l_inv_1
X$2521 VPWR VGND \$76 \$120 sg13cmos5l_inv_1
X$2522 VPWR VGND \$31 \$671 sg13cmos5l_inv_1
X$2523 VPWR VGND \$930 \$1540 sg13cmos5l_inv_1
X$2524 VPWR VGND \$999 \$1723 sg13cmos5l_inv_1
X$2525 VPWR VGND \$217 \$408 sg13cmos5l_inv_1
X$2526 VPWR VGND \$1742 \$1734 sg13cmos5l_inv_1
X$2527 VPWR VGND \$1865 \$1660 sg13cmos5l_inv_1
X$2528 VPWR VGND \$95 \$420 sg13cmos5l_inv_1
X$2529 VPWR VGND \$2021 \$2220 sg13cmos5l_inv_1
X$2530 VPWR VGND \$3340 \$3403 sg13cmos5l_inv_1
X$2531 VPWR VGND \$452 \$450 sg13cmos5l_inv_1
X$2532 VPWR VGND \$1121 \$1845 sg13cmos5l_inv_1
X$2533 VPWR VGND \$2126 \$2395 sg13cmos5l_inv_1
X$2534 VPWR VGND \$2856 \$2610 sg13cmos5l_inv_1
X$2535 VPWR VGND \$2879 \$2748 sg13cmos5l_inv_1
X$2536 VPWR VGND \$2086 \$1873 sg13cmos5l_inv_1
X$2537 VPWR VGND \$3562 \$3558 sg13cmos5l_inv_1
X$2538 VPWR VGND \$46 \$149 sg13cmos5l_inv_1
X$2539 VPWR VGND \$247 \$440 sg13cmos5l_inv_1
X$2540 VPWR VGND \$2437 \$2518 sg13cmos5l_inv_1
X$2541 VPWR VGND \$182 \$180 sg13cmos5l_inv_1
X$2614 \$2092 VPWR VGND sg13cmos5l_tiehi
X$2615 \$2734 VPWR VGND sg13cmos5l_tiehi
X$2616 \$2273 VPWR VGND sg13cmos5l_tiehi
X$2617 \$2735 VPWR VGND sg13cmos5l_tiehi
X$2618 \$4208 VPWR VGND sg13cmos5l_tiehi
X$2619 \$1940 VPWR VGND sg13cmos5l_tiehi
X$2620 \$1885 VPWR VGND sg13cmos5l_tiehi
X$2621 \$1783 VPWR VGND sg13cmos5l_tiehi
X$2622 \$4102 VPWR VGND sg13cmos5l_tiehi
X$2623 \$2207 VPWR VGND sg13cmos5l_tiehi
X$2624 \$2004 VPWR VGND sg13cmos5l_tiehi
X$2625 \$3331 VPWR VGND sg13cmos5l_tiehi
X$2626 \$2013 VPWR VGND sg13cmos5l_tiehi
X$2627 \$1886 VPWR VGND sg13cmos5l_tiehi
X$2628 \$3447 VPWR VGND sg13cmos5l_tiehi
X$2629 \$3383 VPWR VGND sg13cmos5l_tiehi
X$2630 VPWR VGND sg13cmos5l_decap_8
X$2631 VPWR VGND sg13cmos5l_decap_8
X$2632 VPWR VGND sg13cmos5l_decap_8
X$2633 VPWR VGND sg13cmos5l_decap_8
X$2634 VPWR VGND sg13cmos5l_decap_8
X$2635 VPWR VGND sg13cmos5l_decap_8
X$2636 VPWR VGND sg13cmos5l_decap_8
X$2637 VPWR VGND sg13cmos5l_decap_8
X$2638 VPWR VGND sg13cmos5l_decap_8
X$2639 VPWR VGND sg13cmos5l_decap_8
X$2640 VPWR VGND sg13cmos5l_decap_8
X$2641 VPWR VGND sg13cmos5l_decap_8
X$2642 VPWR VGND sg13cmos5l_decap_8
X$2643 VPWR VGND sg13cmos5l_decap_8
X$2644 VPWR VGND sg13cmos5l_decap_8
X$2645 VPWR VGND sg13cmos5l_decap_8
X$2646 VPWR VGND sg13cmos5l_decap_8
X$2647 VPWR VGND sg13cmos5l_decap_8
X$2648 VPWR VGND sg13cmos5l_decap_8
X$2649 VPWR VGND sg13cmos5l_decap_8
X$2650 VPWR VGND sg13cmos5l_decap_8
X$2651 VPWR VGND sg13cmos5l_decap_8
X$2652 VPWR VGND sg13cmos5l_decap_8
X$2653 VPWR VGND sg13cmos5l_decap_8
X$2654 VPWR VGND sg13cmos5l_decap_8
X$2655 VPWR VGND sg13cmos5l_decap_8
X$2656 VPWR VGND sg13cmos5l_decap_8
X$2657 VPWR VGND sg13cmos5l_decap_8
X$2658 VPWR VGND sg13cmos5l_decap_8
X$2659 VPWR VGND sg13cmos5l_decap_8
X$2660 VPWR VGND sg13cmos5l_decap_8
X$2661 VPWR VGND sg13cmos5l_decap_8
X$2662 VPWR VGND sg13cmos5l_decap_8
X$2663 VPWR VGND sg13cmos5l_decap_8
X$2664 VPWR VGND sg13cmos5l_decap_8
X$2665 VPWR VGND sg13cmos5l_decap_8
X$2666 VPWR VGND sg13cmos5l_decap_8
X$2667 VPWR VGND sg13cmos5l_decap_8
X$2668 VPWR VGND sg13cmos5l_decap_8
X$2669 VPWR VGND sg13cmos5l_decap_8
X$2670 VPWR VGND sg13cmos5l_decap_8
X$2671 VPWR VGND sg13cmos5l_decap_8
X$2672 VPWR VGND sg13cmos5l_decap_8
X$2673 VPWR VGND sg13cmos5l_decap_8
X$2674 VPWR VGND sg13cmos5l_decap_8
X$2675 VPWR VGND sg13cmos5l_decap_8
X$2676 VPWR VGND sg13cmos5l_decap_8
X$2677 VPWR VGND sg13cmos5l_decap_8
X$2678 VPWR VGND sg13cmos5l_decap_8
X$2679 VPWR VGND sg13cmos5l_decap_8
X$2680 VPWR VGND sg13cmos5l_decap_8
X$2681 VPWR VGND sg13cmos5l_decap_8
X$2682 VPWR VGND sg13cmos5l_decap_8
X$2683 VPWR VGND sg13cmos5l_decap_8
X$2684 VPWR VGND sg13cmos5l_decap_8
X$2685 VPWR VGND sg13cmos5l_decap_8
X$2686 VPWR VGND sg13cmos5l_decap_8
X$2687 VPWR VGND sg13cmos5l_decap_8
X$2688 VPWR VGND sg13cmos5l_decap_8
X$2689 VPWR VGND sg13cmos5l_decap_8
X$2690 VPWR VGND sg13cmos5l_decap_8
X$2691 VPWR VGND sg13cmos5l_decap_8
X$2692 VPWR VGND sg13cmos5l_decap_8
X$2693 VPWR VGND sg13cmos5l_decap_8
X$2694 VPWR VGND sg13cmos5l_decap_8
X$2695 VPWR VGND \$2302 \$2439 \$2367 sg13cmos5l_nor2_1
X$2696 VPWR VGND \$1048 \$954 \$959 sg13cmos5l_nor2_1
X$2697 VPWR VGND \$2877 \$2786 \$2822 sg13cmos5l_nor2_1
X$2698 VPWR VGND \$71 \$358 \$251 sg13cmos5l_nor2_1
X$2699 VPWR VGND \$330 \$353 \$71 sg13cmos5l_nor2_1
X$2700 VPWR VGND \$750 \$836 \$889 sg13cmos5l_nor2_1
X$2701 VPWR VGND \$3060 \$3175 \$3066 sg13cmos5l_nor2_1
X$2702 VPWR VGND \$705 \$977 \$979 sg13cmos5l_nor2_1
X$2703 VPWR VGND \$2383 \$2189 \$2197 sg13cmos5l_nor2_1
X$2704 VPWR VGND \$471 \$620 \$245 sg13cmos5l_nor2_1
X$2705 VPWR VGND \$4481 \$4337 \$4338 sg13cmos5l_nor2_1
X$2706 VPWR VGND \$4022 \$2247 \$3720 sg13cmos5l_nor2_1
X$2707 VPWR VGND \$2227 \$2748 \$3104 sg13cmos5l_nor2_1
X$2708 VPWR VGND \$3352 \$3927 \$4061 sg13cmos5l_nor2_1
X$2709 VPWR VGND \$3065 \$2768 \$3063 sg13cmos5l_nor2_1
X$2710 VPWR VGND \$37 \$36 \$34 sg13cmos5l_nor2_1
X$2711 VPWR VGND \$503 \$298 \$1056 sg13cmos5l_nor2_1
X$2712 VPWR VGND \$26 \$46 \$27 sg13cmos5l_nor2_1
X$2713 VPWR VGND \$2958 \$3558 \$3423 sg13cmos5l_nor2_1
X$2714 VPWR VGND \$1634 \$1620 \$1594 sg13cmos5l_nor2_1
X$2715 VPWR VGND \$3364 \$2535 \$3237 sg13cmos5l_nor2_1
X$2716 VPWR VGND \$330 \$188 \$1028 sg13cmos5l_nor2_1
X$2717 VPWR VGND \$569 \$190 \$478 sg13cmos5l_nor2_1
X$2718 VPWR VGND \$895 \$471 \$747 sg13cmos5l_nor2_1
X$2719 VPWR VGND \$2663 \$3242 \$3632 sg13cmos5l_nor2_1
X$2720 VPWR VGND \$221 \$30 \$240 sg13cmos5l_nor2_1
X$2721 VPWR VGND \$3723 \$3322 \$3627 sg13cmos5l_nor2_1
X$2722 VPWR VGND \$1056 \$188 \$1181 sg13cmos5l_nor2_1
X$2723 VPWR VGND \$329 \$273 \$524 sg13cmos5l_nor2_1
X$2724 VPWR VGND \$910 \$837 \$879 sg13cmos5l_nor2_1
X$2725 VPWR VGND \$673 \$747 \$565 sg13cmos5l_nor2_1
X$2726 VPWR VGND \$598 \$771 \$774 sg13cmos5l_nor2_1
X$2727 VPWR VGND \$3761 \$3007 \$3762 sg13cmos5l_nor2_1
X$2728 VPWR VGND \$2763 \$2236 \$2761 sg13cmos5l_nor2_1
X$2729 VPWR VGND \$2075 \$2189 \$2119 sg13cmos5l_nor2_1
X$2730 VPWR VGND \$1168 \$1568 \$1512 sg13cmos5l_nor2_1
X$2731 VPWR VGND \$80 \$448 \$290 sg13cmos5l_nor2_1
X$2732 VPWR VGND \$3914 \$2535 \$3984 sg13cmos5l_nor2_1
X$2733 VPWR VGND \$3430 \$4342 \$4386 sg13cmos5l_nor2_1
X$2734 VPWR VGND \$36 \$82 \$94 sg13cmos5l_nor2_1
X$2735 VPWR VGND \$891 \$33 \$890 sg13cmos5l_nor2_1
X$2736 VPWR VGND \$749 \$445 \$643 sg13cmos5l_nor2_1
X$2737 VPWR VGND \$500 \$445 \$948 sg13cmos5l_nor2_1
X$2738 VPWR VGND \$3752 \$3558 \$3761 sg13cmos5l_nor2_1
X$2739 VPWR VGND \$3777 \$3430 \$3847 sg13cmos5l_nor2_1
X$2740 VPWR VGND \$3329 \$2768 \$3019 sg13cmos5l_nor2_1
X$2741 VPWR VGND \$724 \$49 \$730 sg13cmos5l_nor2_1
X$2742 VPWR VGND \$2761 \$2189 \$2709 sg13cmos5l_nor2_1
X$2743 VPWR VGND \$643 \$452 \$677 sg13cmos5l_nor2_1
X$2744 VPWR VGND \$1594 \$954 \$1669 sg13cmos5l_nor2_1
X$2745 VPWR VGND \$66 \$99 \$55 sg13cmos5l_nor2_1
X$2746 VPWR VGND \$245 \$49 \$283 sg13cmos5l_nor2_1
X$2747 VPWR VGND \$240 \$72 \$184 sg13cmos5l_nor2_1
X$2748 VPWR VGND \$149 \$120 \$52 sg13cmos5l_nor2_1
X$2749 VPWR VGND \$479 \$478 \$641 sg13cmos5l_nor2_1
X$2750 VPWR VGND \$479 \$455 \$452 \$643 sg13cmos5l_nand3b_1
X$2751 VPWR VGND \$46 \$76 \$139 sg13cmos5l_nor2_1
X$2752 \$3180 VGND \$3000 VPWR \$2952 \$3423 sg13cmos5l_a21oi_1
X$2753 \$778 VGND \$902 VPWR \$986 \$1287 sg13cmos5l_a21oi_1
X$2754 \$3600 VGND \$2793 VPWR \$3526 \$3403 sg13cmos5l_a21oi_1
X$2755 \$822 VGND \$713 VPWR \$641 \$677 sg13cmos5l_a21oi_1
X$2756 \$598 VGND \$462 VPWR \$341 \$471 sg13cmos5l_a21oi_1
X$2757 \$3160 VGND \$2865 VPWR \$2227 \$3104 sg13cmos5l_a21oi_1
X$2758 \$2743 VGND \$2620 VPWR \$2510 \$2635 sg13cmos5l_a21oi_1
X$2759 \$841 VGND \$644 VPWR \$682 \$73 sg13cmos5l_a21oi_1
X$2760 \$1021 VGND \$644 VPWR \$578 \$1018 sg13cmos5l_a21oi_1
X$2761 \$2490 VGND \$1987 VPWR \$2243 \$2397 sg13cmos5l_a21oi_1
X$2762 \$2458 VGND \$2375 VPWR \$1860 \$2112 sg13cmos5l_a21oi_1
X$2763 \$832 VGND \$900 VPWR \$671 \$971 sg13cmos5l_a21oi_1
X$2764 \$3225 VGND \$3177 VPWR \$3306 \$3119 sg13cmos5l_a21oi_1
X$2765 \$2397 VGND \$1708 VPWR \$1672 \$2395 sg13cmos5l_a21oi_1
X$2766 \$1339 VGND \$741 VPWR \$1139 \$578 sg13cmos5l_a21oi_1
X$2767 \$2598 VGND \$2236 VPWR \$2082 \$2325 sg13cmos5l_a21oi_1
X$2768 \$4488 VGND \$3007 VPWR \$4334 \$4481 sg13cmos5l_a21oi_1
X$2769 \$1577 VGND \$1619 VPWR \$1617 \$73 sg13cmos5l_a21oi_1
X$2770 \$2756 VGND \$2877 VPWR \$2879 \$2458 sg13cmos5l_a21oi_1
X$2771 \$3329 VGND \$3491 VPWR \$3364 \$2610 sg13cmos5l_a21oi_1
X$2772 \$2492 VGND \$2364 VPWR \$1994 \$1620 sg13cmos5l_a21oi_1
X$2773 \$108 VGND \$52 VPWR \$49 \$74 sg13cmos5l_a21oi_1
X$2774 \$3772 VGND \$3489 VPWR \$3361 \$3773 sg13cmos5l_a21oi_1
X$2775 \$533 VGND \$343 VPWR \$477 \$450 sg13cmos5l_a21oi_1
X$2776 \$4481 VGND \$4335 VPWR \$4294 \$4336 sg13cmos5l_a21oi_1
X$2777 \$3229 VGND \$3231 VPWR \$3237 \$3322 sg13cmos5l_a21oi_1
X$2778 \$3060 VGND \$2988 VPWR \$3058 \$3057 sg13cmos5l_a21oi_1
X$2779 \$2619 VGND \$2513 VPWR \$2400 \$2247 sg13cmos5l_a21oi_1
X$2780 \$1667 VGND \$1622 VPWR \$1594 \$1669 sg13cmos5l_a21oi_1
X$2781 \$911 VGND \$981 VPWR \$84 \$1062 sg13cmos5l_a21oi_1
X$2782 \$1114 VGND \$903 VPWR \$905 \$890 sg13cmos5l_a21oi_1
X$2783 \$378 VGND \$313 VPWR \$149 \$120 sg13cmos5l_a21oi_1
X$2784 \$2537 VGND \$1708 VPWR \$1672 \$2972 sg13cmos5l_a21oi_1
X$2785 \$3913 VGND \$3729 VPWR \$2765 \$2768 sg13cmos5l_a21oi_1
X$2786 \$739 VGND \$247 VPWR \$741 \$74 sg13cmos5l_a21oi_1
X$2787 \$2763 VGND \$2473 VPWR \$1871 \$2589 sg13cmos5l_a21oi_1
X$2788 \$1634 VGND \$879 VPWR \$1181 \$1592 sg13cmos5l_a21oi_1
X$2789 \$3723 VGND \$4017 VPWR \$3010 \$4020 sg13cmos5l_a21oi_1
X$2790 \$2302 VGND \$705 VPWR \$1861 \$2021 sg13cmos5l_a21oi_1
X$2791 \$4165 VGND \$3986 VPWR \$3873 \$3803 sg13cmos5l_a21oi_1
X$2792 \$2881 VGND \$3057 VPWR \$3290 \$3291 sg13cmos5l_a21oi_1
X$2793 \$2387 VGND \$2716 VPWR \$2115 \$2652 sg13cmos5l_a21oi_1
X$2794 \$749 VGND \$461 VPWR \$471 \$662 sg13cmos5l_a21oi_1
X$2795 \$955 VGND \$959 VPWR \$611 \$673 sg13cmos5l_a21oi_1
X$2796 \$2219 VGND \$2367 VPWR \$2364 \$2247 sg13cmos5l_a21oi_1
X$4257 VGND \$1748 \$1510 \$1995 \$1277 VPWR sg13cmos5l_dfrbpq_1
X$4258 VGND \$114 \$28 \$180 \$77 VPWR sg13cmos5l_dfrbpq_1
X$4259 VPWR VGND \$74 \$52 \$49 \$66 sg13cmos5l_and3_1
X$4260 VGND \$114 \$101 \$272 \$77 VPWR sg13cmos5l_dfrbpq_1
X$4261 VGND \$69 \$33 \$156 \$79 VPWR sg13cmos5l_dfrbpq_1
X$4262 VPWR VGND \$80 \$156 \$102 \$26 sg13cmos5l_nor3_1
X$4263 VGND \$1699 \$1506 \$1701 \$1277 VPWR sg13cmos5l_dfrbpq_1
X$4264 VGND \$1500 \$1415 \$1458 \$695 VPWR sg13cmos5l_dfrbpq_1
X$4265 VGND \$1699 \$1330 \$1667 \$1630 VPWR sg13cmos5l_dfrbpq_1
X$4266 VGND \$4222 \$3773 \$4010 \$3843 VPWR sg13cmos5l_dfrbpq_1
X$4267 VGND \$1500 \$1318 \$1660 \$1499 VPWR sg13cmos5l_dfrbpq_1
X$4268 VGND \$3704 \$3452 \$3794 \$2358 VPWR sg13cmos5l_dfrbpq_1
X$4269 VGND \$4037 \$4168 \$4329 \$3937 VPWR sg13cmos5l_dfrbpq_1
X$4270 VGND \$4037 \$4129 \$4333 \$3937 VPWR sg13cmos5l_dfrbpq_1
X$4271 VGND \$1748 \$1803 \$2201 \$1277 VPWR sg13cmos5l_dfrbpq_1
X$4272 VGND \$4222 \$3079 \$4187 \$3843 VPWR sg13cmos5l_dfrbpq_1
X$4273 VGND \$4222 \$3707 \$3955 \$2174 VPWR sg13cmos5l_dfrbpq_1
X$4274 VGND \$70 \$372 \$416 \$95 VPWR sg13cmos5l_dfrbpq_1
X$4275 VGND \$1500 \$1121 \$1845 \$1415 VPWR sg13cmos5l_dfrbpq_1
X$4276 VGND \$1543 \$1958 \$2024 \$1630 VPWR sg13cmos5l_dfrbpq_1
X$4277 VGND \$70 \$655 \$937 \$77 VPWR sg13cmos5l_dfrbpq_1
X$4278 VGND \$4037 \$4312 \$4106 \$3937 VPWR sg13cmos5l_dfrbpq_1
X$4279 VGND \$2724 \$2845 \$2596 \$2174 VPWR sg13cmos5l_dfrbpq_1
X$4280 VGND \$4222 \$4342 \$4190 \$3843 VPWR sg13cmos5l_dfrbpq_1
X$4281 VGND \$4222 \$4273 \$4193 \$3843 VPWR sg13cmos5l_dfrbpq_1
X$4282 VGND \$1748 \$2126 \$2085 \$2174 VPWR sg13cmos5l_dfrbpq_1
X$4283 VGND \$1748 \$2534 \$2121 \$2174 VPWR sg13cmos5l_dfrbpq_1
X$4284 VGND \$2531 \$3015 \$2707 \$2174 VPWR sg13cmos5l_dfrbpq_1
X$4285 VGND \$1748 \$2082 \$1978 \$1277 VPWR sg13cmos5l_dfrbpq_1
X$4286 VGND \$1543 \$2104 \$1843 \$1630 VPWR sg13cmos5l_dfrbpq_1
X$4287 VGND \$1748 \$1871 \$1796 \$1630 VPWR sg13cmos5l_dfrbpq_1
X$4288 VGND \$114 \$424 \$512 \$77 VPWR sg13cmos5l_dfrbpq_1
X$4289 \$521 VGND VPWR \$313 \$353 \$470 \$139 sg13cmos5l_a22oi_1
X$4290 VGND \$69 \$104 \$34 \$79 VPWR sg13cmos5l_dfrbpq_1
X$4291 VGND \$1543 \$2116 \$1864 \$1630 VPWR sg13cmos5l_dfrbpq_1
X$4292 VGND \$4222 \$4027 \$4200 \$3843 VPWR sg13cmos5l_dfrbpq_1
X$4293 VGND \$263 \$578 \$932 \$79 VPWR sg13cmos5l_dfrbpq_1
X$4294 VGND \$1748 \$1413 \$1873 \$387 VPWR sg13cmos5l_dfrbpq_1
X$4295 VGND \$70 \$21 \$233 \$77 VPWR sg13cmos5l_dfrbpq_1
X$4296 VGND \$1543 \$1317 \$1734 \$589 VPWR sg13cmos5l_dfrbpq_1
X$4297 VGND \$70 \$93 \$92 \$414 VPWR sg13cmos5l_dfrbpq_1
X$4298 VGND \$70 \$422 \$373 \$372 VPWR sg13cmos5l_dfrbpq_1
X$4299 VGND \$4222 \$4181 \$4338 \$3843 VPWR sg13cmos5l_dfrbpq_1
X$4300 VGND \$4222 \$4137 \$4298 \$3843 VPWR sg13cmos5l_dfrbpq_1
X$4301 VGND \$2531 \$2786 \$3157 \$2358 VPWR sg13cmos5l_dfrbpq_1
X$4302 VGND \$69 \$31 \$163 \$79 VPWR sg13cmos5l_dfrbpq_1
X$4303 VGND \$37 VPWR \$188 \$165 \$190 sg13cmos5l_o21ai_1
X$4304 VGND \$2531 \$3002 \$3646 \$2358 VPWR sg13cmos5l_dfrbpq_1
X$4305 VGND \$1699 \$1287 \$1640 \$1277 VPWR sg13cmos5l_dfrbpq_1
X$4306 VGND \$69 \$30 \$185 \$79 VPWR sg13cmos5l_dfrbpq_1
X$4307 VPWR VGND \$71 \$31 \$72 sg13cmos5l_nor2_1
X$4308 VGND \$1543 \$1299 \$2113 \$1630 VPWR sg13cmos5l_dfrbpq_1
X$4309 VGND \$69 \$84 \$443 \$79 VPWR sg13cmos5l_dfrbpq_1
X$4310 VGND \$4037 \$3473 \$4170 \$3937 VPWR sg13cmos5l_dfrbpq_1
X$4311 VGND \$114 \$95 \$420 \$217 VPWR sg13cmos5l_dfrbpq_1
X$4312 VGND \$4037 \$2955 \$3753 \$3937 VPWR sg13cmos5l_dfrbpq_1
X$4313 VGND \$1543 \$999 \$1723 \$1121 VPWR sg13cmos5l_dfrbpq_1
X$4314 VGND \$3704 \$3364 \$3869 \$2174 VPWR sg13cmos5l_dfrbpq_1
X$4315 VGND \$2531 \$2132 \$2546 \$2174 VPWR sg13cmos5l_dfrbpq_1
X$4316 VGND \$1543 \$930 \$1540 \$999 VPWR sg13cmos5l_dfrbpq_1
X$4317 VGND \$1500 \$736 \$1549 \$77 VPWR sg13cmos5l_dfrbpq_1
X$4318 VGND \$263 \$986 \$1345 \$1277 VPWR sg13cmos5l_dfrbpq_1
X$4319 VGND \$2531 \$2076 \$2527 \$2358 VPWR sg13cmos5l_dfrbpq_1
X$4320 VGND \$2531 \$2161 \$2507 \$2358 VPWR sg13cmos5l_dfrbpq_1
X$4321 VGND \$4037 \$3594 \$3985 \$2358 VPWR sg13cmos5l_dfrbpq_1
X$4322 VGND \$2531 \$2790 \$2741 \$2358 VPWR sg13cmos5l_dfrbpq_1
X$4323 VGND \$69 \$445 \$100 \$79 VPWR sg13cmos5l_dfrbpq_1
X$4324 VGND \$1748 \$1914 \$1805 \$1277 VPWR sg13cmos5l_dfrbpq_1
X$4325 VGND \$4037 \$4291 \$4112 \$3937 VPWR sg13cmos5l_dfrbpq_1
X$4326 VGND \$4037 \$4320 \$4119 \$3937 VPWR sg13cmos5l_dfrbpq_1
X$4327 VGND \$70 \$414 \$415 \$930 VPWR sg13cmos5l_dfrbpq_1
X$4328 VGND \$70 \$217 \$408 \$93 VPWR sg13cmos5l_dfrbpq_1
X$4329 VGND \$1543 \$2065 \$1846 \$1630 VPWR sg13cmos5l_dfrbpq_1
X$4330 VPWR VGND \$46 \$121 sg13cmos5l_dlygate4sd3_1
X$4331 VPWR VGND \$2077 \$2116 sg13cmos5l_dlygate4sd3_1
X$4332 VPWR VGND \$4487 \$4488 sg13cmos5l_dlygate4sd3_1
X$4333 VPWR VGND \$1796 \$2125 sg13cmos5l_dlygate4sd3_1
X$4334 VPWR VGND \$1148 \$1021 sg13cmos5l_dlygate4sd3_1
X$4335 VPWR VGND \$2707 \$2906 sg13cmos5l_dlygate4sd3_1
X$4336 VPWR VGND \$1843 \$2166 sg13cmos5l_dlygate4sd3_1
X$4337 VPWR VGND \$4190 \$4344 sg13cmos5l_dlygate4sd3_1
X$4338 VPWR VGND \$2325 \$2845 sg13cmos5l_dlygate4sd3_1
X$4339 VPWR VGND \$2085 \$2398 sg13cmos5l_dlygate4sd3_1
X$4340 VPWR VGND \$1978 \$2235 sg13cmos5l_dlygate4sd3_1
X$4341 VPWR VGND \$512 \$655 sg13cmos5l_dlygate4sd3_1
X$4342 VGND \$647 \$77 VPWR sg13cmos5l_buf_8
X$4343 VPWR VGND \$1027 \$1506 sg13cmos5l_dlygate4sd3_1
X$4344 VPWR VGND \$2121 \$2317 sg13cmos5l_dlygate4sd3_1
X$4345 VPWR VGND \$953 \$1330 sg13cmos5l_dlygate4sd3_1
X$4346 VPWR VGND \$1864 \$1966 sg13cmos5l_dlygate4sd3_1
X$4347 VPWR VGND \$2021 \$1958 sg13cmos5l_dlygate4sd3_1
X$4348 VPWR VGND \$1805 \$1765 sg13cmos5l_dlygate4sd3_1
X$4349 VPWR VGND \$2164 \$2065 sg13cmos5l_dlygate4sd3_1
X$4350 VPWR VGND \$273 \$84 sg13cmos5l_dlygate4sd3_1
X$4351 VPWR VGND \$4332 \$4129 sg13cmos5l_dlygate4sd3_1
X$4352 VPWR VGND \$4351 \$4286 sg13cmos5l_dlygate4sd3_1
X$4353 VPWR VGND \$2087 \$1914 sg13cmos5l_dlygate4sd3_1
X$4354 VPWR VGND \$3453 \$3452 sg13cmos5l_dlygate4sd3_1
X$4355 VPWR VGND \$1640 \$1618 sg13cmos5l_dlygate4sd3_1
X$4356 VPWR VGND \$2589 \$2534 sg13cmos5l_dlygate4sd3_1
X$4357 VPWR VGND \$3102 \$2786 sg13cmos5l_dlygate4sd3_1
X$4358 VPWR VGND \$4055 \$2955 sg13cmos5l_dlygate4sd3_1
X$4359 VPWR VGND \$2331 \$1803 sg13cmos5l_dlygate4sd3_1
X$4360 VPWR VGND \$4330 \$4168 sg13cmos5l_dlygate4sd3_1
X$4361 VPWR VGND \$2200 \$2082 sg13cmos5l_dlygate4sd3_1
X$4362 VPWR VGND \$4193 \$4192 sg13cmos5l_dlygate4sd3_1
X$4363 VPWR VGND \$4130 \$3079 sg13cmos5l_dlygate4sd3_1
X$4364 VPWR VGND \$2340 \$2132 sg13cmos5l_dlygate4sd3_1
X$4365 VPWR VGND \$2437 \$2161 sg13cmos5l_dlygate4sd3_1
X$4366 VPWR VGND \$4215 \$4243 sg13cmos5l_dlygate4sd3_1
X$4367 VPWR VGND \$1846 \$1960 sg13cmos5l_dlygate4sd3_1
X$4368 VPWR VGND \$1620 \$1803 sg13cmos5l_dlygate4sd3_1
X$4369 VPWR VGND \$1345 \$1147 sg13cmos5l_dlygate4sd3_1
X$4370 VPWR VGND \$2596 \$2387 sg13cmos5l_dlygate4sd3_1
X$4371 VPWR VGND \$82 \$33 sg13cmos5l_dlygate4sd3_1
X$4372 VPWR VGND \$339 \$736 sg13cmos5l_dlygate4sd3_1
X$4373 VPWR VGND \$3662 \$4291 sg13cmos5l_dlygate4sd3_1
X$4374 VPWR VGND \$3914 \$4027 sg13cmos5l_dlygate4sd3_1
X$4375 VPWR VGND \$2622 \$2790 sg13cmos5l_dlygate4sd3_1
X$4376 VPWR VGND \$272 \$424 sg13cmos5l_dlygate4sd3_1
X$4377 VPWR VGND \$272 \$227 \$188 sg13cmos5l_nand2b_1
X$4378 VGND VPWR \$75 \$227 \$272 sg13cmos5l_nor2b_1
X$4379 VPWR VGND \$4119 \$4247 sg13cmos5l_dlygate4sd3_1
X$4380 VPWR VGND \$2165 \$2020 sg13cmos5l_dlygate4sd3_1
X$4381 VPWR VGND \$2024 \$2168 sg13cmos5l_dlygate4sd3_1
X$4382 VPWR VGND \$1860 \$2112 \$298 \$503 \$2227 sg13cmos5l_or4_1
X$4383 VPWR VGND \$3927 \$4320 sg13cmos5l_dlygate4sd3_1
X$4384 VPWR VGND \$1221 \$1299 sg13cmos5l_dlygate4sd3_1
X$4385 VPWR VGND \$29 \$28 sg13cmos5l_dlygate4sd3_1
X$4386 VPWR VGND \$102 \$94 sg13cmos5l_dlygate4sd3_1
X$4387 VPWR VGND \$3483 \$3773 sg13cmos5l_dlygate4sd3_1
X$4388 VPWR VGND \$4176 \$3473 sg13cmos5l_dlygate4sd3_1
X$4389 VPWR VGND \$3390 \$3002 sg13cmos5l_dlygate4sd3_1
X$4390 VPWR VGND \$4106 \$3865 sg13cmos5l_dlygate4sd3_1
X$4391 VPWR VGND \$50 \$30 sg13cmos5l_dlygate4sd3_1
X$4392 VPWR VGND \$2856 \$3015 sg13cmos5l_dlygate4sd3_1
X$4393 VPWR VGND \$1905 \$1871 sg13cmos5l_dlygate4sd3_1
X$4394 VPWR VGND \$448 \$445 sg13cmos5l_dlygate4sd3_1
X$4395 VPWR VGND \$682 \$578 sg13cmos5l_dlygate4sd3_1
X$4396 VPWR VGND \$1568 \$1287 sg13cmos5l_dlygate4sd3_1
X$4397 VPWR VGND \$3923 \$3594 sg13cmos5l_dlygate4sd3_1
X$4398 VPWR VGND \$4298 \$4281 sg13cmos5l_dlygate4sd3_1
X$4399 VPWR VGND \$126 \$55 sg13cmos5l_dlygate4sd3_1
X$4400 VPWR VGND \$169 \$108 sg13cmos5l_dlygate4sd3_1
X$4401 VPWR VGND \$2652 \$2598 sg13cmos5l_dlygate4sd3_1
X$4402 VPWR VGND \$3985 \$3872 sg13cmos5l_dlygate4sd3_1
X$4403 VPWR VGND \$2066 \$2104 sg13cmos5l_dlygate4sd3_1
X$4404 VPWR VGND \$1617 \$1510 sg13cmos5l_dlygate4sd3_1
X$4405 VPWR VGND \$4202 \$4137 sg13cmos5l_dlygate4sd3_1
X$4406 VPWR VGND \$1595 \$1512 sg13cmos5l_dlygate4sd3_1
X$4407 VPWR VGND \$2315 \$2076 sg13cmos5l_dlygate4sd3_1
X$4408 VPWR VGND \$4346 \$4273 sg13cmos5l_dlygate4sd3_1
X$4409 VPWR VGND \$99 \$31 sg13cmos5l_dlygate4sd3_1
X$4410 VPWR VGND \$161 \$104 sg13cmos5l_dlygate4sd3_1
X$4411 VPWR VGND \$1806 \$1762 sg13cmos5l_dlygate4sd3_1
X$4412 VPWR VGND \$1018 \$986 sg13cmos5l_dlygate4sd3_1
X$4413 VPWR VGND \$2343 \$2126 sg13cmos5l_dlygate4sd3_1
X$4414 VPWR VGND \$4334 \$4181 sg13cmos5l_dlygate4sd3_1
X$4415 VPWR VGND \$227 \$101 sg13cmos5l_dlygate4sd3_1
X$4510 VPWR VGND \$573 \$673 \$611 \$467 sg13cmos5l_a21o_1
X$4697 VPWR VGND \$165 \$99 \$66 sg13cmos5l_and2_1
X$5831 VGND \$3430 VPWR \$3707 sg13cmos5l_buf_1
X$5832 VGND \$298 VPWR \$1221 sg13cmos5l_buf_1
X$5833 VGND \$741 VPWR \$2303 sg13cmos5l_buf_1
X$5834 VGND \$3361 VPWR \$3430 sg13cmos5l_buf_1
X$5835 VGND \$1748 VPWR \$1699 sg13cmos5l_buf_1
X$5836 VGND \$3227 VPWR \$2247 sg13cmos5l_buf_1
X$5837 VGND \$4222 VPWR \$3704 sg13cmos5l_buf_1
X$5838 VGND \$1543 VPWR \$1699 sg13cmos5l_buf_1
X$5839 VGND \$2663 VPWR \$2492 sg13cmos5l_buf_1
X$5840 VGND \$3292 VPWR \$3453 sg13cmos5l_buf_1
X$5841 VGND \$1861 VPWR \$2340 sg13cmos5l_buf_1
X$5842 VGND \$4037 VPWR \$3704 sg13cmos5l_buf_1
X$5843 VGND \$3010 VPWR \$3364 sg13cmos5l_buf_1
X$5844 VGND \$3562 VPWR \$4176 sg13cmos5l_buf_1
X$5845 VGND \$114 VPWR \$69 sg13cmos5l_buf_1
X$5846 VGND \$74 VPWR \$50 sg13cmos5l_buf_1
X$5847 VGND \$246 VPWR \$298 sg13cmos5l_buf_1
X$5848 VGND \$3322 VPWR \$2364 sg13cmos5l_buf_1
X$5849 VGND \$70 VPWR \$69 sg13cmos5l_buf_1
X$5850 VGND \$2943 VPWR \$3229 sg13cmos5l_buf_1
X$5851 VGND \$49 VPWR \$29 sg13cmos5l_buf_1
X$5852 VGND \$2639 VPWR \$2490 sg13cmos5l_buf_1
X$5853 VGND \$2879 VPWR \$2786 sg13cmos5l_buf_1
X$5854 VGND \$3365 VPWR \$3483 sg13cmos5l_buf_1
X$5855 VGND \$1048 VPWR \$1027 sg13cmos5l_buf_1
X$5856 VGND \$1699 VPWR \$263 sg13cmos5l_buf_1
X$5857 VGND \$954 VPWR \$953 sg13cmos5l_buf_1
X$5858 VGND \$1138 VPWR \$339 sg13cmos5l_buf_1
X$5859 VGND \$3704 VPWR \$2531 sg13cmos5l_buf_1
X$5860 VGND \$I17734 VPWR \$1499 sg13cmos5l_buf_1
X$5861 VGND \$620 VPWR \$954 sg13cmos5l_buf_1
X$5862 VGND \$I17732 VPWR \$695 sg13cmos5l_buf_1
X$5863 VGND \$2531 VPWR \$2724 sg13cmos5l_buf_1
X$5864 VGND \$I17730 VPWR \$589 sg13cmos5l_buf_1
X$5865 VGND \$1500 VPWR \$1699 sg13cmos5l_buf_1
X$5866 VGND \$705 VPWR \$1056 sg13cmos5l_buf_1
X$5867 VGND \$69 VPWR \$263 sg13cmos5l_buf_1
X$5868 VGND \$263 VPWR \$2724 sg13cmos5l_buf_1
X$5869 VGND \$2535 VPWR \$2610 sg13cmos5l_buf_1
X$5870 VGND \$611 VPWR \$353 sg13cmos5l_buf_1
X$5871 VGND \$899 VPWR \$1048 sg13cmos5l_buf_1
X$5872 VGND \$590 VPWR \$1299 sg13cmos5l_buf_1
X$5873 VGND \$43 VPWR vctrl_in sg13cmos5l_buf_1
X$5874 VPWR VGND \$178 \$74 \$221 sg13cmos5l_nand2_1
X$5875 VGND \$41 VPWR vctrl_b_in sg13cmos5l_buf_1
X$5876 VGND \$419 VPWR \$41 sg13cmos5l_buf_1
X$5877 VGND \$4289 VPWR \$4312 sg13cmos5l_buf_1
X$5878 VGND \$2775 VPWR \$2639 sg13cmos5l_buf_1
X$5879 VGND \$190 VPWR \$161 sg13cmos5l_buf_1
X$5880 VGND \$2375 VPWR \$741 sg13cmos5l_buf_1
X$5881 VGND \$3352 VPWR \$3452 sg13cmos5l_buf_1
X$5882 VGND \$73 VPWR \$75 sg13cmos5l_buf_1
X$5883 VGND \$2724 VPWR rst_n sg13cmos5l_buf_1
X$5884 VGND \$3007 VPWR \$4130 sg13cmos5l_buf_1
X$5885 VGND \$371 VPWR \$339 sg13cmos5l_buf_1
X$5886 VGND \$26 VPWR \$73 sg13cmos5l_buf_1
X$5887 VGND \$3340 VPWR \$3002 sg13cmos5l_buf_1
X$5888 VGND \$2949 VPWR \$4055 sg13cmos5l_buf_1
X$5889 VGND \$2247 VPWR \$2242 sg13cmos5l_buf_1
X$5890 VGND \$3201 VPWR \$2364 sg13cmos5l_buf_1
X$5891 VGND \$2364 VPWR \$2400 sg13cmos5l_buf_1
X$5892 VGND \$2877 VPWR \$2375 sg13cmos5l_buf_1
X$5894 VPWR VGND sg13cmos5l_decap_4
X$5895 VGND \$429 VPWR \$43 sg13cmos5l_buf_1
X$5899 VPWR VGND \$76 \$21 sg13cmos5l_dlygate4sd3_1
X$5900 VGND \$70 \$121 \$27 \$77 VPWR sg13cmos5l_dfrbpq_1
X$5902 \$45 VGND \$52 VPWR \$49 \$26 sg13cmos5l_a21oi_1
X$5903 VPWR VGND sg13cmos5l_decap_8
X$5904 VPWR VGND \$93 \$92 sg13cmos5l_inv_1
X$5906 VPWR VGND sg13cmos5l_decap_4
X$5907 VPWR VGND sg13cmos5l_decap_4
X$5908 VPWR VGND sg13cmos5l_decap_4
X$5909 VPWR VGND sg13cmos5l_decap_4
X$5910 VPWR VGND sg13cmos5l_decap_4
X$5911 VPWR VGND sg13cmos5l_decap_4
X$5912 VPWR VGND sg13cmos5l_decap_4
X$5913 VPWR VGND sg13cmos5l_decap_4
X$5914 VPWR VGND sg13cmos5l_decap_4
X$5915 VPWR VGND sg13cmos5l_decap_4
X$5916 VPWR VGND sg13cmos5l_decap_4
X$5917 VPWR VGND sg13cmos5l_decap_4
X$5918 VPWR VGND sg13cmos5l_decap_4
X$5919 VPWR VGND sg13cmos5l_decap_4
X$5920 VPWR VGND sg13cmos5l_decap_4
X$5921 VPWR VGND sg13cmos5l_decap_4
X$5922 VPWR VGND sg13cmos5l_decap_4
X$5923 VPWR VGND sg13cmos5l_decap_4
X$5924 VPWR VGND sg13cmos5l_decap_4
X$5925 VPWR VGND sg13cmos5l_decap_4
X$5926 VPWR VGND sg13cmos5l_decap_4
X$5927 VPWR VGND sg13cmos5l_decap_4
X$5928 VPWR VGND sg13cmos5l_decap_4
X$5929 VPWR VGND sg13cmos5l_decap_4
X$5930 VPWR VGND sg13cmos5l_decap_4
X$5931 VPWR VGND sg13cmos5l_decap_4
X$5932 VPWR VGND sg13cmos5l_decap_4
X$5934 VPWR VGND sg13cmos5l_decap_4
X$5935 VPWR VGND sg13cmos5l_decap_4
X$5936 VPWR VGND sg13cmos5l_decap_4
X$5937 VPWR VGND sg13cmos5l_decap_4
X$5938 VPWR VGND sg13cmos5l_decap_4
X$5939 VPWR VGND sg13cmos5l_decap_4
X$5940 VPWR VGND sg13cmos5l_decap_4
X$5941 VPWR VGND sg13cmos5l_decap_4
X$5942 VPWR VGND sg13cmos5l_decap_4
X$5943 VPWR VGND sg13cmos5l_decap_4
X$5944 VPWR VGND sg13cmos5l_decap_4
X$5945 VPWR VGND sg13cmos5l_decap_4
X$9687 in_tieon VPWR VGND sg13cmos5l_tiehi
X$10672 in_tieoff VPWR VGND sg13cmos5l_tielo
R$1 VGND \$259 VGND rhigh w=1.78u l=2u ps=0.18u b=2 m=1
M$2 \$336 \$336 \$336 VAPWR sg13_hv_pmos L=0.5u W=12u AS=4.08p AD=4.08p
+ PS=26.04u PD=26.04u rfmode=0
M$3 \$335 \$200 \$336 VAPWR sg13_hv_pmos L=0.5u W=16u AS=5.44p AD=5.44p
+ PS=34.72u PD=34.72u rfmode=0
M$5 \$393 analog_1 \$336 VAPWR sg13_hv_pmos L=0.5u W=16u AS=5.44p AD=5.44p
+ PS=34.72u PD=34.72u rfmode=0
M$7 \$393 \$393 \$393 VAPWR sg13_hv_pmos L=0.5u W=4u AS=1.36p AD=1.36p PS=8.68u
+ PD=8.68u rfmode=0
M$9 \$335 \$335 \$335 VAPWR sg13_hv_pmos L=0.5u W=4u AS=1.36p AD=1.36p PS=8.68u
+ PD=8.68u rfmode=0
R$13 VAPWR \$260 VGND rhigh w=1.78u l=2u ps=0.18u b=9 m=1
R$14 \$918 VAPWR VGND rhigh w=1.78u l=2u ps=0.18u b=9 m=1
R$15 VGND \$200 VGND rhigh w=2u l=12.9u ps=0u b=0 m=1
M$17 \$335 \$335 \$335 VGND sg13_hv_nmos L=0.5u W=2u AS=0.68p AD=0.68p PS=4.68u
+ PD=4.68u rfmode=0
M$18 VGND VGND VGND VGND sg13_hv_nmos L=0.5u W=38.5u AS=13.09p AD=13.09p
+ PS=96.72u PD=96.72u rfmode=0
M$19 \$393 \$393 VGND VGND sg13_hv_nmos L=0.5u W=8u AS=2.72p AD=2.72p PS=18.72u
+ PD=18.72u rfmode=0
M$20 \$335 \$393 VGND VGND sg13_hv_nmos L=0.5u W=8u AS=2.72p AD=2.72p PS=18.72u
+ PD=18.72u rfmode=0
R$22 \$1235 VGND VGND rhigh w=2u l=4.25u ps=0u b=0 m=1
R$24 \$197 VGND VGND rhigh w=1.78u l=2u ps=0.18u b=8 m=1
M$25 \$1351 \$1443 VGND VGND sg13_hv_nmos L=0.5u W=8u AS=2.72p AD=2.72p
+ PS=18.72u PD=18.72u rfmode=0
M$27 \$1443 \$1443 VGND VGND sg13_hv_nmos L=0.5u W=8u AS=2.72p AD=2.72p
+ PS=18.72u PD=18.72u rfmode=0
M$28 \$1351 \$1351 \$1351 VGND sg13_hv_nmos L=0.5u W=2u AS=0.68p AD=0.68p
+ PS=4.68u PD=4.68u rfmode=0
R$31 \$2036 VGND VGND rhigh w=1.78u l=2u ps=0.18u b=8 m=1
M$32 \$2133 \$2133 \$2133 VGND sg13_hv_nmos L=0.5u W=2u AS=0.68p AD=0.68p
+ PS=4.68u PD=4.68u rfmode=0
M$33 \$2135 \$2135 VGND VGND sg13_hv_nmos L=0.5u W=8u AS=2.72p AD=2.72p
+ PS=18.72u PD=18.72u rfmode=0
M$35 \$2133 \$2135 VGND VGND sg13_hv_nmos L=0.5u W=8u AS=2.72p AD=2.72p
+ PS=18.72u PD=18.72u rfmode=0
R$37 \$200 \$1239 VGND rhigh w=2u l=2.8u ps=0u b=0 m=1
M$38 \$1443 analog_1 \$1352 VAPWR sg13_hv_pmos L=0.5u W=16u AS=5.44p AD=5.44p
+ PS=34.72u PD=34.72u rfmode=0
M$40 \$1351 \$1351 \$1351 VAPWR sg13_hv_pmos L=0.5u W=4u AS=1.36p AD=1.36p
+ PS=8.68u PD=8.68u rfmode=0
M$41 \$1351 \$1239 \$1352 VAPWR sg13_hv_pmos L=0.5u W=16u AS=5.44p AD=5.44p
+ PS=34.72u PD=34.72u rfmode=0
M$43 \$1352 \$1352 \$1352 VAPWR sg13_hv_pmos L=0.5u W=12u AS=4.08p AD=4.08p
+ PS=26.04u PD=26.04u rfmode=0
M$45 \$1443 \$1443 \$1443 VAPWR sg13_hv_pmos L=0.5u W=4u AS=1.36p AD=1.36p
+ PS=8.68u PD=8.68u rfmode=0
M$50 \$2136 \$2136 \$2136 VAPWR sg13_hv_pmos L=0.5u W=12u AS=4.08p AD=4.08p
+ PS=26.04u PD=26.04u rfmode=0
M$51 \$2135 analog_1 \$2136 VAPWR sg13_hv_pmos L=0.5u W=16u AS=5.44p AD=5.44p
+ PS=34.72u PD=34.72u rfmode=0
M$53 \$2133 \$2039 \$2136 VAPWR sg13_hv_pmos L=0.5u W=16u AS=5.44p AD=5.44p
+ PS=34.72u PD=34.72u rfmode=0
R$58 VAPWR \$1924 VGND rhigh w=1.78u l=2u ps=0.18u b=9 m=1
R$59 VGND \$2043 VGND rhigh w=1.78u l=2u ps=0.18u b=2 m=1
R$60 VGND \$1450 VGND rhigh w=1.78u l=2u ps=0.18u b=2 m=1
M$61 \$393 \$393 \$393 VGND sg13_hv_nmos L=0.5u W=2u AS=0.68p AD=0.68p PS=4.68u
+ PD=4.68u rfmode=0
M$68 \$1443 \$1443 \$1443 VGND sg13_hv_nmos L=0.5u W=2u AS=0.68p AD=0.68p
+ PS=4.68u PD=4.68u rfmode=0
M$74 \$2135 \$2135 \$2135 VGND sg13_hv_nmos L=0.5u W=2u AS=0.68p AD=0.68p
+ PS=4.68u PD=4.68u rfmode=0
R$77 VGND \$201 VGND rhigh w=1.78u l=2u ps=0.18u b=15 m=1
R$78 VGND \$2041 VGND rhigh w=1.78u l=2u ps=0.18u b=15 m=1
R$79 VGND \$1240 VGND rhigh w=1.78u l=2u ps=0.18u b=15 m=1
R$80 \$1246 VAPWR VGND rhigh w=1.78u l=2u ps=0.18u b=10 m=1
R$81 \$918 analog_2 VGND rhigh w=1.78u l=2u ps=0.18u b=3 m=1
R$82 \$1236 VGND VGND rhigh w=1.78u l=2u ps=0.18u b=8 m=1
M$84 VGND \$1686 \$I24060 VGND sg13_lv_nmos L=0.13u W=0.55u AS=0.14505p
+ AD=0.187p PS=1.15u PD=1.78u rfmode=0
M$85 VGND \$1779 \$I24061 VGND sg13_lv_nmos L=0.13u W=0.74u AS=0.14505p
+ AD=0.1406p PS=1.15u PD=1.12u rfmode=0
M$86 \$I24061 \$I24060 \$1895 VGND sg13_lv_nmos L=0.13u W=0.74u AS=0.1406p
+ AD=0.333p PS=1.12u PD=2.38u rfmode=0
M$87 \$I24060 \$1686 VPWR VPWR sg13_lv_pmos L=0.13u W=0.84u AS=0.2856p
+ AD=0.2198p PS=2.36u PD=1.53u rfmode=0
M$88 VPWR \$1779 \$1895 VPWR sg13_lv_pmos L=0.13u W=1.12u AS=0.2198p AD=0.2128p
+ PS=1.53u PD=1.5u rfmode=0
M$89 \$1895 \$I24060 VPWR VPWR sg13_lv_pmos L=0.13u W=1.12u AS=0.2128p
+ AD=0.3808p PS=1.5u PD=2.92u rfmode=0
M$90 \$1938 \$1893 \$I24064 VGND sg13_lv_nmos L=0.13u W=0.74u AS=0.2516p
+ AD=0.1406p PS=2.16u PD=1.12u rfmode=0
M$91 \$I24064 \$1784 VGND VGND sg13_lv_nmos L=0.13u W=0.74u AS=0.1406p
+ AD=0.2516p PS=1.12u PD=2.16u rfmode=0
M$92 \$1938 \$1782 VGND VGND sg13_lv_nmos L=0.13u W=0.74u AS=0.2516p AD=0.1406p
+ PS=2.16u PD=1.12u rfmode=0
M$93 VGND \$1785 \$I24065 VGND sg13_lv_nmos L=0.13u W=0.74u AS=0.1406p
+ AD=0.1406p PS=1.12u PD=1.12u rfmode=0
M$94 \$I24065 \$2012 \$1938 VGND sg13_lv_nmos L=0.13u W=0.74u AS=0.1406p
+ AD=0.2516p PS=1.12u PD=2.16u rfmode=0
M$95 VPWR \$1893 \$I24063 VPWR sg13_lv_pmos L=0.13u W=1.12u AS=0.3808p
+ AD=0.2128p PS=2.92u PD=1.5u rfmode=0
M$96 \$I24063 \$1784 VPWR VPWR sg13_lv_pmos L=0.13u W=1.12u AS=0.2128p
+ AD=0.3808p PS=1.5u PD=2.92u rfmode=0
M$97 \$1938 \$1782 \$I24062 VPWR sg13_lv_pmos L=0.13u W=1.12u AS=0.3808p
+ AD=0.2128p PS=2.92u PD=1.5u rfmode=0
M$98 \$I24062 \$1785 \$I24063 VPWR sg13_lv_pmos L=0.13u W=1.12u AS=0.2128p
+ AD=0.2128p PS=1.5u PD=1.5u rfmode=0
M$99 \$I24063 \$2012 \$I24062 VPWR sg13_lv_pmos L=0.13u W=1.12u AS=0.2128p
+ AD=0.3808p PS=1.5u PD=2.92u rfmode=0
M$100 \$2262 \$I24066 VGND VGND sg13_lv_nmos L=0.13u W=0.74u AS=0.2351p
+ AD=0.15745p PS=2.16u PD=1.175u rfmode=0
M$101 VGND \$1889 \$I24066 VGND sg13_lv_nmos L=0.13u W=0.64u AS=0.15745p
+ AD=0.1216p PS=1.175u PD=1.02u rfmode=0
M$102 \$I24066 \$1772 \$I24068 VGND sg13_lv_nmos L=0.13u W=0.64u AS=0.1216p
+ AD=0.0816p PS=1.02u PD=0.895u rfmode=0
M$103 \$I24068 \$1888 VGND VGND sg13_lv_nmos L=0.13u W=0.64u AS=0.0816p
+ AD=0.2176p PS=0.895u PD=1.96u rfmode=0
M$104 \$I24066 \$1889 \$I24067 VPWR sg13_lv_pmos L=0.13u W=1u AS=0.35p
+ AD=0.2125p PS=2.7u PD=1.425u rfmode=0
M$105 \$I24067 \$1772 VPWR VPWR sg13_lv_pmos L=0.13u W=1u AS=0.2125p AD=0.19p
+ PS=1.425u PD=1.38u rfmode=0
M$106 VPWR \$1888 \$I24067 VPWR sg13_lv_pmos L=0.13u W=1u AS=0.19p AD=0.34p
+ PS=1.38u PD=2.68u rfmode=0
M$107 \$2262 \$I24066 VPWR VPWR sg13_lv_pmos L=0.13u W=1.12u AS=0.3808p
+ AD=0.3808p PS=2.92u PD=2.92u rfmode=0
M$108 VGND \$1772 \$1684 VGND sg13_lv_nmos L=0.13u W=0.74u AS=0.2516p
+ AD=0.1406p PS=2.16u PD=1.12u rfmode=0
M$109 \$1684 \$2208 VGND VGND sg13_lv_nmos L=0.13u W=0.74u AS=0.1406p
+ AD=0.1406p PS=1.12u PD=1.12u rfmode=0
M$110 VGND \$2097 \$1684 VGND sg13_lv_nmos L=0.13u W=0.74u AS=0.1406p
+ AD=0.1406p PS=1.12u PD=1.12u rfmode=0
M$111 \$1684 \$2420 VGND VGND sg13_lv_nmos L=0.13u W=0.74u AS=0.1406p
+ AD=0.237575p PS=1.12u PD=2.16u rfmode=0
M$112 VPWR \$1772 \$I24070 VPWR sg13_lv_pmos L=0.13u W=1.12u AS=0.3808p
+ AD=0.2128p PS=2.92u PD=1.5u rfmode=0
M$113 \$I24070 \$2208 \$I24069 VPWR sg13_lv_pmos L=0.13u W=1.12u AS=0.2128p
+ AD=0.2128p PS=1.5u PD=1.5u rfmode=0
M$114 \$I24069 \$2097 \$I24071 VPWR sg13_lv_pmos L=0.13u W=1.12u AS=0.2128p
+ AD=0.2128p PS=1.5u PD=1.5u rfmode=0
M$115 \$I24071 \$2420 \$1684 VPWR sg13_lv_pmos L=0.13u W=1.12u AS=0.2128p
+ AD=0.4368p PS=1.5u PD=3.02u rfmode=0
M$116 VGND \$1774 \$2142 VGND sg13_lv_nmos L=0.13u W=0.74u AS=0.2516p
+ AD=0.1406p PS=2.16u PD=1.12u rfmode=0
M$117 \$2142 \$2202 \$I24073 VGND sg13_lv_nmos L=0.13u W=0.74u AS=0.1406p
+ AD=0.1406p PS=1.12u PD=1.12u rfmode=0
M$118 \$I24073 \$2153 VGND VGND sg13_lv_nmos L=0.13u W=0.74u AS=0.1406p
+ AD=0.2516p PS=1.12u PD=2.16u rfmode=0
M$119 \$2142 \$1774 \$I24072 VPWR sg13_lv_pmos L=0.13u W=1.12u AS=0.3808p
+ AD=0.2128p PS=2.92u PD=1.5u rfmode=0
M$120 \$I24072 \$2202 VPWR VPWR sg13_lv_pmos L=0.13u W=1.12u AS=0.2128p
+ AD=0.2128p PS=1.5u PD=1.5u rfmode=0
M$121 VPWR \$2153 \$I24072 VPWR sg13_lv_pmos L=0.13u W=1.12u AS=0.2128p
+ AD=0.3808p PS=1.5u PD=2.92u rfmode=0
M$122 VGND \$2262 \$2203 VGND sg13_lv_nmos L=0.13u W=0.74u AS=0.2516p
+ AD=0.1406p PS=2.16u PD=1.12u rfmode=0
M$123 \$2203 \$1770 \$I24075 VGND sg13_lv_nmos L=0.13u W=0.74u AS=0.1406p
+ AD=0.1406p PS=1.12u PD=1.12u rfmode=0
M$124 \$I24075 \$1771 VGND VGND sg13_lv_nmos L=0.13u W=0.74u AS=0.1406p
+ AD=0.2516p PS=1.12u PD=2.16u rfmode=0
M$125 \$2203 \$2262 \$I24074 VPWR sg13_lv_pmos L=0.13u W=1.12u AS=0.3808p
+ AD=0.2128p PS=2.92u PD=1.5u rfmode=0
M$126 \$I24074 \$1770 VPWR VPWR sg13_lv_pmos L=0.13u W=1.12u AS=0.2128p
+ AD=0.2128p PS=1.5u PD=1.5u rfmode=0
M$127 VPWR \$1771 \$I24074 VPWR sg13_lv_pmos L=0.13u W=1.12u AS=0.2128p
+ AD=0.3808p PS=1.5u PD=2.92u rfmode=0
M$128 VGND \$1683 \$1818 VGND sg13_lv_nmos L=0.13u W=0.74u AS=0.2516p
+ AD=0.1406p PS=2.16u PD=1.12u rfmode=0
M$129 \$1818 \$1681 \$I24077 VGND sg13_lv_nmos L=0.13u W=0.74u AS=0.1406p
+ AD=0.1406p PS=1.12u PD=1.12u rfmode=0
M$130 \$I24077 \$1684 VGND VGND sg13_lv_nmos L=0.13u W=0.74u AS=0.1406p
+ AD=0.2516p PS=1.12u PD=2.16u rfmode=0
M$131 \$1818 \$1683 \$I24076 VPWR sg13_lv_pmos L=0.13u W=1.12u AS=0.3808p
+ AD=0.2128p PS=2.92u PD=1.5u rfmode=0
M$132 \$I24076 \$1681 VPWR VPWR sg13_lv_pmos L=0.13u W=1.12u AS=0.2128p
+ AD=0.2128p PS=1.5u PD=1.5u rfmode=0
M$133 VPWR \$1684 \$I24076 VPWR sg13_lv_pmos L=0.13u W=1.12u AS=0.2128p
+ AD=0.3808p PS=1.5u PD=2.92u rfmode=0
M$134 VGND \$1684 \$I24078 VGND sg13_lv_nmos L=0.13u W=0.55u AS=0.18575p
+ AD=0.187p PS=1.26u PD=1.78u rfmode=0
M$135 VGND \$2014 \$I24080 VGND sg13_lv_nmos L=0.13u W=0.74u AS=0.18575p
+ AD=0.1406p PS=1.26u PD=1.12u rfmode=0
M$136 \$I24080 \$1895 \$I24079 VGND sg13_lv_nmos L=0.13u W=0.74u AS=0.1406p
+ AD=0.1406p PS=1.12u PD=1.12u rfmode=0
M$137 \$I24079 \$I24078 \$1784 VGND sg13_lv_nmos L=0.13u W=0.74u AS=0.1406p
+ AD=0.3404p PS=1.12u PD=2.4u rfmode=0
M$138 \$I24078 \$1684 VPWR VPWR sg13_lv_pmos L=0.13u W=0.84u AS=0.2856p
+ AD=0.2198p PS=2.36u PD=1.53u rfmode=0
M$139 VPWR \$2014 \$1784 VPWR sg13_lv_pmos L=0.13u W=1.12u AS=0.2198p
+ AD=0.2128p PS=1.53u PD=1.5u rfmode=0
M$140 \$1784 \$1895 VPWR VPWR sg13_lv_pmos L=0.13u W=1.12u AS=0.2128p
+ AD=0.2128p PS=1.5u PD=1.5u rfmode=0
M$141 VPWR \$I24078 \$1784 VPWR sg13_lv_pmos L=0.13u W=1.12u AS=0.2128p
+ AD=0.3808p PS=1.5u PD=2.92u rfmode=0
M$142 VGND \$1895 \$I24082 VGND sg13_lv_nmos L=0.13u W=0.74u AS=0.2886p
+ AD=0.1406p PS=2.26u PD=1.12u rfmode=0
M$143 \$I24082 \$2100 \$I24081 VGND sg13_lv_nmos L=0.13u W=0.74u AS=0.1406p
+ AD=0.1406p PS=1.12u PD=1.12u rfmode=0
M$144 \$I24081 \$2094 \$2153 VGND sg13_lv_nmos L=0.13u W=0.74u AS=0.1406p
+ AD=0.2516p PS=1.12u PD=2.16u rfmode=0
M$145 VPWR \$1895 \$2153 VPWR sg13_lv_pmos L=0.13u W=1.12u AS=0.3808p
+ AD=0.2128p PS=2.92u PD=1.5u rfmode=0
M$146 \$2153 \$2100 VPWR VPWR sg13_lv_pmos L=0.13u W=1.12u AS=0.2128p
+ AD=0.2128p PS=1.5u PD=1.5u rfmode=0
M$147 VPWR \$2094 \$2153 VPWR sg13_lv_pmos L=0.13u W=1.12u AS=0.2128p
+ AD=0.3808p PS=1.5u PD=2.92u rfmode=0
M$148 VGND \$1776 \$I24085 VGND sg13_lv_nmos L=0.13u W=0.64u AS=0.2272p
+ AD=0.0784p PS=1.99u PD=0.885u rfmode=0
M$149 \$I24085 \$1778 \$I24084 VGND sg13_lv_nmos L=0.13u W=0.64u AS=0.0784p
+ AD=0.2176p PS=0.885u PD=1.96u rfmode=0
M$150 VGND \$1776 \$I24083 VGND sg13_lv_nmos L=0.13u W=0.74u AS=0.1898p
+ AD=0.2516p PS=1.36u PD=2.16u rfmode=0
M$151 VGND \$1778 \$I24083 VGND sg13_lv_nmos L=0.13u W=0.74u AS=0.1898p
+ AD=0.1406p PS=1.36u PD=1.12u rfmode=0
M$152 \$I24083 \$I24084 \$1779 VGND sg13_lv_nmos L=0.13u W=0.74u AS=0.1406p
+ AD=0.2516p PS=1.12u PD=2.16u rfmode=0
M$153 VPWR \$1776 \$I24084 VPWR sg13_lv_pmos L=0.13u W=0.84u AS=0.4536p
+ AD=0.1596p PS=2.76u PD=1.22u rfmode=0
M$154 VPWR \$1778 \$I24084 VPWR sg13_lv_pmos L=0.13u W=0.84u AS=0.2891p
+ AD=0.1596p PS=1.695u PD=1.22u rfmode=0
M$155 VPWR \$1776 \$I24086 VPWR sg13_lv_pmos L=0.13u W=1.12u AS=0.2891p
+ AD=0.1428p PS=1.695u PD=1.375u rfmode=0
M$156 \$I24086 \$1778 \$1779 VPWR sg13_lv_pmos L=0.13u W=1.12u AS=0.1428p
+ AD=0.2408p PS=1.375u PD=1.55u rfmode=0
M$157 \$1779 \$I24084 VPWR VPWR sg13_lv_pmos L=0.13u W=1.12u AS=0.2408p
+ AD=0.3808p PS=1.55u PD=2.92u rfmode=0
M$158 VGND \$1771 \$I24087 VGND sg13_lv_nmos L=0.13u W=0.55u AS=0.187p
+ AD=0.1045p PS=1.78u PD=0.93u rfmode=0
M$159 \$I24087 \$1889 VGND VGND sg13_lv_nmos L=0.13u W=0.55u AS=0.1045p
+ AD=0.1469p PS=0.93u PD=1.155u rfmode=0
M$160 VGND \$I24087 \$1774 VGND sg13_lv_nmos L=0.13u W=0.74u AS=0.1469p
+ AD=0.2516p PS=1.155u PD=2.16u rfmode=0
M$161 \$I24087 \$1771 \$I24088 VPWR sg13_lv_pmos L=0.13u W=0.84u AS=0.2856p
+ AD=0.1596p PS=2.36u PD=1.22u rfmode=0
M$162 VPWR \$1889 \$I24088 VPWR sg13_lv_pmos L=0.13u W=0.84u AS=0.2226p
+ AD=0.1596p PS=1.535u PD=1.22u rfmode=0
M$163 VPWR \$I24087 \$1774 VPWR sg13_lv_pmos L=0.13u W=1.12u AS=0.2226p
+ AD=0.3976p PS=1.535u PD=2.95u rfmode=0
M$164 \$I24089 \$1686 VGND VGND sg13_lv_nmos L=0.15u W=0.74u AS=0.2516p
+ AD=0.1406p PS=2.16u PD=1.12u rfmode=0
M$165 VGND \$1779 \$I24089 VGND sg13_lv_nmos L=0.15u W=0.74u AS=0.1406p
+ AD=0.1406p PS=1.12u PD=1.12u rfmode=0
M$166 \$I24089 \$1888 \$1771 VGND sg13_lv_nmos L=0.15u W=0.74u AS=0.1406p
+ AD=0.2516p PS=1.12u PD=2.16u rfmode=0
M$167 VPWR \$1686 \$I24090 VPWR sg13_lv_pmos L=0.15u W=1.12u AS=0.3808p
+ AD=0.2128p PS=2.92u PD=1.5u rfmode=0
M$168 \$I24090 \$1779 \$1771 VPWR sg13_lv_pmos L=0.15u W=1.12u AS=0.2128p
+ AD=0.2128p PS=1.5u PD=1.5u rfmode=0
M$169 \$1771 \$1888 VPWR VPWR sg13_lv_pmos L=0.15u W=1.12u AS=0.2128p
+ AD=0.3808p PS=1.5u PD=2.92u rfmode=0
M$170 \$I24091 \$1686 VGND VGND sg13_lv_nmos L=0.15u W=0.74u AS=0.2516p
+ AD=0.1406p PS=2.16u PD=1.12u rfmode=0
M$171 VGND \$1779 \$I24091 VGND sg13_lv_nmos L=0.15u W=0.74u AS=0.1406p
+ AD=0.1406p PS=1.12u PD=1.12u rfmode=0
M$172 \$I24091 \$1682 \$1782 VGND sg13_lv_nmos L=0.15u W=0.74u AS=0.1406p
+ AD=0.2516p PS=1.12u PD=2.16u rfmode=0
M$173 VPWR \$1686 \$I24092 VPWR sg13_lv_pmos L=0.15u W=1.12u AS=0.3808p
+ AD=0.2128p PS=2.92u PD=1.5u rfmode=0
M$174 \$I24092 \$1779 \$1782 VPWR sg13_lv_pmos L=0.15u W=1.12u AS=0.2128p
+ AD=0.2128p PS=1.5u PD=1.5u rfmode=0
M$175 \$1782 \$1682 VPWR VPWR sg13_lv_pmos L=0.15u W=1.12u AS=0.2128p
+ AD=0.3808p PS=1.5u PD=2.92u rfmode=0
M$176 \$I24093 \$2014 VGND VGND sg13_lv_nmos L=0.15u W=0.74u AS=0.2516p
+ AD=0.1406p PS=2.16u PD=1.12u rfmode=0
M$177 VGND \$1686 \$I24093 VGND sg13_lv_nmos L=0.15u W=0.74u AS=0.1406p
+ AD=0.1406p PS=1.12u PD=1.12u rfmode=0
M$178 \$I24093 \$1682 \$2103 VGND sg13_lv_nmos L=0.15u W=0.74u AS=0.1406p
+ AD=0.2516p PS=1.12u PD=2.16u rfmode=0
M$179 VPWR \$2014 \$I24094 VPWR sg13_lv_pmos L=0.15u W=1.12u AS=0.3808p
+ AD=0.2128p PS=2.92u PD=1.5u rfmode=0
M$180 \$I24094 \$1686 \$2103 VPWR sg13_lv_pmos L=0.15u W=1.12u AS=0.2128p
+ AD=0.2128p PS=1.5u PD=1.5u rfmode=0
M$181 \$2103 \$1682 VPWR VPWR sg13_lv_pmos L=0.15u W=1.12u AS=0.2128p
+ AD=0.3808p PS=1.5u PD=2.92u rfmode=0
M$182 \$I24095 \$1776 VGND VGND sg13_lv_nmos L=0.15u W=0.74u AS=0.2516p
+ AD=0.1406p PS=2.16u PD=1.12u rfmode=0
M$183 VGND \$1684 \$I24095 VGND sg13_lv_nmos L=0.15u W=0.74u AS=0.1406p
+ AD=0.1406p PS=1.12u PD=1.12u rfmode=0
M$184 \$I24095 \$1682 \$1683 VGND sg13_lv_nmos L=0.15u W=0.74u AS=0.1406p
+ AD=0.2516p PS=1.12u PD=2.16u rfmode=0
M$185 VPWR \$1776 \$I24096 VPWR sg13_lv_pmos L=0.15u W=1.12u AS=0.3808p
+ AD=0.2128p PS=2.92u PD=1.5u rfmode=0
M$186 \$I24096 \$1684 \$1683 VPWR sg13_lv_pmos L=0.15u W=1.12u AS=0.2128p
+ AD=0.2128p PS=1.5u PD=1.5u rfmode=0
M$187 \$1683 \$1682 VPWR VPWR sg13_lv_pmos L=0.15u W=1.12u AS=0.2128p
+ AD=0.3808p PS=1.5u PD=2.92u rfmode=0
M$188 VGND \$1776 \$548 VGND sg13_lv_nmos L=0.13u W=0.74u AS=0.2516p AD=0.1406p
+ PS=2.16u PD=1.12u rfmode=0
M$189 \$548 \$1686 VGND VGND sg13_lv_nmos L=0.13u W=0.74u AS=0.1406p AD=0.2516p
+ PS=1.12u PD=2.16u rfmode=0
M$190 VPWR \$1776 \$I24097 VPWR sg13_lv_pmos L=0.13u W=1.12u AS=0.4032p
+ AD=0.1176p PS=2.96u PD=1.33u rfmode=0
M$191 \$I24097 \$1686 \$548 VPWR sg13_lv_pmos L=0.13u W=1.12u AS=0.1176p
+ AD=0.3808p PS=1.33u PD=2.92u rfmode=0
M$192 VGND \$1784 \$I24098 VGND sg13_lv_nmos L=0.13u W=0.55u AS=0.17255p
+ AD=0.187p PS=1.25u PD=1.78u rfmode=0
M$193 VGND \$I24098 \$2152 VGND sg13_lv_nmos L=0.13u W=0.74u AS=0.17255p
+ AD=0.1406p PS=1.25u PD=1.12u rfmode=0
M$194 \$2152 \$2102 VGND VGND sg13_lv_nmos L=0.13u W=0.74u AS=0.1406p
+ AD=0.2516p PS=1.12u PD=2.16u rfmode=0
M$195 \$I24098 \$1784 VPWR VPWR sg13_lv_pmos L=0.13u W=0.84u AS=0.2856p
+ AD=0.2618p PS=2.36u PD=1.63u rfmode=0
M$196 VPWR \$I24098 \$I24099 VPWR sg13_lv_pmos L=0.13u W=1.12u AS=0.2618p
+ AD=0.1176p PS=1.63u PD=1.33u rfmode=0
M$197 \$I24099 \$2102 \$2152 VPWR sg13_lv_pmos L=0.13u W=1.12u AS=0.1176p
+ AD=0.3808p PS=1.33u PD=2.92u rfmode=0
M$198 VGND \$1895 \$I24100 VGND sg13_lv_nmos L=0.13u W=0.55u AS=0.17255p
+ AD=0.187p PS=1.25u PD=1.78u rfmode=0
M$199 VGND \$I24100 \$1785 VGND sg13_lv_nmos L=0.13u W=0.74u AS=0.17255p
+ AD=0.1406p PS=1.25u PD=1.12u rfmode=0
M$200 \$1785 \$1684 VGND VGND sg13_lv_nmos L=0.13u W=0.74u AS=0.1406p
+ AD=0.2516p PS=1.12u PD=2.16u rfmode=0
M$201 \$I24100 \$1895 VPWR VPWR sg13_lv_pmos L=0.13u W=0.84u AS=0.2856p
+ AD=0.2618p PS=2.36u PD=1.63u rfmode=0
M$202 VPWR \$I24100 \$I24101 VPWR sg13_lv_pmos L=0.13u W=1.12u AS=0.2618p
+ AD=0.1176p PS=1.63u PD=1.33u rfmode=0
M$203 \$I24101 \$1684 \$1785 VPWR sg13_lv_pmos L=0.13u W=1.12u AS=0.1176p
+ AD=0.3808p PS=1.33u PD=2.92u rfmode=0
M$204 VGND \$1776 \$I24102 VGND sg13_lv_nmos L=0.13u W=0.55u AS=0.17255p
+ AD=0.187p PS=1.25u PD=1.78u rfmode=0
M$205 VGND \$I24102 \$824 VGND sg13_lv_nmos L=0.13u W=0.74u AS=0.17255p
+ AD=0.1406p PS=1.25u PD=1.12u rfmode=0
M$206 \$824 \$1686 VGND VGND sg13_lv_nmos L=0.13u W=0.74u AS=0.1406p AD=0.2516p
+ PS=1.12u PD=2.16u rfmode=0
M$207 \$I24102 \$1776 VPWR VPWR sg13_lv_pmos L=0.13u W=0.84u AS=0.2856p
+ AD=0.2618p PS=2.36u PD=1.63u rfmode=0
M$208 VPWR \$I24102 \$I24103 VPWR sg13_lv_pmos L=0.13u W=1.12u AS=0.2618p
+ AD=0.1176p PS=1.63u PD=1.33u rfmode=0
M$209 \$I24103 \$1686 \$824 VPWR sg13_lv_pmos L=0.13u W=1.12u AS=0.1176p
+ AD=0.3808p PS=1.33u PD=2.92u rfmode=0
M$210 \$I24104 \$2983 VGND VGND sg13_lv_nmos L=0.13u W=2.22u AS=0.5365p
+ AD=0.4218p PS=4.41u PD=3.36u rfmode=0
M$213 VGND \$I24104 \$2009 VGND sg13_lv_nmos L=0.13u W=5.92u AS=1.1248p
+ AD=1.2358p PS=8.96u PD=10u rfmode=0
M$221 \$I24104 \$2983 VPWR VPWR sg13_lv_pmos L=0.13u W=3.36u AS=0.8064p
+ AD=0.6384p PS=5.92u PD=4.5u rfmode=0
M$224 VPWR \$I24104 \$2009 VPWR sg13_lv_pmos L=0.13u W=8.96u AS=1.7024p
+ AD=1.876p PS=12u PD=13.43u rfmode=0
M$232 \$I24105 \$2009 VGND VGND sg13_lv_nmos L=0.13u W=2.22u AS=0.5365p
+ AD=0.4218p PS=4.41u PD=3.36u rfmode=0
M$235 VGND \$I24105 \$1781 VGND sg13_lv_nmos L=0.13u W=5.92u AS=1.1248p
+ AD=1.2358p PS=8.96u PD=10u rfmode=0
M$243 \$I24105 \$2009 VPWR VPWR sg13_lv_pmos L=0.13u W=3.36u AS=0.8064p
+ AD=0.6384p PS=5.92u PD=4.5u rfmode=0
M$246 VPWR \$I24105 \$1781 VPWR sg13_lv_pmos L=0.13u W=8.96u AS=1.7024p
+ AD=1.876p PS=12u PD=13.43u rfmode=0
M$254 \$I24106 clk VGND VGND sg13_lv_nmos L=0.13u W=2.22u AS=0.5365p AD=0.4218p
+ PS=4.41u PD=3.36u rfmode=0
M$257 VGND \$I24106 \$1587 VGND sg13_lv_nmos L=0.13u W=5.92u AS=1.1248p
+ AD=1.2358p PS=8.96u PD=10u rfmode=0
M$265 \$I24106 clk VPWR VPWR sg13_lv_pmos L=0.13u W=3.36u AS=0.8064p AD=0.6384p
+ PS=5.92u PD=4.5u rfmode=0
M$268 VPWR \$I24106 \$1587 VPWR sg13_lv_pmos L=0.13u W=8.96u AS=1.7024p
+ AD=1.876p PS=12u PD=13.43u rfmode=0
M$276 \$I24107 clk VGND VGND sg13_lv_nmos L=0.13u W=2.22u AS=0.5365p AD=0.4218p
+ PS=4.41u PD=3.36u rfmode=0
M$279 VGND \$I24107 \$2983 VGND sg13_lv_nmos L=0.13u W=5.92u AS=1.1248p
+ AD=1.2358p PS=8.96u PD=10u rfmode=0
M$287 \$I24107 clk VPWR VPWR sg13_lv_pmos L=0.13u W=3.36u AS=0.8064p AD=0.6384p
+ PS=5.92u PD=4.5u rfmode=0
M$290 VPWR \$I24107 \$2983 VPWR sg13_lv_pmos L=0.13u W=8.96u AS=1.7024p
+ AD=1.876p PS=12u PD=13.43u rfmode=0
M$298 \$I24108 \$2009 VGND VGND sg13_lv_nmos L=0.13u W=2.22u AS=0.5365p
+ AD=0.4218p PS=4.41u PD=3.36u rfmode=0
M$301 VGND \$I24108 \$1887 VGND sg13_lv_nmos L=0.13u W=5.92u AS=1.1248p
+ AD=1.2358p PS=8.96u PD=10u rfmode=0
M$309 \$I24108 \$2009 VPWR VPWR sg13_lv_pmos L=0.13u W=3.36u AS=0.8064p
+ AD=0.6384p PS=5.92u PD=4.5u rfmode=0
M$312 VPWR \$I24108 \$1887 VPWR sg13_lv_pmos L=0.13u W=8.96u AS=1.7024p
+ AD=1.876p PS=12u PD=13.43u rfmode=0
M$320 \$I24109 \$2009 VGND VGND sg13_lv_nmos L=0.13u W=2.22u AS=0.5365p
+ AD=0.4218p PS=4.41u PD=3.36u rfmode=0
M$323 VGND \$I24109 \$3332 VGND sg13_lv_nmos L=0.13u W=5.92u AS=1.1248p
+ AD=1.2358p PS=8.96u PD=10u rfmode=0
M$331 \$I24109 \$2009 VPWR VPWR sg13_lv_pmos L=0.13u W=3.36u AS=0.8064p
+ AD=0.6384p PS=5.92u PD=4.5u rfmode=0
M$334 VPWR \$I24109 \$3332 VPWR sg13_lv_pmos L=0.13u W=8.96u AS=1.7024p
+ AD=1.876p PS=12u PD=13.43u rfmode=0
M$342 \$I24110 \$2009 VGND VGND sg13_lv_nmos L=0.13u W=2.22u AS=0.5365p
+ AD=0.4218p PS=4.41u PD=3.36u rfmode=0
M$345 VGND \$I24110 \$2357 VGND sg13_lv_nmos L=0.13u W=5.92u AS=1.1248p
+ AD=1.2358p PS=8.96u PD=10u rfmode=0
M$353 \$I24110 \$2009 VPWR VPWR sg13_lv_pmos L=0.13u W=3.36u AS=0.8064p
+ AD=0.6384p PS=5.92u PD=4.5u rfmode=0
M$356 VPWR \$I24110 \$2357 VPWR sg13_lv_pmos L=0.13u W=8.96u AS=1.7024p
+ AD=1.876p PS=12u PD=13.43u rfmode=0
M$364 \$I24111 \$1587 VGND VGND sg13_lv_nmos L=0.13u W=2.22u AS=0.5365p
+ AD=0.4218p PS=4.41u PD=3.36u rfmode=0
M$367 VGND \$I24111 \$1717 VGND sg13_lv_nmos L=0.13u W=5.92u AS=1.1248p
+ AD=1.2358p PS=8.96u PD=10u rfmode=0
M$375 \$I24111 \$1587 VPWR VPWR sg13_lv_pmos L=0.13u W=3.36u AS=0.8064p
+ AD=0.6384p PS=5.92u PD=4.5u rfmode=0
M$378 VPWR \$I24111 \$1717 VPWR sg13_lv_pmos L=0.13u W=8.96u AS=1.7024p
+ AD=1.876p PS=12u PD=13.43u rfmode=0
M$386 \$I24112 \$2097 \$I24113 VGND sg13_lv_nmos L=0.13u W=0.64u AS=0.2176p
+ AD=0.1216p PS=1.96u PD=1.02u rfmode=0
M$387 VGND \$2100 \$I24113 VGND sg13_lv_nmos L=0.13u W=0.64u AS=0.1331p
+ AD=0.1216p PS=1.12u PD=1.02u rfmode=0
M$388 VGND \$I24112 \$2012 VGND sg13_lv_nmos L=0.13u W=0.74u AS=0.1331p
+ AD=0.2516p PS=1.12u PD=2.16u rfmode=0
M$389 VPWR \$2097 \$I24112 VPWR sg13_lv_pmos L=0.13u W=0.84u AS=0.2856p
+ AD=0.1596p PS=2.36u PD=1.22u rfmode=0
M$390 VPWR \$2100 \$I24112 VPWR sg13_lv_pmos L=0.13u W=0.84u AS=0.1918p
+ AD=0.1596p PS=1.5u PD=1.22u rfmode=0
M$391 VPWR \$I24112 \$2012 VPWR sg13_lv_pmos L=0.13u W=1.12u AS=0.1918p
+ AD=0.3808p PS=1.5u PD=2.92u rfmode=0
M$392 \$I24114 \$1682 \$I24115 VGND sg13_lv_nmos L=0.13u W=0.64u AS=0.2176p
+ AD=0.1216p PS=1.96u PD=1.02u rfmode=0
M$393 VGND \$2858 \$I24115 VGND sg13_lv_nmos L=0.13u W=0.64u AS=0.1331p
+ AD=0.1216p PS=1.12u PD=1.02u rfmode=0
M$394 VGND \$I24114 \$1930 VGND sg13_lv_nmos L=0.13u W=0.74u AS=0.1331p
+ AD=0.2516p PS=1.12u PD=2.16u rfmode=0
M$395 VPWR \$1682 \$I24114 VPWR sg13_lv_pmos L=0.13u W=0.84u AS=0.2856p
+ AD=0.1596p PS=2.36u PD=1.22u rfmode=0
M$396 VPWR \$2858 \$I24114 VPWR sg13_lv_pmos L=0.13u W=0.84u AS=0.1918p
+ AD=0.1596p PS=1.5u PD=1.22u rfmode=0
M$397 VPWR \$I24114 \$1930 VPWR sg13_lv_pmos L=0.13u W=1.12u AS=0.1918p
+ AD=0.3808p PS=1.5u PD=2.92u rfmode=0
M$398 \$I24116 \$1682 \$I24117 VGND sg13_lv_nmos L=0.13u W=0.64u AS=0.2176p
+ AD=0.1216p PS=1.96u PD=1.02u rfmode=0
M$399 VGND \$3782 \$I24117 VGND sg13_lv_nmos L=0.13u W=0.64u AS=0.1331p
+ AD=0.1216p PS=1.12u PD=1.02u rfmode=0
M$400 VGND \$I24116 \$3504 VGND sg13_lv_nmos L=0.13u W=0.74u AS=0.1331p
+ AD=0.2516p PS=1.12u PD=2.16u rfmode=0
M$401 VPWR \$1682 \$I24116 VPWR sg13_lv_pmos L=0.13u W=0.84u AS=0.2856p
+ AD=0.1596p PS=2.36u PD=1.22u rfmode=0
M$402 VPWR \$3782 \$I24116 VPWR sg13_lv_pmos L=0.13u W=0.84u AS=0.1918p
+ AD=0.1596p PS=1.5u PD=1.22u rfmode=0
M$403 VPWR \$I24116 \$3504 VPWR sg13_lv_pmos L=0.13u W=1.12u AS=0.1918p
+ AD=0.3808p PS=1.5u PD=2.92u rfmode=0
M$404 \$I24118 \$1682 \$I24119 VGND sg13_lv_nmos L=0.13u W=0.64u AS=0.2176p
+ AD=0.1216p PS=1.96u PD=1.02u rfmode=0
M$405 VGND \$1785 \$I24119 VGND sg13_lv_nmos L=0.13u W=0.64u AS=0.1331p
+ AD=0.1216p PS=1.12u PD=1.02u rfmode=0
M$406 VGND \$I24118 \$1894 VGND sg13_lv_nmos L=0.13u W=0.74u AS=0.1331p
+ AD=0.2516p PS=1.12u PD=2.16u rfmode=0
M$407 VPWR \$1682 \$I24118 VPWR sg13_lv_pmos L=0.13u W=0.84u AS=0.2856p
+ AD=0.1596p PS=2.36u PD=1.22u rfmode=0
M$408 VPWR \$1785 \$I24118 VPWR sg13_lv_pmos L=0.13u W=0.84u AS=0.1918p
+ AD=0.1596p PS=1.5u PD=1.22u rfmode=0
M$409 VPWR \$I24118 \$1894 VPWR sg13_lv_pmos L=0.13u W=1.12u AS=0.1918p
+ AD=0.3808p PS=1.5u PD=2.92u rfmode=0
M$410 \$I24122 \$I24121 \$I24127 VGND sg13_lv_nmos L=0.13u W=0.42u AS=0.1296p
+ AD=0.0798p PS=1.52u PD=0.8u rfmode=0
M$411 \$I24127 \$I24132 \$I24123 VGND sg13_lv_nmos L=0.13u W=0.42u AS=0.0798p
+ AD=0.2373p PS=0.8u PD=1.97u rfmode=0
M$412 \$I24126 \$I24128 VGND VGND sg13_lv_nmos L=0.13u W=0.74u AS=0.2516p
+ AD=0.1406p PS=2.16u PD=1.12u rfmode=0
M$413 VGND \$I24126 \$1686 VGND sg13_lv_nmos L=0.13u W=0.74u AS=0.1406p
+ AD=0.2516p PS=1.12u PD=2.16u rfmode=0
M$414 VGND \$1940 \$I24130 VGND sg13_lv_nmos L=0.13u W=0.42u AS=0.1701p
+ AD=0.0378p PS=1.65u PD=0.6u rfmode=0
M$415 \$I24130 \$I24120 \$I24123 VGND sg13_lv_nmos L=0.13u W=0.42u AS=0.0378p
+ AD=0.1428p PS=0.6u PD=1.52u rfmode=0
M$416 \$I24124 \$I24125 VGND VGND sg13_lv_nmos L=0.13u W=0.42u AS=0.1428p
+ AD=0.0798p PS=1.52u PD=0.8u rfmode=0
M$417 VGND \$1940 \$I24131 VGND sg13_lv_nmos L=0.13u W=0.42u AS=0.0798p
+ AD=0.0378p PS=0.8u PD=0.6u rfmode=0
M$418 \$I24131 \$I24128 \$I24125 VGND sg13_lv_nmos L=0.13u W=0.42u AS=0.0378p
+ AD=0.1428p PS=0.6u PD=1.52u rfmode=0
M$419 VGND \$I24121 \$I24132 VGND sg13_lv_nmos L=0.13u W=0.74u AS=0.317325p
+ AD=0.2516p PS=1.805u PD=2.16u rfmode=0
M$420 VGND \$1781 \$I24121 VGND sg13_lv_nmos L=0.13u W=0.74u AS=0.317325p
+ AD=0.2516p PS=1.805u PD=2.16u rfmode=0
M$421 \$I24122 \$1894 \$I24129 VGND sg13_lv_nmos L=0.13u W=0.42u AS=0.1428p
+ AD=0.0609p PS=1.52u PD=0.71u rfmode=0
M$422 \$I24129 \$1940 VGND VGND sg13_lv_nmos L=0.13u W=0.42u AS=0.0609p
+ AD=0.1626p PS=0.71u PD=1.415u rfmode=0
M$423 VGND \$I24127 \$I24120 VGND sg13_lv_nmos L=0.13u W=0.74u AS=0.1626p
+ AD=0.2516p PS=1.415u PD=2.16u rfmode=0
M$424 \$I24128 \$I24121 \$I24124 VGND sg13_lv_nmos L=0.13u W=0.42u AS=0.12665p
+ AD=0.1428p PS=1.145u PD=1.52u rfmode=0
M$425 \$I24120 \$I24132 \$I24128 VGND sg13_lv_nmos L=0.13u W=0.74u AS=0.3473p
+ AD=0.12665p PS=2.71u PD=1.145u rfmode=0
M$426 \$I24128 \$I24132 \$I24134 VPWR sg13_lv_pmos L=0.13u W=0.42u AS=0.2048p
+ AD=0.09345p PS=1.63u PD=0.865u rfmode=0
M$427 \$I24134 \$I24125 VPWR VPWR sg13_lv_pmos L=0.13u W=0.42u AS=0.09345p
+ AD=0.204p PS=0.865u PD=1.835u rfmode=0
M$428 VPWR \$1940 \$I24125 VPWR sg13_lv_pmos L=0.13u W=0.42u AS=0.204p
+ AD=0.0798p PS=1.835u PD=0.8u rfmode=0
M$429 \$I24125 \$I24128 VPWR VPWR sg13_lv_pmos L=0.13u W=0.42u AS=0.0798p
+ AD=0.4659p PS=0.8u PD=3.65u rfmode=0
M$430 \$I24120 \$I24121 \$I24128 VPWR sg13_lv_pmos L=0.13u W=1u AS=0.34p
+ AD=0.2048p PS=2.68u PD=1.63u rfmode=0
M$431 \$I24126 \$I24128 VPWR VPWR sg13_lv_pmos L=0.13u W=1.12u AS=0.3864p
+ AD=0.2128p PS=2.93u PD=1.5u rfmode=0
M$432 VPWR \$I24126 \$1686 VPWR sg13_lv_pmos L=0.13u W=1.12u AS=0.2128p
+ AD=0.3808p PS=1.5u PD=2.92u rfmode=0
M$433 VPWR \$1894 \$I24122 VPWR sg13_lv_pmos L=0.13u W=0.42u AS=0.1428p
+ AD=0.0798p PS=1.52u PD=0.8u rfmode=0
M$434 VPWR \$1940 \$I24122 VPWR sg13_lv_pmos L=0.13u W=0.42u AS=0.3623875p
+ AD=0.0798p PS=2.605u PD=0.8u rfmode=0
M$435 VPWR \$I24127 \$I24120 VPWR sg13_lv_pmos L=0.13u W=1u AS=0.3623875p
+ AD=0.34p PS=2.605u PD=2.68u rfmode=0
M$436 \$I24132 \$I24121 VPWR VPWR sg13_lv_pmos L=0.13u W=1.12u AS=0.3864p
+ AD=0.41165p PS=2.93u PD=2.12u rfmode=0
M$437 VPWR \$1781 \$I24121 VPWR sg13_lv_pmos L=0.13u W=1.12u AS=0.41165p
+ AD=0.4088p PS=2.12u PD=2.97u rfmode=0
M$438 \$I24127 \$1940 VPWR VPWR sg13_lv_pmos L=0.13u W=0.42u AS=0.147p
+ AD=0.1563p PS=1.54u PD=1.22u rfmode=0
M$439 VPWR \$I24120 \$I24133 VPWR sg13_lv_pmos L=0.13u W=0.42u AS=0.1563p
+ AD=0.063p PS=1.22u PD=0.72u rfmode=0
M$440 \$I24133 \$I24121 \$I24127 VPWR sg13_lv_pmos L=0.13u W=0.42u AS=0.063p
+ AD=0.0798p PS=0.72u PD=0.8u rfmode=0
M$441 \$I24127 \$I24132 \$I24122 VPWR sg13_lv_pmos L=0.13u W=0.42u AS=0.0798p
+ AD=0.1428p PS=0.8u PD=1.52u rfmode=0
M$442 \$I24137 \$I24136 \$I24142 VGND sg13_lv_nmos L=0.13u W=0.42u AS=0.1296p
+ AD=0.0798p PS=1.52u PD=0.8u rfmode=0
M$443 \$I24142 \$I24147 \$I24138 VGND sg13_lv_nmos L=0.13u W=0.42u AS=0.0798p
+ AD=0.2373p PS=0.8u PD=1.97u rfmode=0
M$444 \$I24141 \$I24143 VGND VGND sg13_lv_nmos L=0.13u W=0.74u AS=0.2516p
+ AD=0.1406p PS=2.16u PD=1.12u rfmode=0
M$445 VGND \$I24141 \$766 VGND sg13_lv_nmos L=0.13u W=0.74u AS=0.1406p
+ AD=0.2516p PS=1.12u PD=2.16u rfmode=0
M$446 VGND \$2735 \$I24145 VGND sg13_lv_nmos L=0.13u W=0.42u AS=0.1701p
+ AD=0.0378p PS=1.65u PD=0.6u rfmode=0
M$447 \$I24145 \$I24135 \$I24138 VGND sg13_lv_nmos L=0.13u W=0.42u AS=0.0378p
+ AD=0.1428p PS=0.6u PD=1.52u rfmode=0
M$448 \$I24139 \$I24140 VGND VGND sg13_lv_nmos L=0.13u W=0.42u AS=0.1428p
+ AD=0.0798p PS=1.52u PD=0.8u rfmode=0
M$449 VGND \$2735 \$I24146 VGND sg13_lv_nmos L=0.13u W=0.42u AS=0.0798p
+ AD=0.0378p PS=0.8u PD=0.6u rfmode=0
M$450 \$I24146 \$I24143 \$I24140 VGND sg13_lv_nmos L=0.13u W=0.42u AS=0.0378p
+ AD=0.1428p PS=0.6u PD=1.52u rfmode=0
M$451 VGND \$I24136 \$I24147 VGND sg13_lv_nmos L=0.13u W=0.74u AS=0.317325p
+ AD=0.2516p PS=1.805u PD=2.16u rfmode=0
M$452 VGND \$2357 \$I24136 VGND sg13_lv_nmos L=0.13u W=0.74u AS=0.317325p
+ AD=0.2516p PS=1.805u PD=2.16u rfmode=0
M$453 \$I24137 \$2562 \$I24144 VGND sg13_lv_nmos L=0.13u W=0.42u AS=0.1428p
+ AD=0.0609p PS=1.52u PD=0.71u rfmode=0
M$454 \$I24144 \$2735 VGND VGND sg13_lv_nmos L=0.13u W=0.42u AS=0.0609p
+ AD=0.1626p PS=0.71u PD=1.415u rfmode=0
M$455 VGND \$I24142 \$I24135 VGND sg13_lv_nmos L=0.13u W=0.74u AS=0.1626p
+ AD=0.2516p PS=1.415u PD=2.16u rfmode=0
M$456 \$I24143 \$I24136 \$I24139 VGND sg13_lv_nmos L=0.13u W=0.42u AS=0.12665p
+ AD=0.1428p PS=1.145u PD=1.52u rfmode=0
M$457 \$I24135 \$I24147 \$I24143 VGND sg13_lv_nmos L=0.13u W=0.74u AS=0.3473p
+ AD=0.12665p PS=2.71u PD=1.145u rfmode=0
M$458 \$I24143 \$I24147 \$I24149 VPWR sg13_lv_pmos L=0.13u W=0.42u AS=0.2048p
+ AD=0.09345p PS=1.63u PD=0.865u rfmode=0
M$459 \$I24149 \$I24140 VPWR VPWR sg13_lv_pmos L=0.13u W=0.42u AS=0.09345p
+ AD=0.204p PS=0.865u PD=1.835u rfmode=0
M$460 VPWR \$2735 \$I24140 VPWR sg13_lv_pmos L=0.13u W=0.42u AS=0.204p
+ AD=0.0798p PS=1.835u PD=0.8u rfmode=0
M$461 \$I24140 \$I24143 VPWR VPWR sg13_lv_pmos L=0.13u W=0.42u AS=0.0798p
+ AD=0.4659p PS=0.8u PD=3.65u rfmode=0
M$462 \$I24135 \$I24136 \$I24143 VPWR sg13_lv_pmos L=0.13u W=1u AS=0.34p
+ AD=0.2048p PS=2.68u PD=1.63u rfmode=0
M$463 \$I24141 \$I24143 VPWR VPWR sg13_lv_pmos L=0.13u W=1.12u AS=0.3864p
+ AD=0.2128p PS=2.93u PD=1.5u rfmode=0
M$464 VPWR \$I24141 \$766 VPWR sg13_lv_pmos L=0.13u W=1.12u AS=0.2128p
+ AD=0.3808p PS=1.5u PD=2.92u rfmode=0
M$465 VPWR \$2562 \$I24137 VPWR sg13_lv_pmos L=0.13u W=0.42u AS=0.1428p
+ AD=0.0798p PS=1.52u PD=0.8u rfmode=0
M$466 VPWR \$2735 \$I24137 VPWR sg13_lv_pmos L=0.13u W=0.42u AS=0.3623875p
+ AD=0.0798p PS=2.605u PD=0.8u rfmode=0
M$467 VPWR \$I24142 \$I24135 VPWR sg13_lv_pmos L=0.13u W=1u AS=0.3623875p
+ AD=0.34p PS=2.605u PD=2.68u rfmode=0
M$468 \$I24147 \$I24136 VPWR VPWR sg13_lv_pmos L=0.13u W=1.12u AS=0.3864p
+ AD=0.41165p PS=2.93u PD=2.12u rfmode=0
M$469 VPWR \$2357 \$I24136 VPWR sg13_lv_pmos L=0.13u W=1.12u AS=0.41165p
+ AD=0.4088p PS=2.12u PD=2.97u rfmode=0
M$470 \$I24142 \$2735 VPWR VPWR sg13_lv_pmos L=0.13u W=0.42u AS=0.147p
+ AD=0.1563p PS=1.54u PD=1.22u rfmode=0
M$471 VPWR \$I24135 \$I24148 VPWR sg13_lv_pmos L=0.13u W=0.42u AS=0.1563p
+ AD=0.063p PS=1.22u PD=0.72u rfmode=0
M$472 \$I24148 \$I24136 \$I24142 VPWR sg13_lv_pmos L=0.13u W=0.42u AS=0.063p
+ AD=0.0798p PS=0.72u PD=0.8u rfmode=0
M$473 \$I24142 \$I24147 \$I24137 VPWR sg13_lv_pmos L=0.13u W=0.42u AS=0.0798p
+ AD=0.1428p PS=0.8u PD=1.52u rfmode=0
M$474 \$I24152 \$I24151 \$I24157 VGND sg13_lv_nmos L=0.13u W=0.42u AS=0.1296p
+ AD=0.0798p PS=1.52u PD=0.8u rfmode=0
M$475 \$I24157 \$I24162 \$I24153 VGND sg13_lv_nmos L=0.13u W=0.42u AS=0.0798p
+ AD=0.2373p PS=0.8u PD=1.97u rfmode=0
M$476 \$I24156 \$I24158 VGND VGND sg13_lv_nmos L=0.13u W=0.74u AS=0.2516p
+ AD=0.1406p PS=2.16u PD=1.12u rfmode=0
M$477 VGND \$I24156 \$2100 VGND sg13_lv_nmos L=0.13u W=0.74u AS=0.1406p
+ AD=0.2516p PS=1.12u PD=2.16u rfmode=0
M$478 VGND \$2273 \$I24160 VGND sg13_lv_nmos L=0.13u W=0.42u AS=0.1701p
+ AD=0.0378p PS=1.65u PD=0.6u rfmode=0
M$479 \$I24160 \$I24150 \$I24153 VGND sg13_lv_nmos L=0.13u W=0.42u AS=0.0378p
+ AD=0.1428p PS=0.6u PD=1.52u rfmode=0
M$480 \$I24154 \$I24155 VGND VGND sg13_lv_nmos L=0.13u W=0.42u AS=0.1428p
+ AD=0.0798p PS=1.52u PD=0.8u rfmode=0
M$481 VGND \$2273 \$I24161 VGND sg13_lv_nmos L=0.13u W=0.42u AS=0.0798p
+ AD=0.0378p PS=0.8u PD=0.6u rfmode=0
M$482 \$I24161 \$I24158 \$I24155 VGND sg13_lv_nmos L=0.13u W=0.42u AS=0.0378p
+ AD=0.1428p PS=0.6u PD=1.52u rfmode=0
M$483 VGND \$I24151 \$I24162 VGND sg13_lv_nmos L=0.13u W=0.74u AS=0.317325p
+ AD=0.2516p PS=1.805u PD=2.16u rfmode=0
M$484 VGND \$1781 \$I24151 VGND sg13_lv_nmos L=0.13u W=0.74u AS=0.317325p
+ AD=0.2516p PS=1.805u PD=2.16u rfmode=0
M$485 \$I24152 \$2152 \$I24159 VGND sg13_lv_nmos L=0.13u W=0.42u AS=0.1428p
+ AD=0.0609p PS=1.52u PD=0.71u rfmode=0
M$486 \$I24159 \$2273 VGND VGND sg13_lv_nmos L=0.13u W=0.42u AS=0.0609p
+ AD=0.1626p PS=0.71u PD=1.415u rfmode=0
M$487 VGND \$I24157 \$I24150 VGND sg13_lv_nmos L=0.13u W=0.74u AS=0.1626p
+ AD=0.2516p PS=1.415u PD=2.16u rfmode=0
M$488 \$I24158 \$I24151 \$I24154 VGND sg13_lv_nmos L=0.13u W=0.42u AS=0.12665p
+ AD=0.1428p PS=1.145u PD=1.52u rfmode=0
M$489 \$I24150 \$I24162 \$I24158 VGND sg13_lv_nmos L=0.13u W=0.74u AS=0.3473p
+ AD=0.12665p PS=2.71u PD=1.145u rfmode=0
M$490 \$I24158 \$I24162 \$I24164 VPWR sg13_lv_pmos L=0.13u W=0.42u AS=0.2048p
+ AD=0.09345p PS=1.63u PD=0.865u rfmode=0
M$491 \$I24164 \$I24155 VPWR VPWR sg13_lv_pmos L=0.13u W=0.42u AS=0.09345p
+ AD=0.204p PS=0.865u PD=1.835u rfmode=0
M$492 VPWR \$2273 \$I24155 VPWR sg13_lv_pmos L=0.13u W=0.42u AS=0.204p
+ AD=0.0798p PS=1.835u PD=0.8u rfmode=0
M$493 \$I24155 \$I24158 VPWR VPWR sg13_lv_pmos L=0.13u W=0.42u AS=0.0798p
+ AD=0.4659p PS=0.8u PD=3.65u rfmode=0
M$494 \$I24150 \$I24151 \$I24158 VPWR sg13_lv_pmos L=0.13u W=1u AS=0.34p
+ AD=0.2048p PS=2.68u PD=1.63u rfmode=0
M$495 \$I24156 \$I24158 VPWR VPWR sg13_lv_pmos L=0.13u W=1.12u AS=0.3864p
+ AD=0.2128p PS=2.93u PD=1.5u rfmode=0
M$496 VPWR \$I24156 \$2100 VPWR sg13_lv_pmos L=0.13u W=1.12u AS=0.2128p
+ AD=0.3808p PS=1.5u PD=2.92u rfmode=0
M$497 VPWR \$2152 \$I24152 VPWR sg13_lv_pmos L=0.13u W=0.42u AS=0.1428p
+ AD=0.0798p PS=1.52u PD=0.8u rfmode=0
M$498 VPWR \$2273 \$I24152 VPWR sg13_lv_pmos L=0.13u W=0.42u AS=0.3623875p
+ AD=0.0798p PS=2.605u PD=0.8u rfmode=0
M$499 VPWR \$I24157 \$I24150 VPWR sg13_lv_pmos L=0.13u W=1u AS=0.3623875p
+ AD=0.34p PS=2.605u PD=2.68u rfmode=0
M$500 \$I24162 \$I24151 VPWR VPWR sg13_lv_pmos L=0.13u W=1.12u AS=0.3864p
+ AD=0.41165p PS=2.93u PD=2.12u rfmode=0
M$501 VPWR \$1781 \$I24151 VPWR sg13_lv_pmos L=0.13u W=1.12u AS=0.41165p
+ AD=0.4088p PS=2.12u PD=2.97u rfmode=0
M$502 \$I24157 \$2273 VPWR VPWR sg13_lv_pmos L=0.13u W=0.42u AS=0.147p
+ AD=0.1563p PS=1.54u PD=1.22u rfmode=0
M$503 VPWR \$I24150 \$I24163 VPWR sg13_lv_pmos L=0.13u W=0.42u AS=0.1563p
+ AD=0.063p PS=1.22u PD=0.72u rfmode=0
M$504 \$I24163 \$I24151 \$I24157 VPWR sg13_lv_pmos L=0.13u W=0.42u AS=0.063p
+ AD=0.0798p PS=0.72u PD=0.8u rfmode=0
M$505 \$I24157 \$I24162 \$I24152 VPWR sg13_lv_pmos L=0.13u W=0.42u AS=0.0798p
+ AD=0.1428p PS=0.8u PD=1.52u rfmode=0
M$506 \$I24167 \$I24166 \$I24172 VGND sg13_lv_nmos L=0.13u W=0.42u AS=0.1296p
+ AD=0.0798p PS=1.52u PD=0.8u rfmode=0
M$507 \$I24172 \$I24177 \$I24168 VGND sg13_lv_nmos L=0.13u W=0.42u AS=0.0798p
+ AD=0.2373p PS=0.8u PD=1.97u rfmode=0
M$508 \$I24171 \$I24173 VGND VGND sg13_lv_nmos L=0.13u W=0.74u AS=0.2516p
+ AD=0.1406p PS=2.16u PD=1.12u rfmode=0
M$509 VGND \$I24171 \$2411 VGND sg13_lv_nmos L=0.13u W=0.74u AS=0.1406p
+ AD=0.2516p PS=1.12u PD=2.16u rfmode=0
M$510 VGND \$4102 \$I24175 VGND sg13_lv_nmos L=0.13u W=0.42u AS=0.1701p
+ AD=0.0378p PS=1.65u PD=0.6u rfmode=0
M$511 \$I24175 \$I24165 \$I24168 VGND sg13_lv_nmos L=0.13u W=0.42u AS=0.0378p
+ AD=0.1428p PS=0.6u PD=1.52u rfmode=0
M$512 \$I24169 \$I24170 VGND VGND sg13_lv_nmos L=0.13u W=0.42u AS=0.1428p
+ AD=0.0798p PS=1.52u PD=0.8u rfmode=0
M$513 VGND \$4102 \$I24176 VGND sg13_lv_nmos L=0.13u W=0.42u AS=0.0798p
+ AD=0.0378p PS=0.8u PD=0.6u rfmode=0
M$514 \$I24176 \$I24173 \$I24170 VGND sg13_lv_nmos L=0.13u W=0.42u AS=0.0378p
+ AD=0.1428p PS=0.6u PD=1.52u rfmode=0
M$515 VGND \$I24166 \$I24177 VGND sg13_lv_nmos L=0.13u W=0.74u AS=0.317325p
+ AD=0.2516p PS=1.805u PD=2.16u rfmode=0
M$516 VGND \$3332 \$I24166 VGND sg13_lv_nmos L=0.13u W=0.74u AS=0.317325p
+ AD=0.2516p PS=1.805u PD=2.16u rfmode=0
M$517 \$I24167 \$4103 \$I24174 VGND sg13_lv_nmos L=0.13u W=0.42u AS=0.1428p
+ AD=0.0609p PS=1.52u PD=0.71u rfmode=0
M$518 \$I24174 \$4102 VGND VGND sg13_lv_nmos L=0.13u W=0.42u AS=0.0609p
+ AD=0.1626p PS=0.71u PD=1.415u rfmode=0
M$519 VGND \$I24172 \$I24165 VGND sg13_lv_nmos L=0.13u W=0.74u AS=0.1626p
+ AD=0.2516p PS=1.415u PD=2.16u rfmode=0
M$520 \$I24173 \$I24166 \$I24169 VGND sg13_lv_nmos L=0.13u W=0.42u AS=0.12665p
+ AD=0.1428p PS=1.145u PD=1.52u rfmode=0
M$521 \$I24165 \$I24177 \$I24173 VGND sg13_lv_nmos L=0.13u W=0.74u AS=0.3473p
+ AD=0.12665p PS=2.71u PD=1.145u rfmode=0
M$522 \$I24173 \$I24177 \$I24179 VPWR sg13_lv_pmos L=0.13u W=0.42u AS=0.2048p
+ AD=0.09345p PS=1.63u PD=0.865u rfmode=0
M$523 \$I24179 \$I24170 VPWR VPWR sg13_lv_pmos L=0.13u W=0.42u AS=0.09345p
+ AD=0.204p PS=0.865u PD=1.835u rfmode=0
M$524 VPWR \$4102 \$I24170 VPWR sg13_lv_pmos L=0.13u W=0.42u AS=0.204p
+ AD=0.0798p PS=1.835u PD=0.8u rfmode=0
M$525 \$I24170 \$I24173 VPWR VPWR sg13_lv_pmos L=0.13u W=0.42u AS=0.0798p
+ AD=0.4659p PS=0.8u PD=3.65u rfmode=0
M$526 \$I24165 \$I24166 \$I24173 VPWR sg13_lv_pmos L=0.13u W=1u AS=0.34p
+ AD=0.2048p PS=2.68u PD=1.63u rfmode=0
M$527 \$I24171 \$I24173 VPWR VPWR sg13_lv_pmos L=0.13u W=1.12u AS=0.3864p
+ AD=0.2128p PS=2.93u PD=1.5u rfmode=0
M$528 VPWR \$I24171 \$2411 VPWR sg13_lv_pmos L=0.13u W=1.12u AS=0.2128p
+ AD=0.3808p PS=1.5u PD=2.92u rfmode=0
M$529 VPWR \$4103 \$I24167 VPWR sg13_lv_pmos L=0.13u W=0.42u AS=0.1428p
+ AD=0.0798p PS=1.52u PD=0.8u rfmode=0
M$530 VPWR \$4102 \$I24167 VPWR sg13_lv_pmos L=0.13u W=0.42u AS=0.3623875p
+ AD=0.0798p PS=2.605u PD=0.8u rfmode=0
M$531 VPWR \$I24172 \$I24165 VPWR sg13_lv_pmos L=0.13u W=1u AS=0.3623875p
+ AD=0.34p PS=2.605u PD=2.68u rfmode=0
M$532 \$I24177 \$I24166 VPWR VPWR sg13_lv_pmos L=0.13u W=1.12u AS=0.3864p
+ AD=0.41165p PS=2.93u PD=2.12u rfmode=0
M$533 VPWR \$3332 \$I24166 VPWR sg13_lv_pmos L=0.13u W=1.12u AS=0.41165p
+ AD=0.4088p PS=2.12u PD=2.97u rfmode=0
M$534 \$I24172 \$4102 VPWR VPWR sg13_lv_pmos L=0.13u W=0.42u AS=0.147p
+ AD=0.1563p PS=1.54u PD=1.22u rfmode=0
M$535 VPWR \$I24165 \$I24178 VPWR sg13_lv_pmos L=0.13u W=0.42u AS=0.1563p
+ AD=0.063p PS=1.22u PD=0.72u rfmode=0
M$536 \$I24178 \$I24166 \$I24172 VPWR sg13_lv_pmos L=0.13u W=0.42u AS=0.063p
+ AD=0.0798p PS=0.72u PD=0.8u rfmode=0
M$537 \$I24172 \$I24177 \$I24167 VPWR sg13_lv_pmos L=0.13u W=0.42u AS=0.0798p
+ AD=0.1428p PS=0.8u PD=1.52u rfmode=0
M$538 \$I24182 \$I24181 \$I24187 VGND sg13_lv_nmos L=0.13u W=0.42u AS=0.1296p
+ AD=0.0798p PS=1.52u PD=0.8u rfmode=0
M$539 \$I24187 \$I24192 \$I24183 VGND sg13_lv_nmos L=0.13u W=0.42u AS=0.0798p
+ AD=0.2373p PS=0.8u PD=1.97u rfmode=0
M$540 \$I24186 \$I24188 VGND VGND sg13_lv_nmos L=0.13u W=0.74u AS=0.2516p
+ AD=0.1406p PS=2.16u PD=1.12u rfmode=0
M$541 VGND \$I24186 \$4148 VGND sg13_lv_nmos L=0.13u W=0.74u AS=0.1406p
+ AD=0.2516p PS=1.12u PD=2.16u rfmode=0
M$542 VGND \$4208 \$I24190 VGND sg13_lv_nmos L=0.13u W=0.42u AS=0.1701p
+ AD=0.0378p PS=1.65u PD=0.6u rfmode=0
M$543 \$I24190 \$I24180 \$I24183 VGND sg13_lv_nmos L=0.13u W=0.42u AS=0.0378p
+ AD=0.1428p PS=0.6u PD=1.52u rfmode=0
M$544 \$I24184 \$I24185 VGND VGND sg13_lv_nmos L=0.13u W=0.42u AS=0.1428p
+ AD=0.0798p PS=1.52u PD=0.8u rfmode=0
M$545 VGND \$4208 \$I24191 VGND sg13_lv_nmos L=0.13u W=0.42u AS=0.0798p
+ AD=0.0378p PS=0.8u PD=0.6u rfmode=0
M$546 \$I24191 \$I24188 \$I24185 VGND sg13_lv_nmos L=0.13u W=0.42u AS=0.0378p
+ AD=0.1428p PS=0.6u PD=1.52u rfmode=0
M$547 VGND \$I24181 \$I24192 VGND sg13_lv_nmos L=0.13u W=0.74u AS=0.317325p
+ AD=0.2516p PS=1.805u PD=2.16u rfmode=0
M$548 VGND \$3332 \$I24181 VGND sg13_lv_nmos L=0.13u W=0.74u AS=0.317325p
+ AD=0.2516p PS=1.805u PD=2.16u rfmode=0
M$549 \$I24182 \$4503 \$I24189 VGND sg13_lv_nmos L=0.13u W=0.42u AS=0.1428p
+ AD=0.0609p PS=1.52u PD=0.71u rfmode=0
M$550 \$I24189 \$4208 VGND VGND sg13_lv_nmos L=0.13u W=0.42u AS=0.0609p
+ AD=0.1626p PS=0.71u PD=1.415u rfmode=0
M$551 VGND \$I24187 \$I24180 VGND sg13_lv_nmos L=0.13u W=0.74u AS=0.1626p
+ AD=0.2516p PS=1.415u PD=2.16u rfmode=0
M$552 \$I24188 \$I24181 \$I24184 VGND sg13_lv_nmos L=0.13u W=0.42u AS=0.12665p
+ AD=0.1428p PS=1.145u PD=1.52u rfmode=0
M$553 \$I24180 \$I24192 \$I24188 VGND sg13_lv_nmos L=0.13u W=0.74u AS=0.3473p
+ AD=0.12665p PS=2.71u PD=1.145u rfmode=0
M$554 \$I24188 \$I24192 \$I24194 VPWR sg13_lv_pmos L=0.13u W=0.42u AS=0.2048p
+ AD=0.09345p PS=1.63u PD=0.865u rfmode=0
M$555 \$I24194 \$I24185 VPWR VPWR sg13_lv_pmos L=0.13u W=0.42u AS=0.09345p
+ AD=0.204p PS=0.865u PD=1.835u rfmode=0
M$556 VPWR \$4208 \$I24185 VPWR sg13_lv_pmos L=0.13u W=0.42u AS=0.204p
+ AD=0.0798p PS=1.835u PD=0.8u rfmode=0
M$557 \$I24185 \$I24188 VPWR VPWR sg13_lv_pmos L=0.13u W=0.42u AS=0.0798p
+ AD=0.4659p PS=0.8u PD=3.65u rfmode=0
M$558 \$I24180 \$I24181 \$I24188 VPWR sg13_lv_pmos L=0.13u W=1u AS=0.34p
+ AD=0.2048p PS=2.68u PD=1.63u rfmode=0
M$559 \$I24186 \$I24188 VPWR VPWR sg13_lv_pmos L=0.13u W=1.12u AS=0.3864p
+ AD=0.2128p PS=2.93u PD=1.5u rfmode=0
M$560 VPWR \$I24186 \$4148 VPWR sg13_lv_pmos L=0.13u W=1.12u AS=0.2128p
+ AD=0.3808p PS=1.5u PD=2.92u rfmode=0
M$561 VPWR \$4503 \$I24182 VPWR sg13_lv_pmos L=0.13u W=0.42u AS=0.1428p
+ AD=0.0798p PS=1.52u PD=0.8u rfmode=0
M$562 VPWR \$4208 \$I24182 VPWR sg13_lv_pmos L=0.13u W=0.42u AS=0.3623875p
+ AD=0.0798p PS=2.605u PD=0.8u rfmode=0
M$563 VPWR \$I24187 \$I24180 VPWR sg13_lv_pmos L=0.13u W=1u AS=0.3623875p
+ AD=0.34p PS=2.605u PD=2.68u rfmode=0
M$564 \$I24192 \$I24181 VPWR VPWR sg13_lv_pmos L=0.13u W=1.12u AS=0.3864p
+ AD=0.41165p PS=2.93u PD=2.12u rfmode=0
M$565 VPWR \$3332 \$I24181 VPWR sg13_lv_pmos L=0.13u W=1.12u AS=0.41165p
+ AD=0.4088p PS=2.12u PD=2.97u rfmode=0
M$566 \$I24187 \$4208 VPWR VPWR sg13_lv_pmos L=0.13u W=0.42u AS=0.147p
+ AD=0.1563p PS=1.54u PD=1.22u rfmode=0
M$567 VPWR \$I24180 \$I24193 VPWR sg13_lv_pmos L=0.13u W=0.42u AS=0.1563p
+ AD=0.063p PS=1.22u PD=0.72u rfmode=0
M$568 \$I24193 \$I24181 \$I24187 VPWR sg13_lv_pmos L=0.13u W=0.42u AS=0.063p
+ AD=0.0798p PS=0.72u PD=0.8u rfmode=0
M$569 \$I24187 \$I24192 \$I24182 VPWR sg13_lv_pmos L=0.13u W=0.42u AS=0.0798p
+ AD=0.1428p PS=0.8u PD=1.52u rfmode=0
M$570 \$I24197 \$I24196 \$I24202 VGND sg13_lv_nmos L=0.13u W=0.42u AS=0.1296p
+ AD=0.0798p PS=1.52u PD=0.8u rfmode=0
M$571 \$I24202 \$I24207 \$I24198 VGND sg13_lv_nmos L=0.13u W=0.42u AS=0.0798p
+ AD=0.2373p PS=0.8u PD=1.97u rfmode=0
M$572 \$I24201 \$I24203 VGND VGND sg13_lv_nmos L=0.13u W=0.74u AS=0.2516p
+ AD=0.1406p PS=2.16u PD=1.12u rfmode=0
M$573 VGND \$I24201 \$2616 VGND sg13_lv_nmos L=0.13u W=0.74u AS=0.1406p
+ AD=0.2516p PS=1.12u PD=2.16u rfmode=0
M$574 VGND \$2734 \$I24205 VGND sg13_lv_nmos L=0.13u W=0.42u AS=0.1701p
+ AD=0.0378p PS=1.65u PD=0.6u rfmode=0
M$575 \$I24205 \$I24195 \$I24198 VGND sg13_lv_nmos L=0.13u W=0.42u AS=0.0378p
+ AD=0.1428p PS=0.6u PD=1.52u rfmode=0
M$576 \$I24199 \$I24200 VGND VGND sg13_lv_nmos L=0.13u W=0.42u AS=0.1428p
+ AD=0.0798p PS=1.52u PD=0.8u rfmode=0
M$577 VGND \$2734 \$I24206 VGND sg13_lv_nmos L=0.13u W=0.42u AS=0.0798p
+ AD=0.0378p PS=0.8u PD=0.6u rfmode=0
M$578 \$I24206 \$I24203 \$I24200 VGND sg13_lv_nmos L=0.13u W=0.42u AS=0.0378p
+ AD=0.1428p PS=0.6u PD=1.52u rfmode=0
M$579 VGND \$I24196 \$I24207 VGND sg13_lv_nmos L=0.13u W=0.74u AS=0.317325p
+ AD=0.2516p PS=1.805u PD=2.16u rfmode=0
M$580 VGND \$2357 \$I24196 VGND sg13_lv_nmos L=0.13u W=0.74u AS=0.317325p
+ AD=0.2516p PS=1.805u PD=2.16u rfmode=0
M$581 \$I24197 \$2915 \$I24204 VGND sg13_lv_nmos L=0.13u W=0.42u AS=0.1428p
+ AD=0.0609p PS=1.52u PD=0.71u rfmode=0
M$582 \$I24204 \$2734 VGND VGND sg13_lv_nmos L=0.13u W=0.42u AS=0.0609p
+ AD=0.1626p PS=0.71u PD=1.415u rfmode=0
M$583 VGND \$I24202 \$I24195 VGND sg13_lv_nmos L=0.13u W=0.74u AS=0.1626p
+ AD=0.2516p PS=1.415u PD=2.16u rfmode=0
M$584 \$I24203 \$I24196 \$I24199 VGND sg13_lv_nmos L=0.13u W=0.42u AS=0.12665p
+ AD=0.1428p PS=1.145u PD=1.52u rfmode=0
M$585 \$I24195 \$I24207 \$I24203 VGND sg13_lv_nmos L=0.13u W=0.74u AS=0.3473p
+ AD=0.12665p PS=2.71u PD=1.145u rfmode=0
M$586 \$I24203 \$I24207 \$I24209 VPWR sg13_lv_pmos L=0.13u W=0.42u AS=0.2048p
+ AD=0.09345p PS=1.63u PD=0.865u rfmode=0
M$587 \$I24209 \$I24200 VPWR VPWR sg13_lv_pmos L=0.13u W=0.42u AS=0.09345p
+ AD=0.204p PS=0.865u PD=1.835u rfmode=0
M$588 VPWR \$2734 \$I24200 VPWR sg13_lv_pmos L=0.13u W=0.42u AS=0.204p
+ AD=0.0798p PS=1.835u PD=0.8u rfmode=0
M$589 \$I24200 \$I24203 VPWR VPWR sg13_lv_pmos L=0.13u W=0.42u AS=0.0798p
+ AD=0.4659p PS=0.8u PD=3.65u rfmode=0
M$590 \$I24195 \$I24196 \$I24203 VPWR sg13_lv_pmos L=0.13u W=1u AS=0.34p
+ AD=0.2048p PS=2.68u PD=1.63u rfmode=0
M$591 \$I24201 \$I24203 VPWR VPWR sg13_lv_pmos L=0.13u W=1.12u AS=0.3864p
+ AD=0.2128p PS=2.93u PD=1.5u rfmode=0
M$592 VPWR \$I24201 \$2616 VPWR sg13_lv_pmos L=0.13u W=1.12u AS=0.2128p
+ AD=0.3808p PS=1.5u PD=2.92u rfmode=0
M$593 VPWR \$2915 \$I24197 VPWR sg13_lv_pmos L=0.13u W=0.42u AS=0.1428p
+ AD=0.0798p PS=1.52u PD=0.8u rfmode=0
M$594 VPWR \$2734 \$I24197 VPWR sg13_lv_pmos L=0.13u W=0.42u AS=0.3623875p
+ AD=0.0798p PS=2.605u PD=0.8u rfmode=0
M$595 VPWR \$I24202 \$I24195 VPWR sg13_lv_pmos L=0.13u W=1u AS=0.3623875p
+ AD=0.34p PS=2.605u PD=2.68u rfmode=0
M$596 \$I24207 \$I24196 VPWR VPWR sg13_lv_pmos L=0.13u W=1.12u AS=0.3864p
+ AD=0.41165p PS=2.93u PD=2.12u rfmode=0
M$597 VPWR \$2357 \$I24196 VPWR sg13_lv_pmos L=0.13u W=1.12u AS=0.41165p
+ AD=0.4088p PS=2.12u PD=2.97u rfmode=0
M$598 \$I24202 \$2734 VPWR VPWR sg13_lv_pmos L=0.13u W=0.42u AS=0.147p
+ AD=0.1563p PS=1.54u PD=1.22u rfmode=0
M$599 VPWR \$I24195 \$I24208 VPWR sg13_lv_pmos L=0.13u W=0.42u AS=0.1563p
+ AD=0.063p PS=1.22u PD=0.72u rfmode=0
M$600 \$I24208 \$I24196 \$I24202 VPWR sg13_lv_pmos L=0.13u W=0.42u AS=0.063p
+ AD=0.0798p PS=0.72u PD=0.8u rfmode=0
M$601 \$I24202 \$I24207 \$I24197 VPWR sg13_lv_pmos L=0.13u W=0.42u AS=0.0798p
+ AD=0.1428p PS=0.8u PD=1.52u rfmode=0
M$602 \$I24212 \$I24211 \$I24217 VGND sg13_lv_nmos L=0.13u W=0.42u AS=0.1296p
+ AD=0.0798p PS=1.52u PD=0.8u rfmode=0
M$603 \$I24217 \$I24222 \$I24213 VGND sg13_lv_nmos L=0.13u W=0.42u AS=0.0798p
+ AD=0.2373p PS=0.8u PD=1.97u rfmode=0
M$604 \$I24216 \$I24218 VGND VGND sg13_lv_nmos L=0.13u W=0.74u AS=0.2516p
+ AD=0.1406p PS=2.16u PD=1.12u rfmode=0
M$605 VGND \$I24216 \$3153 VGND sg13_lv_nmos L=0.13u W=0.74u AS=0.1406p
+ AD=0.2516p PS=1.12u PD=2.16u rfmode=0
M$606 VGND \$3447 \$I24220 VGND sg13_lv_nmos L=0.13u W=0.42u AS=0.1701p
+ AD=0.0378p PS=1.65u PD=0.6u rfmode=0
M$607 \$I24220 \$I24210 \$I24213 VGND sg13_lv_nmos L=0.13u W=0.42u AS=0.0378p
+ AD=0.1428p PS=0.6u PD=1.52u rfmode=0
M$608 \$I24214 \$I24215 VGND VGND sg13_lv_nmos L=0.13u W=0.42u AS=0.1428p
+ AD=0.0798p PS=1.52u PD=0.8u rfmode=0
M$609 VGND \$3447 \$I24221 VGND sg13_lv_nmos L=0.13u W=0.42u AS=0.0798p
+ AD=0.0378p PS=0.8u PD=0.6u rfmode=0
M$610 \$I24221 \$I24218 \$I24215 VGND sg13_lv_nmos L=0.13u W=0.42u AS=0.0378p
+ AD=0.1428p PS=0.6u PD=1.52u rfmode=0
M$611 VGND \$I24211 \$I24222 VGND sg13_lv_nmos L=0.13u W=0.74u AS=0.317325p
+ AD=0.2516p PS=1.805u PD=2.16u rfmode=0
M$612 VGND \$3332 \$I24211 VGND sg13_lv_nmos L=0.13u W=0.74u AS=0.317325p
+ AD=0.2516p PS=1.805u PD=2.16u rfmode=0
M$613 \$I24212 \$3504 \$I24219 VGND sg13_lv_nmos L=0.13u W=0.42u AS=0.1428p
+ AD=0.0609p PS=1.52u PD=0.71u rfmode=0
M$614 \$I24219 \$3447 VGND VGND sg13_lv_nmos L=0.13u W=0.42u AS=0.0609p
+ AD=0.1626p PS=0.71u PD=1.415u rfmode=0
M$615 VGND \$I24217 \$I24210 VGND sg13_lv_nmos L=0.13u W=0.74u AS=0.1626p
+ AD=0.2516p PS=1.415u PD=2.16u rfmode=0
M$616 \$I24218 \$I24211 \$I24214 VGND sg13_lv_nmos L=0.13u W=0.42u AS=0.12665p
+ AD=0.1428p PS=1.145u PD=1.52u rfmode=0
M$617 \$I24210 \$I24222 \$I24218 VGND sg13_lv_nmos L=0.13u W=0.74u AS=0.3473p
+ AD=0.12665p PS=2.71u PD=1.145u rfmode=0
M$618 \$I24218 \$I24222 \$I24224 VPWR sg13_lv_pmos L=0.13u W=0.42u AS=0.2048p
+ AD=0.09345p PS=1.63u PD=0.865u rfmode=0
M$619 \$I24224 \$I24215 VPWR VPWR sg13_lv_pmos L=0.13u W=0.42u AS=0.09345p
+ AD=0.204p PS=0.865u PD=1.835u rfmode=0
M$620 VPWR \$3447 \$I24215 VPWR sg13_lv_pmos L=0.13u W=0.42u AS=0.204p
+ AD=0.0798p PS=1.835u PD=0.8u rfmode=0
M$621 \$I24215 \$I24218 VPWR VPWR sg13_lv_pmos L=0.13u W=0.42u AS=0.0798p
+ AD=0.4659p PS=0.8u PD=3.65u rfmode=0
M$622 \$I24210 \$I24211 \$I24218 VPWR sg13_lv_pmos L=0.13u W=1u AS=0.34p
+ AD=0.2048p PS=2.68u PD=1.63u rfmode=0
M$623 \$I24216 \$I24218 VPWR VPWR sg13_lv_pmos L=0.13u W=1.12u AS=0.3864p
+ AD=0.2128p PS=2.93u PD=1.5u rfmode=0
M$624 VPWR \$I24216 \$3153 VPWR sg13_lv_pmos L=0.13u W=1.12u AS=0.2128p
+ AD=0.3808p PS=1.5u PD=2.92u rfmode=0
M$625 VPWR \$3504 \$I24212 VPWR sg13_lv_pmos L=0.13u W=0.42u AS=0.1428p
+ AD=0.0798p PS=1.52u PD=0.8u rfmode=0
M$626 VPWR \$3447 \$I24212 VPWR sg13_lv_pmos L=0.13u W=0.42u AS=0.3623875p
+ AD=0.0798p PS=2.605u PD=0.8u rfmode=0
M$627 VPWR \$I24217 \$I24210 VPWR sg13_lv_pmos L=0.13u W=1u AS=0.3623875p
+ AD=0.34p PS=2.605u PD=2.68u rfmode=0
M$628 \$I24222 \$I24211 VPWR VPWR sg13_lv_pmos L=0.13u W=1.12u AS=0.3864p
+ AD=0.41165p PS=2.93u PD=2.12u rfmode=0
M$629 VPWR \$3332 \$I24211 VPWR sg13_lv_pmos L=0.13u W=1.12u AS=0.41165p
+ AD=0.4088p PS=2.12u PD=2.97u rfmode=0
M$630 \$I24217 \$3447 VPWR VPWR sg13_lv_pmos L=0.13u W=0.42u AS=0.147p
+ AD=0.1563p PS=1.54u PD=1.22u rfmode=0
M$631 VPWR \$I24210 \$I24223 VPWR sg13_lv_pmos L=0.13u W=0.42u AS=0.1563p
+ AD=0.063p PS=1.22u PD=0.72u rfmode=0
M$632 \$I24223 \$I24211 \$I24217 VPWR sg13_lv_pmos L=0.13u W=0.42u AS=0.063p
+ AD=0.0798p PS=0.72u PD=0.8u rfmode=0
M$633 \$I24217 \$I24222 \$I24212 VPWR sg13_lv_pmos L=0.13u W=0.42u AS=0.0798p
+ AD=0.1428p PS=0.8u PD=1.52u rfmode=0
M$634 \$I24227 \$I24226 \$I24232 VGND sg13_lv_nmos L=0.13u W=0.42u AS=0.1296p
+ AD=0.0798p PS=1.52u PD=0.8u rfmode=0
M$635 \$I24232 \$I24237 \$I24228 VGND sg13_lv_nmos L=0.13u W=0.42u AS=0.0798p
+ AD=0.2373p PS=0.8u PD=1.97u rfmode=0
M$636 \$I24231 \$I24233 VGND VGND sg13_lv_nmos L=0.13u W=0.74u AS=0.2516p
+ AD=0.1406p PS=2.16u PD=1.12u rfmode=0
M$637 VGND \$I24231 \$1775 VGND sg13_lv_nmos L=0.13u W=0.74u AS=0.1406p
+ AD=0.2516p PS=1.12u PD=2.16u rfmode=0
M$638 VGND \$1886 \$I24235 VGND sg13_lv_nmos L=0.13u W=0.42u AS=0.1701p
+ AD=0.0378p PS=1.65u PD=0.6u rfmode=0
M$639 \$I24235 \$I24225 \$I24228 VGND sg13_lv_nmos L=0.13u W=0.42u AS=0.0378p
+ AD=0.1428p PS=0.6u PD=1.52u rfmode=0
M$640 \$I24229 \$I24230 VGND VGND sg13_lv_nmos L=0.13u W=0.42u AS=0.1428p
+ AD=0.0798p PS=1.52u PD=0.8u rfmode=0
M$641 VGND \$1886 \$I24236 VGND sg13_lv_nmos L=0.13u W=0.42u AS=0.0798p
+ AD=0.0378p PS=0.8u PD=0.6u rfmode=0
M$642 \$I24236 \$I24233 \$I24230 VGND sg13_lv_nmos L=0.13u W=0.42u AS=0.0378p
+ AD=0.1428p PS=0.6u PD=1.52u rfmode=0
M$643 VGND \$I24226 \$I24237 VGND sg13_lv_nmos L=0.13u W=0.74u AS=0.317325p
+ AD=0.2516p PS=1.805u PD=2.16u rfmode=0
M$644 VGND \$1887 \$I24226 VGND sg13_lv_nmos L=0.13u W=0.74u AS=0.317325p
+ AD=0.2516p PS=1.805u PD=2.16u rfmode=0
M$645 \$I24227 \$1930 \$I24234 VGND sg13_lv_nmos L=0.13u W=0.42u AS=0.1428p
+ AD=0.0609p PS=1.52u PD=0.71u rfmode=0
M$646 \$I24234 \$1886 VGND VGND sg13_lv_nmos L=0.13u W=0.42u AS=0.0609p
+ AD=0.1626p PS=0.71u PD=1.415u rfmode=0
M$647 VGND \$I24232 \$I24225 VGND sg13_lv_nmos L=0.13u W=0.74u AS=0.1626p
+ AD=0.2516p PS=1.415u PD=2.16u rfmode=0
M$648 \$I24233 \$I24226 \$I24229 VGND sg13_lv_nmos L=0.13u W=0.42u AS=0.12665p
+ AD=0.1428p PS=1.145u PD=1.52u rfmode=0
M$649 \$I24225 \$I24237 \$I24233 VGND sg13_lv_nmos L=0.13u W=0.74u AS=0.3473p
+ AD=0.12665p PS=2.71u PD=1.145u rfmode=0
M$650 \$I24233 \$I24237 \$I24239 VPWR sg13_lv_pmos L=0.13u W=0.42u AS=0.2048p
+ AD=0.09345p PS=1.63u PD=0.865u rfmode=0
M$651 \$I24239 \$I24230 VPWR VPWR sg13_lv_pmos L=0.13u W=0.42u AS=0.09345p
+ AD=0.204p PS=0.865u PD=1.835u rfmode=0
M$652 VPWR \$1886 \$I24230 VPWR sg13_lv_pmos L=0.13u W=0.42u AS=0.204p
+ AD=0.0798p PS=1.835u PD=0.8u rfmode=0
M$653 \$I24230 \$I24233 VPWR VPWR sg13_lv_pmos L=0.13u W=0.42u AS=0.0798p
+ AD=0.4659p PS=0.8u PD=3.65u rfmode=0
M$654 \$I24225 \$I24226 \$I24233 VPWR sg13_lv_pmos L=0.13u W=1u AS=0.34p
+ AD=0.2048p PS=2.68u PD=1.63u rfmode=0
M$655 \$I24231 \$I24233 VPWR VPWR sg13_lv_pmos L=0.13u W=1.12u AS=0.3864p
+ AD=0.2128p PS=2.93u PD=1.5u rfmode=0
M$656 VPWR \$I24231 \$1775 VPWR sg13_lv_pmos L=0.13u W=1.12u AS=0.2128p
+ AD=0.3808p PS=1.5u PD=2.92u rfmode=0
M$657 VPWR \$1930 \$I24227 VPWR sg13_lv_pmos L=0.13u W=0.42u AS=0.1428p
+ AD=0.0798p PS=1.52u PD=0.8u rfmode=0
M$658 VPWR \$1886 \$I24227 VPWR sg13_lv_pmos L=0.13u W=0.42u AS=0.3623875p
+ AD=0.0798p PS=2.605u PD=0.8u rfmode=0
M$659 VPWR \$I24232 \$I24225 VPWR sg13_lv_pmos L=0.13u W=1u AS=0.3623875p
+ AD=0.34p PS=2.605u PD=2.68u rfmode=0
M$660 \$I24237 \$I24226 VPWR VPWR sg13_lv_pmos L=0.13u W=1.12u AS=0.3864p
+ AD=0.41165p PS=2.93u PD=2.12u rfmode=0
M$661 VPWR \$1887 \$I24226 VPWR sg13_lv_pmos L=0.13u W=1.12u AS=0.41165p
+ AD=0.4088p PS=2.12u PD=2.97u rfmode=0
M$662 \$I24232 \$1886 VPWR VPWR sg13_lv_pmos L=0.13u W=0.42u AS=0.147p
+ AD=0.1563p PS=1.54u PD=1.22u rfmode=0
M$663 VPWR \$I24225 \$I24238 VPWR sg13_lv_pmos L=0.13u W=0.42u AS=0.1563p
+ AD=0.063p PS=1.22u PD=0.72u rfmode=0
M$664 \$I24238 \$I24226 \$I24232 VPWR sg13_lv_pmos L=0.13u W=0.42u AS=0.063p
+ AD=0.0798p PS=0.72u PD=0.8u rfmode=0
M$665 \$I24232 \$I24237 \$I24227 VPWR sg13_lv_pmos L=0.13u W=0.42u AS=0.0798p
+ AD=0.1428p PS=0.8u PD=1.52u rfmode=0
M$666 \$I24242 \$I24241 \$I24247 VGND sg13_lv_nmos L=0.13u W=0.42u AS=0.1296p
+ AD=0.0798p PS=1.52u PD=0.8u rfmode=0
M$667 \$I24247 \$I24252 \$I24243 VGND sg13_lv_nmos L=0.13u W=0.42u AS=0.0798p
+ AD=0.2373p PS=0.8u PD=1.97u rfmode=0
M$668 \$I24246 \$I24248 VGND VGND sg13_lv_nmos L=0.13u W=0.74u AS=0.2516p
+ AD=0.1406p PS=2.16u PD=1.12u rfmode=0
M$669 VGND \$I24246 \$2094 VGND sg13_lv_nmos L=0.13u W=0.74u AS=0.1406p
+ AD=0.2516p PS=1.12u PD=2.16u rfmode=0
M$670 VGND \$2013 \$I24250 VGND sg13_lv_nmos L=0.13u W=0.42u AS=0.1701p
+ AD=0.0378p PS=1.65u PD=0.6u rfmode=0
M$671 \$I24250 \$I24240 \$I24243 VGND sg13_lv_nmos L=0.13u W=0.42u AS=0.0378p
+ AD=0.1428p PS=0.6u PD=1.52u rfmode=0
M$672 \$I24244 \$I24245 VGND VGND sg13_lv_nmos L=0.13u W=0.42u AS=0.1428p
+ AD=0.0798p PS=1.52u PD=0.8u rfmode=0
M$673 VGND \$2013 \$I24251 VGND sg13_lv_nmos L=0.13u W=0.42u AS=0.0798p
+ AD=0.0378p PS=0.8u PD=0.6u rfmode=0
M$674 \$I24251 \$I24248 \$I24245 VGND sg13_lv_nmos L=0.13u W=0.42u AS=0.0378p
+ AD=0.1428p PS=0.6u PD=1.52u rfmode=0
M$675 VGND \$I24241 \$I24252 VGND sg13_lv_nmos L=0.13u W=0.74u AS=0.317325p
+ AD=0.2516p PS=1.805u PD=2.16u rfmode=0
M$676 VGND \$1781 \$I24241 VGND sg13_lv_nmos L=0.13u W=0.74u AS=0.317325p
+ AD=0.2516p PS=1.805u PD=2.16u rfmode=0
M$677 \$I24242 \$2054 \$I24249 VGND sg13_lv_nmos L=0.13u W=0.42u AS=0.1428p
+ AD=0.0609p PS=1.52u PD=0.71u rfmode=0
M$678 \$I24249 \$2013 VGND VGND sg13_lv_nmos L=0.13u W=0.42u AS=0.0609p
+ AD=0.1626p PS=0.71u PD=1.415u rfmode=0
M$679 VGND \$I24247 \$I24240 VGND sg13_lv_nmos L=0.13u W=0.74u AS=0.1626p
+ AD=0.2516p PS=1.415u PD=2.16u rfmode=0
M$680 \$I24248 \$I24241 \$I24244 VGND sg13_lv_nmos L=0.13u W=0.42u AS=0.12665p
+ AD=0.1428p PS=1.145u PD=1.52u rfmode=0
M$681 \$I24240 \$I24252 \$I24248 VGND sg13_lv_nmos L=0.13u W=0.74u AS=0.3473p
+ AD=0.12665p PS=2.71u PD=1.145u rfmode=0
M$682 \$I24248 \$I24252 \$I24254 VPWR sg13_lv_pmos L=0.13u W=0.42u AS=0.2048p
+ AD=0.09345p PS=1.63u PD=0.865u rfmode=0
M$683 \$I24254 \$I24245 VPWR VPWR sg13_lv_pmos L=0.13u W=0.42u AS=0.09345p
+ AD=0.204p PS=0.865u PD=1.835u rfmode=0
M$684 VPWR \$2013 \$I24245 VPWR sg13_lv_pmos L=0.13u W=0.42u AS=0.204p
+ AD=0.0798p PS=1.835u PD=0.8u rfmode=0
M$685 \$I24245 \$I24248 VPWR VPWR sg13_lv_pmos L=0.13u W=0.42u AS=0.0798p
+ AD=0.4659p PS=0.8u PD=3.65u rfmode=0
M$686 \$I24240 \$I24241 \$I24248 VPWR sg13_lv_pmos L=0.13u W=1u AS=0.34p
+ AD=0.2048p PS=2.68u PD=1.63u rfmode=0
M$687 \$I24246 \$I24248 VPWR VPWR sg13_lv_pmos L=0.13u W=1.12u AS=0.3864p
+ AD=0.2128p PS=2.93u PD=1.5u rfmode=0
M$688 VPWR \$I24246 \$2094 VPWR sg13_lv_pmos L=0.13u W=1.12u AS=0.2128p
+ AD=0.3808p PS=1.5u PD=2.92u rfmode=0
M$689 VPWR \$2054 \$I24242 VPWR sg13_lv_pmos L=0.13u W=0.42u AS=0.1428p
+ AD=0.0798p PS=1.52u PD=0.8u rfmode=0
M$690 VPWR \$2013 \$I24242 VPWR sg13_lv_pmos L=0.13u W=0.42u AS=0.3623875p
+ AD=0.0798p PS=2.605u PD=0.8u rfmode=0
M$691 VPWR \$I24247 \$I24240 VPWR sg13_lv_pmos L=0.13u W=1u AS=0.3623875p
+ AD=0.34p PS=2.605u PD=2.68u rfmode=0
M$692 \$I24252 \$I24241 VPWR VPWR sg13_lv_pmos L=0.13u W=1.12u AS=0.3864p
+ AD=0.41165p PS=2.93u PD=2.12u rfmode=0
M$693 VPWR \$1781 \$I24241 VPWR sg13_lv_pmos L=0.13u W=1.12u AS=0.41165p
+ AD=0.4088p PS=2.12u PD=2.97u rfmode=0
M$694 \$I24247 \$2013 VPWR VPWR sg13_lv_pmos L=0.13u W=0.42u AS=0.147p
+ AD=0.1563p PS=1.54u PD=1.22u rfmode=0
M$695 VPWR \$I24240 \$I24253 VPWR sg13_lv_pmos L=0.13u W=0.42u AS=0.1563p
+ AD=0.063p PS=1.22u PD=0.72u rfmode=0
M$696 \$I24253 \$I24241 \$I24247 VPWR sg13_lv_pmos L=0.13u W=0.42u AS=0.063p
+ AD=0.0798p PS=0.72u PD=0.8u rfmode=0
M$697 \$I24247 \$I24252 \$I24242 VPWR sg13_lv_pmos L=0.13u W=0.42u AS=0.0798p
+ AD=0.1428p PS=0.8u PD=1.52u rfmode=0
M$698 \$I24257 \$I24256 \$I24262 VGND sg13_lv_nmos L=0.13u W=0.42u AS=0.1296p
+ AD=0.0798p PS=1.52u PD=0.8u rfmode=0
M$699 \$I24262 \$I24267 \$I24258 VGND sg13_lv_nmos L=0.13u W=0.42u AS=0.0798p
+ AD=0.2373p PS=0.8u PD=1.97u rfmode=0
M$700 \$I24261 \$I24263 VGND VGND sg13_lv_nmos L=0.13u W=0.74u AS=0.2516p
+ AD=0.1406p PS=2.16u PD=1.12u rfmode=0
M$701 VGND \$I24261 \$1769 VGND sg13_lv_nmos L=0.13u W=0.74u AS=0.1406p
+ AD=0.2516p PS=1.12u PD=2.16u rfmode=0
M$702 VGND \$3383 \$I24265 VGND sg13_lv_nmos L=0.13u W=0.42u AS=0.1701p
+ AD=0.0378p PS=1.65u PD=0.6u rfmode=0
M$703 \$I24265 \$I24255 \$I24258 VGND sg13_lv_nmos L=0.13u W=0.42u AS=0.0378p
+ AD=0.1428p PS=0.6u PD=1.52u rfmode=0
M$704 \$I24259 \$I24260 VGND VGND sg13_lv_nmos L=0.13u W=0.42u AS=0.1428p
+ AD=0.0798p PS=1.52u PD=0.8u rfmode=0
M$705 VGND \$3383 \$I24266 VGND sg13_lv_nmos L=0.13u W=0.42u AS=0.0798p
+ AD=0.0378p PS=0.8u PD=0.6u rfmode=0
M$706 \$I24266 \$I24263 \$I24260 VGND sg13_lv_nmos L=0.13u W=0.42u AS=0.0378p
+ AD=0.1428p PS=0.6u PD=1.52u rfmode=0
M$707 VGND \$I24256 \$I24267 VGND sg13_lv_nmos L=0.13u W=0.74u AS=0.317325p
+ AD=0.2516p PS=1.805u PD=2.16u rfmode=0
M$708 VGND \$2357 \$I24256 VGND sg13_lv_nmos L=0.13u W=0.74u AS=0.317325p
+ AD=0.2516p PS=1.805u PD=2.16u rfmode=0
M$709 \$I24257 \$3194 \$I24264 VGND sg13_lv_nmos L=0.13u W=0.42u AS=0.1428p
+ AD=0.0609p PS=1.52u PD=0.71u rfmode=0
M$710 \$I24264 \$3383 VGND VGND sg13_lv_nmos L=0.13u W=0.42u AS=0.0609p
+ AD=0.1626p PS=0.71u PD=1.415u rfmode=0
M$711 VGND \$I24262 \$I24255 VGND sg13_lv_nmos L=0.13u W=0.74u AS=0.1626p
+ AD=0.2516p PS=1.415u PD=2.16u rfmode=0
M$712 \$I24263 \$I24256 \$I24259 VGND sg13_lv_nmos L=0.13u W=0.42u AS=0.12665p
+ AD=0.1428p PS=1.145u PD=1.52u rfmode=0
M$713 \$I24255 \$I24267 \$I24263 VGND sg13_lv_nmos L=0.13u W=0.74u AS=0.3473p
+ AD=0.12665p PS=2.71u PD=1.145u rfmode=0
M$714 \$I24263 \$I24267 \$I24269 VPWR sg13_lv_pmos L=0.13u W=0.42u AS=0.2048p
+ AD=0.09345p PS=1.63u PD=0.865u rfmode=0
M$715 \$I24269 \$I24260 VPWR VPWR sg13_lv_pmos L=0.13u W=0.42u AS=0.09345p
+ AD=0.204p PS=0.865u PD=1.835u rfmode=0
M$716 VPWR \$3383 \$I24260 VPWR sg13_lv_pmos L=0.13u W=0.42u AS=0.204p
+ AD=0.0798p PS=1.835u PD=0.8u rfmode=0
M$717 \$I24260 \$I24263 VPWR VPWR sg13_lv_pmos L=0.13u W=0.42u AS=0.0798p
+ AD=0.4659p PS=0.8u PD=3.65u rfmode=0
M$718 \$I24255 \$I24256 \$I24263 VPWR sg13_lv_pmos L=0.13u W=1u AS=0.34p
+ AD=0.2048p PS=2.68u PD=1.63u rfmode=0
M$719 \$I24261 \$I24263 VPWR VPWR sg13_lv_pmos L=0.13u W=1.12u AS=0.3864p
+ AD=0.2128p PS=2.93u PD=1.5u rfmode=0
M$720 VPWR \$I24261 \$1769 VPWR sg13_lv_pmos L=0.13u W=1.12u AS=0.2128p
+ AD=0.3808p PS=1.5u PD=2.92u rfmode=0
M$721 VPWR \$3194 \$I24257 VPWR sg13_lv_pmos L=0.13u W=0.42u AS=0.1428p
+ AD=0.0798p PS=1.52u PD=0.8u rfmode=0
M$722 VPWR \$3383 \$I24257 VPWR sg13_lv_pmos L=0.13u W=0.42u AS=0.3623875p
+ AD=0.0798p PS=2.605u PD=0.8u rfmode=0
M$723 VPWR \$I24262 \$I24255 VPWR sg13_lv_pmos L=0.13u W=1u AS=0.3623875p
+ AD=0.34p PS=2.605u PD=2.68u rfmode=0
M$724 \$I24267 \$I24256 VPWR VPWR sg13_lv_pmos L=0.13u W=1.12u AS=0.3864p
+ AD=0.41165p PS=2.93u PD=2.12u rfmode=0
M$725 VPWR \$2357 \$I24256 VPWR sg13_lv_pmos L=0.13u W=1.12u AS=0.41165p
+ AD=0.4088p PS=2.12u PD=2.97u rfmode=0
M$726 \$I24262 \$3383 VPWR VPWR sg13_lv_pmos L=0.13u W=0.42u AS=0.147p
+ AD=0.1563p PS=1.54u PD=1.22u rfmode=0
M$727 VPWR \$I24255 \$I24268 VPWR sg13_lv_pmos L=0.13u W=0.42u AS=0.1563p
+ AD=0.063p PS=1.22u PD=0.72u rfmode=0
M$728 \$I24268 \$I24256 \$I24262 VPWR sg13_lv_pmos L=0.13u W=0.42u AS=0.063p
+ AD=0.0798p PS=0.72u PD=0.8u rfmode=0
M$729 \$I24262 \$I24267 \$I24257 VPWR sg13_lv_pmos L=0.13u W=0.42u AS=0.0798p
+ AD=0.1428p PS=0.8u PD=1.52u rfmode=0
M$730 \$I24272 \$I24271 \$I24277 VGND sg13_lv_nmos L=0.13u W=0.42u AS=0.1296p
+ AD=0.0798p PS=1.52u PD=0.8u rfmode=0
M$731 \$I24277 \$I24282 \$I24273 VGND sg13_lv_nmos L=0.13u W=0.42u AS=0.0798p
+ AD=0.2373p PS=0.8u PD=1.97u rfmode=0
M$732 \$I24276 \$I24278 VGND VGND sg13_lv_nmos L=0.13u W=0.74u AS=0.2516p
+ AD=0.1406p PS=2.16u PD=1.12u rfmode=0
M$733 VGND \$I24276 \$1926 VGND sg13_lv_nmos L=0.13u W=0.74u AS=0.1406p
+ AD=0.2516p PS=1.12u PD=2.16u rfmode=0
M$734 VGND \$1885 \$I24280 VGND sg13_lv_nmos L=0.13u W=0.42u AS=0.1701p
+ AD=0.0378p PS=1.65u PD=0.6u rfmode=0
M$735 \$I24280 \$I24270 \$I24273 VGND sg13_lv_nmos L=0.13u W=0.42u AS=0.0378p
+ AD=0.1428p PS=0.6u PD=1.52u rfmode=0
M$736 \$I24274 \$I24275 VGND VGND sg13_lv_nmos L=0.13u W=0.42u AS=0.1428p
+ AD=0.0798p PS=1.52u PD=0.8u rfmode=0
M$737 VGND \$1885 \$I24281 VGND sg13_lv_nmos L=0.13u W=0.42u AS=0.0798p
+ AD=0.0378p PS=0.8u PD=0.6u rfmode=0
M$738 \$I24281 \$I24278 \$I24275 VGND sg13_lv_nmos L=0.13u W=0.42u AS=0.0378p
+ AD=0.1428p PS=0.6u PD=1.52u rfmode=0
M$739 VGND \$I24271 \$I24282 VGND sg13_lv_nmos L=0.13u W=0.74u AS=0.317325p
+ AD=0.2516p PS=1.805u PD=2.16u rfmode=0
M$740 VGND \$1887 \$I24271 VGND sg13_lv_nmos L=0.13u W=0.74u AS=0.317325p
+ AD=0.2516p PS=1.805u PD=2.16u rfmode=0
M$741 \$I24272 \$2049 \$I24279 VGND sg13_lv_nmos L=0.13u W=0.42u AS=0.1428p
+ AD=0.0609p PS=1.52u PD=0.71u rfmode=0
M$742 \$I24279 \$1885 VGND VGND sg13_lv_nmos L=0.13u W=0.42u AS=0.0609p
+ AD=0.1626p PS=0.71u PD=1.415u rfmode=0
M$743 VGND \$I24277 \$I24270 VGND sg13_lv_nmos L=0.13u W=0.74u AS=0.1626p
+ AD=0.2516p PS=1.415u PD=2.16u rfmode=0
M$744 \$I24278 \$I24271 \$I24274 VGND sg13_lv_nmos L=0.13u W=0.42u AS=0.12665p
+ AD=0.1428p PS=1.145u PD=1.52u rfmode=0
M$745 \$I24270 \$I24282 \$I24278 VGND sg13_lv_nmos L=0.13u W=0.74u AS=0.3473p
+ AD=0.12665p PS=2.71u PD=1.145u rfmode=0
M$746 \$I24278 \$I24282 \$I24284 VPWR sg13_lv_pmos L=0.13u W=0.42u AS=0.2048p
+ AD=0.09345p PS=1.63u PD=0.865u rfmode=0
M$747 \$I24284 \$I24275 VPWR VPWR sg13_lv_pmos L=0.13u W=0.42u AS=0.09345p
+ AD=0.204p PS=0.865u PD=1.835u rfmode=0
M$748 VPWR \$1885 \$I24275 VPWR sg13_lv_pmos L=0.13u W=0.42u AS=0.204p
+ AD=0.0798p PS=1.835u PD=0.8u rfmode=0
M$749 \$I24275 \$I24278 VPWR VPWR sg13_lv_pmos L=0.13u W=0.42u AS=0.0798p
+ AD=0.4659p PS=0.8u PD=3.65u rfmode=0
M$750 \$I24270 \$I24271 \$I24278 VPWR sg13_lv_pmos L=0.13u W=1u AS=0.34p
+ AD=0.2048p PS=2.68u PD=1.63u rfmode=0
M$751 \$I24276 \$I24278 VPWR VPWR sg13_lv_pmos L=0.13u W=1.12u AS=0.3864p
+ AD=0.2128p PS=2.93u PD=1.5u rfmode=0
M$752 VPWR \$I24276 \$1926 VPWR sg13_lv_pmos L=0.13u W=1.12u AS=0.2128p
+ AD=0.3808p PS=1.5u PD=2.92u rfmode=0
M$753 VPWR \$2049 \$I24272 VPWR sg13_lv_pmos L=0.13u W=0.42u AS=0.1428p
+ AD=0.0798p PS=1.52u PD=0.8u rfmode=0
M$754 VPWR \$1885 \$I24272 VPWR sg13_lv_pmos L=0.13u W=0.42u AS=0.3623875p
+ AD=0.0798p PS=2.605u PD=0.8u rfmode=0
M$755 VPWR \$I24277 \$I24270 VPWR sg13_lv_pmos L=0.13u W=1u AS=0.3623875p
+ AD=0.34p PS=2.605u PD=2.68u rfmode=0
M$756 \$I24282 \$I24271 VPWR VPWR sg13_lv_pmos L=0.13u W=1.12u AS=0.3864p
+ AD=0.41165p PS=2.93u PD=2.12u rfmode=0
M$757 VPWR \$1887 \$I24271 VPWR sg13_lv_pmos L=0.13u W=1.12u AS=0.41165p
+ AD=0.4088p PS=2.12u PD=2.97u rfmode=0
M$758 \$I24277 \$1885 VPWR VPWR sg13_lv_pmos L=0.13u W=0.42u AS=0.147p
+ AD=0.1563p PS=1.54u PD=1.22u rfmode=0
M$759 VPWR \$I24270 \$I24283 VPWR sg13_lv_pmos L=0.13u W=0.42u AS=0.1563p
+ AD=0.063p PS=1.22u PD=0.72u rfmode=0
M$760 \$I24283 \$I24271 \$I24277 VPWR sg13_lv_pmos L=0.13u W=0.42u AS=0.063p
+ AD=0.0798p PS=0.72u PD=0.8u rfmode=0
M$761 \$I24277 \$I24282 \$I24272 VPWR sg13_lv_pmos L=0.13u W=0.42u AS=0.0798p
+ AD=0.1428p PS=0.8u PD=1.52u rfmode=0
M$762 \$I24287 \$I24286 \$I24292 VGND sg13_lv_nmos L=0.13u W=0.42u AS=0.1296p
+ AD=0.0798p PS=1.52u PD=0.8u rfmode=0
M$763 \$I24292 \$I24297 \$I24288 VGND sg13_lv_nmos L=0.13u W=0.42u AS=0.0798p
+ AD=0.2373p PS=0.8u PD=1.97u rfmode=0
M$764 \$I24291 \$I24293 VGND VGND sg13_lv_nmos L=0.13u W=0.74u AS=0.2516p
+ AD=0.1406p PS=2.16u PD=1.12u rfmode=0
M$765 VGND \$I24291 \$1928 VGND sg13_lv_nmos L=0.13u W=0.74u AS=0.1406p
+ AD=0.2516p PS=1.12u PD=2.16u rfmode=0
M$766 VGND \$2004 \$I24295 VGND sg13_lv_nmos L=0.13u W=0.42u AS=0.1701p
+ AD=0.0378p PS=1.65u PD=0.6u rfmode=0
M$767 \$I24295 \$I24285 \$I24288 VGND sg13_lv_nmos L=0.13u W=0.42u AS=0.0378p
+ AD=0.1428p PS=0.6u PD=1.52u rfmode=0
M$768 \$I24289 \$I24290 VGND VGND sg13_lv_nmos L=0.13u W=0.42u AS=0.1428p
+ AD=0.0798p PS=1.52u PD=0.8u rfmode=0
M$769 VGND \$2004 \$I24296 VGND sg13_lv_nmos L=0.13u W=0.42u AS=0.0798p
+ AD=0.0378p PS=0.8u PD=0.6u rfmode=0
M$770 \$I24296 \$I24293 \$I24290 VGND sg13_lv_nmos L=0.13u W=0.42u AS=0.0378p
+ AD=0.1428p PS=0.6u PD=1.52u rfmode=0
M$771 VGND \$I24286 \$I24297 VGND sg13_lv_nmos L=0.13u W=0.74u AS=0.317325p
+ AD=0.2516p PS=1.805u PD=2.16u rfmode=0
M$772 VGND \$1887 \$I24286 VGND sg13_lv_nmos L=0.13u W=0.74u AS=0.317325p
+ AD=0.2516p PS=1.805u PD=2.16u rfmode=0
M$773 \$I24287 \$3637 \$I24294 VGND sg13_lv_nmos L=0.13u W=0.42u AS=0.1428p
+ AD=0.0609p PS=1.52u PD=0.71u rfmode=0
M$774 \$I24294 \$2004 VGND VGND sg13_lv_nmos L=0.13u W=0.42u AS=0.0609p
+ AD=0.1626p PS=0.71u PD=1.415u rfmode=0
M$775 VGND \$I24292 \$I24285 VGND sg13_lv_nmos L=0.13u W=0.74u AS=0.1626p
+ AD=0.2516p PS=1.415u PD=2.16u rfmode=0
M$776 \$I24293 \$I24286 \$I24289 VGND sg13_lv_nmos L=0.13u W=0.42u AS=0.12665p
+ AD=0.1428p PS=1.145u PD=1.52u rfmode=0
M$777 \$I24285 \$I24297 \$I24293 VGND sg13_lv_nmos L=0.13u W=0.74u AS=0.3473p
+ AD=0.12665p PS=2.71u PD=1.145u rfmode=0
M$778 \$I24293 \$I24297 \$I24299 VPWR sg13_lv_pmos L=0.13u W=0.42u AS=0.2048p
+ AD=0.09345p PS=1.63u PD=0.865u rfmode=0
M$779 \$I24299 \$I24290 VPWR VPWR sg13_lv_pmos L=0.13u W=0.42u AS=0.09345p
+ AD=0.204p PS=0.865u PD=1.835u rfmode=0
M$780 VPWR \$2004 \$I24290 VPWR sg13_lv_pmos L=0.13u W=0.42u AS=0.204p
+ AD=0.0798p PS=1.835u PD=0.8u rfmode=0
M$781 \$I24290 \$I24293 VPWR VPWR sg13_lv_pmos L=0.13u W=0.42u AS=0.0798p
+ AD=0.4659p PS=0.8u PD=3.65u rfmode=0
M$782 \$I24285 \$I24286 \$I24293 VPWR sg13_lv_pmos L=0.13u W=1u AS=0.34p
+ AD=0.2048p PS=2.68u PD=1.63u rfmode=0
M$783 \$I24291 \$I24293 VPWR VPWR sg13_lv_pmos L=0.13u W=1.12u AS=0.3864p
+ AD=0.2128p PS=2.93u PD=1.5u rfmode=0
M$784 VPWR \$I24291 \$1928 VPWR sg13_lv_pmos L=0.13u W=1.12u AS=0.2128p
+ AD=0.3808p PS=1.5u PD=2.92u rfmode=0
M$785 VPWR \$3637 \$I24287 VPWR sg13_lv_pmos L=0.13u W=0.42u AS=0.1428p
+ AD=0.0798p PS=1.52u PD=0.8u rfmode=0
M$786 VPWR \$2004 \$I24287 VPWR sg13_lv_pmos L=0.13u W=0.42u AS=0.3623875p
+ AD=0.0798p PS=2.605u PD=0.8u rfmode=0
M$787 VPWR \$I24292 \$I24285 VPWR sg13_lv_pmos L=0.13u W=1u AS=0.3623875p
+ AD=0.34p PS=2.605u PD=2.68u rfmode=0
M$788 \$I24297 \$I24286 VPWR VPWR sg13_lv_pmos L=0.13u W=1.12u AS=0.3864p
+ AD=0.41165p PS=2.93u PD=2.12u rfmode=0
M$789 VPWR \$1887 \$I24286 VPWR sg13_lv_pmos L=0.13u W=1.12u AS=0.41165p
+ AD=0.4088p PS=2.12u PD=2.97u rfmode=0
M$790 \$I24292 \$2004 VPWR VPWR sg13_lv_pmos L=0.13u W=0.42u AS=0.147p
+ AD=0.1563p PS=1.54u PD=1.22u rfmode=0
M$791 VPWR \$I24285 \$I24298 VPWR sg13_lv_pmos L=0.13u W=0.42u AS=0.1563p
+ AD=0.063p PS=1.22u PD=0.72u rfmode=0
M$792 \$I24298 \$I24286 \$I24292 VPWR sg13_lv_pmos L=0.13u W=0.42u AS=0.063p
+ AD=0.0798p PS=0.72u PD=0.8u rfmode=0
M$793 \$I24292 \$I24297 \$I24287 VPWR sg13_lv_pmos L=0.13u W=0.42u AS=0.0798p
+ AD=0.1428p PS=0.8u PD=1.52u rfmode=0
M$794 \$I24302 \$I24301 \$I24307 VGND sg13_lv_nmos L=0.13u W=0.42u AS=0.1296p
+ AD=0.0798p PS=1.52u PD=0.8u rfmode=0
M$795 \$I24307 \$I24312 \$I24303 VGND sg13_lv_nmos L=0.13u W=0.42u AS=0.0798p
+ AD=0.2373p PS=0.8u PD=1.97u rfmode=0
M$796 \$I24306 \$I24308 VGND VGND sg13_lv_nmos L=0.13u W=0.74u AS=0.2516p
+ AD=0.1406p PS=2.16u PD=1.12u rfmode=0
M$797 VGND \$I24306 \$3333 VGND sg13_lv_nmos L=0.13u W=0.74u AS=0.1406p
+ AD=0.2516p PS=1.12u PD=2.16u rfmode=0
M$798 VGND \$3331 \$I24310 VGND sg13_lv_nmos L=0.13u W=0.42u AS=0.1701p
+ AD=0.0378p PS=1.65u PD=0.6u rfmode=0
M$799 \$I24310 \$I24300 \$I24303 VGND sg13_lv_nmos L=0.13u W=0.42u AS=0.0378p
+ AD=0.1428p PS=0.6u PD=1.52u rfmode=0
M$800 \$I24304 \$I24305 VGND VGND sg13_lv_nmos L=0.13u W=0.42u AS=0.1428p
+ AD=0.0798p PS=1.52u PD=0.8u rfmode=0
M$801 VGND \$3331 \$I24311 VGND sg13_lv_nmos L=0.13u W=0.42u AS=0.0798p
+ AD=0.0378p PS=0.8u PD=0.6u rfmode=0
M$802 \$I24311 \$I24308 \$I24305 VGND sg13_lv_nmos L=0.13u W=0.42u AS=0.0378p
+ AD=0.1428p PS=0.6u PD=1.52u rfmode=0
M$803 VGND \$I24301 \$I24312 VGND sg13_lv_nmos L=0.13u W=0.74u AS=0.317325p
+ AD=0.2516p PS=1.805u PD=2.16u rfmode=0
M$804 VGND \$3332 \$I24301 VGND sg13_lv_nmos L=0.13u W=0.74u AS=0.317325p
+ AD=0.2516p PS=1.805u PD=2.16u rfmode=0
M$805 \$I24302 \$3380 \$I24309 VGND sg13_lv_nmos L=0.13u W=0.42u AS=0.1428p
+ AD=0.0609p PS=1.52u PD=0.71u rfmode=0
M$806 \$I24309 \$3331 VGND VGND sg13_lv_nmos L=0.13u W=0.42u AS=0.0609p
+ AD=0.1626p PS=0.71u PD=1.415u rfmode=0
M$807 VGND \$I24307 \$I24300 VGND sg13_lv_nmos L=0.13u W=0.74u AS=0.1626p
+ AD=0.2516p PS=1.415u PD=2.16u rfmode=0
M$808 \$I24308 \$I24301 \$I24304 VGND sg13_lv_nmos L=0.13u W=0.42u AS=0.12665p
+ AD=0.1428p PS=1.145u PD=1.52u rfmode=0
M$809 \$I24300 \$I24312 \$I24308 VGND sg13_lv_nmos L=0.13u W=0.74u AS=0.3473p
+ AD=0.12665p PS=2.71u PD=1.145u rfmode=0
M$810 \$I24308 \$I24312 \$I24314 VPWR sg13_lv_pmos L=0.13u W=0.42u AS=0.2048p
+ AD=0.09345p PS=1.63u PD=0.865u rfmode=0
M$811 \$I24314 \$I24305 VPWR VPWR sg13_lv_pmos L=0.13u W=0.42u AS=0.09345p
+ AD=0.204p PS=0.865u PD=1.835u rfmode=0
M$812 VPWR \$3331 \$I24305 VPWR sg13_lv_pmos L=0.13u W=0.42u AS=0.204p
+ AD=0.0798p PS=1.835u PD=0.8u rfmode=0
M$813 \$I24305 \$I24308 VPWR VPWR sg13_lv_pmos L=0.13u W=0.42u AS=0.0798p
+ AD=0.4659p PS=0.8u PD=3.65u rfmode=0
M$814 \$I24300 \$I24301 \$I24308 VPWR sg13_lv_pmos L=0.13u W=1u AS=0.34p
+ AD=0.2048p PS=2.68u PD=1.63u rfmode=0
M$815 \$I24306 \$I24308 VPWR VPWR sg13_lv_pmos L=0.13u W=1.12u AS=0.3864p
+ AD=0.2128p PS=2.93u PD=1.5u rfmode=0
M$816 VPWR \$I24306 \$3333 VPWR sg13_lv_pmos L=0.13u W=1.12u AS=0.2128p
+ AD=0.3808p PS=1.5u PD=2.92u rfmode=0
M$817 VPWR \$3380 \$I24302 VPWR sg13_lv_pmos L=0.13u W=0.42u AS=0.1428p
+ AD=0.0798p PS=1.52u PD=0.8u rfmode=0
M$818 VPWR \$3331 \$I24302 VPWR sg13_lv_pmos L=0.13u W=0.42u AS=0.3623875p
+ AD=0.0798p PS=2.605u PD=0.8u rfmode=0
M$819 VPWR \$I24307 \$I24300 VPWR sg13_lv_pmos L=0.13u W=1u AS=0.3623875p
+ AD=0.34p PS=2.605u PD=2.68u rfmode=0
M$820 \$I24312 \$I24301 VPWR VPWR sg13_lv_pmos L=0.13u W=1.12u AS=0.3864p
+ AD=0.41165p PS=2.93u PD=2.12u rfmode=0
M$821 VPWR \$3332 \$I24301 VPWR sg13_lv_pmos L=0.13u W=1.12u AS=0.41165p
+ AD=0.4088p PS=2.12u PD=2.97u rfmode=0
M$822 \$I24307 \$3331 VPWR VPWR sg13_lv_pmos L=0.13u W=0.42u AS=0.147p
+ AD=0.1563p PS=1.54u PD=1.22u rfmode=0
M$823 VPWR \$I24300 \$I24313 VPWR sg13_lv_pmos L=0.13u W=0.42u AS=0.1563p
+ AD=0.063p PS=1.22u PD=0.72u rfmode=0
M$824 \$I24313 \$I24301 \$I24307 VPWR sg13_lv_pmos L=0.13u W=0.42u AS=0.063p
+ AD=0.0798p PS=0.72u PD=0.8u rfmode=0
M$825 \$I24307 \$I24312 \$I24302 VPWR sg13_lv_pmos L=0.13u W=0.42u AS=0.0798p
+ AD=0.1428p PS=0.8u PD=1.52u rfmode=0
M$826 \$I24317 \$I24316 \$I24322 VGND sg13_lv_nmos L=0.13u W=0.42u AS=0.1296p
+ AD=0.0798p PS=1.52u PD=0.8u rfmode=0
M$827 \$I24322 \$I24327 \$I24318 VGND sg13_lv_nmos L=0.13u W=0.42u AS=0.0798p
+ AD=0.2373p PS=0.8u PD=1.97u rfmode=0
M$828 \$I24321 \$I24323 VGND VGND sg13_lv_nmos L=0.13u W=0.74u AS=0.2516p
+ AD=0.1406p PS=2.16u PD=1.12u rfmode=0
M$829 VGND \$I24321 \$2270 VGND sg13_lv_nmos L=0.13u W=0.74u AS=0.1406p
+ AD=0.2516p PS=1.12u PD=2.16u rfmode=0
M$830 VGND \$2207 \$I24325 VGND sg13_lv_nmos L=0.13u W=0.42u AS=0.1701p
+ AD=0.0378p PS=1.65u PD=0.6u rfmode=0
M$831 \$I24325 \$I24315 \$I24318 VGND sg13_lv_nmos L=0.13u W=0.42u AS=0.0378p
+ AD=0.1428p PS=0.6u PD=1.52u rfmode=0
M$832 \$I24319 \$I24320 VGND VGND sg13_lv_nmos L=0.13u W=0.42u AS=0.1428p
+ AD=0.0798p PS=1.52u PD=0.8u rfmode=0
M$833 VGND \$2207 \$I24326 VGND sg13_lv_nmos L=0.13u W=0.42u AS=0.0798p
+ AD=0.0378p PS=0.8u PD=0.6u rfmode=0
M$834 \$I24326 \$I24323 \$I24320 VGND sg13_lv_nmos L=0.13u W=0.42u AS=0.0378p
+ AD=0.1428p PS=0.6u PD=1.52u rfmode=0
M$835 VGND \$I24316 \$I24327 VGND sg13_lv_nmos L=0.13u W=0.74u AS=0.317325p
+ AD=0.2516p PS=1.805u PD=2.16u rfmode=0
M$836 VGND \$2357 \$I24316 VGND sg13_lv_nmos L=0.13u W=0.74u AS=0.317325p
+ AD=0.2516p PS=1.805u PD=2.16u rfmode=0
M$837 \$I24317 \$2264 \$I24324 VGND sg13_lv_nmos L=0.13u W=0.42u AS=0.1428p
+ AD=0.0609p PS=1.52u PD=0.71u rfmode=0
M$838 \$I24324 \$2207 VGND VGND sg13_lv_nmos L=0.13u W=0.42u AS=0.0609p
+ AD=0.1626p PS=0.71u PD=1.415u rfmode=0
M$839 VGND \$I24322 \$I24315 VGND sg13_lv_nmos L=0.13u W=0.74u AS=0.1626p
+ AD=0.2516p PS=1.415u PD=2.16u rfmode=0
M$840 \$I24323 \$I24316 \$I24319 VGND sg13_lv_nmos L=0.13u W=0.42u AS=0.12665p
+ AD=0.1428p PS=1.145u PD=1.52u rfmode=0
M$841 \$I24315 \$I24327 \$I24323 VGND sg13_lv_nmos L=0.13u W=0.74u AS=0.3473p
+ AD=0.12665p PS=2.71u PD=1.145u rfmode=0
M$842 \$I24323 \$I24327 \$I24329 VPWR sg13_lv_pmos L=0.13u W=0.42u AS=0.2048p
+ AD=0.09345p PS=1.63u PD=0.865u rfmode=0
M$843 \$I24329 \$I24320 VPWR VPWR sg13_lv_pmos L=0.13u W=0.42u AS=0.09345p
+ AD=0.204p PS=0.865u PD=1.835u rfmode=0
M$844 VPWR \$2207 \$I24320 VPWR sg13_lv_pmos L=0.13u W=0.42u AS=0.204p
+ AD=0.0798p PS=1.835u PD=0.8u rfmode=0
M$845 \$I24320 \$I24323 VPWR VPWR sg13_lv_pmos L=0.13u W=0.42u AS=0.0798p
+ AD=0.4659p PS=0.8u PD=3.65u rfmode=0
M$846 \$I24315 \$I24316 \$I24323 VPWR sg13_lv_pmos L=0.13u W=1u AS=0.34p
+ AD=0.2048p PS=2.68u PD=1.63u rfmode=0
M$847 \$I24321 \$I24323 VPWR VPWR sg13_lv_pmos L=0.13u W=1.12u AS=0.3864p
+ AD=0.2128p PS=2.93u PD=1.5u rfmode=0
M$848 VPWR \$I24321 \$2270 VPWR sg13_lv_pmos L=0.13u W=1.12u AS=0.2128p
+ AD=0.3808p PS=1.5u PD=2.92u rfmode=0
M$849 VPWR \$2264 \$I24317 VPWR sg13_lv_pmos L=0.13u W=0.42u AS=0.1428p
+ AD=0.0798p PS=1.52u PD=0.8u rfmode=0
M$850 VPWR \$2207 \$I24317 VPWR sg13_lv_pmos L=0.13u W=0.42u AS=0.3623875p
+ AD=0.0798p PS=2.605u PD=0.8u rfmode=0
M$851 VPWR \$I24322 \$I24315 VPWR sg13_lv_pmos L=0.13u W=1u AS=0.3623875p
+ AD=0.34p PS=2.605u PD=2.68u rfmode=0
M$852 \$I24327 \$I24316 VPWR VPWR sg13_lv_pmos L=0.13u W=1.12u AS=0.3864p
+ AD=0.41165p PS=2.93u PD=2.12u rfmode=0
M$853 VPWR \$2357 \$I24316 VPWR sg13_lv_pmos L=0.13u W=1.12u AS=0.41165p
+ AD=0.4088p PS=2.12u PD=2.97u rfmode=0
M$854 \$I24322 \$2207 VPWR VPWR sg13_lv_pmos L=0.13u W=0.42u AS=0.147p
+ AD=0.1563p PS=1.54u PD=1.22u rfmode=0
M$855 VPWR \$I24315 \$I24328 VPWR sg13_lv_pmos L=0.13u W=0.42u AS=0.1563p
+ AD=0.063p PS=1.22u PD=0.72u rfmode=0
M$856 \$I24328 \$I24316 \$I24322 VPWR sg13_lv_pmos L=0.13u W=0.42u AS=0.063p
+ AD=0.0798p PS=0.72u PD=0.8u rfmode=0
M$857 \$I24322 \$I24327 \$I24317 VPWR sg13_lv_pmos L=0.13u W=0.42u AS=0.0798p
+ AD=0.1428p PS=0.8u PD=1.52u rfmode=0
M$858 \$I24332 \$I24331 \$I24337 VGND sg13_lv_nmos L=0.13u W=0.42u AS=0.1296p
+ AD=0.0798p PS=1.52u PD=0.8u rfmode=0
M$859 \$I24337 \$I24342 \$I24333 VGND sg13_lv_nmos L=0.13u W=0.42u AS=0.0798p
+ AD=0.2373p PS=0.8u PD=1.97u rfmode=0
M$860 \$I24336 \$I24338 VGND VGND sg13_lv_nmos L=0.13u W=0.74u AS=0.2516p
+ AD=0.1406p PS=2.16u PD=1.12u rfmode=0
M$861 VGND \$I24336 \$2011 VGND sg13_lv_nmos L=0.13u W=0.74u AS=0.1406p
+ AD=0.2516p PS=1.12u PD=2.16u rfmode=0
M$862 VGND \$2092 \$I24340 VGND sg13_lv_nmos L=0.13u W=0.42u AS=0.1701p
+ AD=0.0378p PS=1.65u PD=0.6u rfmode=0
M$863 \$I24340 \$I24330 \$I24333 VGND sg13_lv_nmos L=0.13u W=0.42u AS=0.0378p
+ AD=0.1428p PS=0.6u PD=1.52u rfmode=0
M$864 \$I24334 \$I24335 VGND VGND sg13_lv_nmos L=0.13u W=0.42u AS=0.1428p
+ AD=0.0798p PS=1.52u PD=0.8u rfmode=0
M$865 VGND \$2092 \$I24341 VGND sg13_lv_nmos L=0.13u W=0.42u AS=0.0798p
+ AD=0.0378p PS=0.8u PD=0.6u rfmode=0
M$866 \$I24341 \$I24338 \$I24335 VGND sg13_lv_nmos L=0.13u W=0.42u AS=0.0378p
+ AD=0.1428p PS=0.6u PD=1.52u rfmode=0
M$867 VGND \$I24331 \$I24342 VGND sg13_lv_nmos L=0.13u W=0.74u AS=0.317325p
+ AD=0.2516p PS=1.805u PD=2.16u rfmode=0
M$868 VGND \$1887 \$I24331 VGND sg13_lv_nmos L=0.13u W=0.74u AS=0.317325p
+ AD=0.2516p PS=1.805u PD=2.16u rfmode=0
M$869 \$I24332 \$2138 \$I24339 VGND sg13_lv_nmos L=0.13u W=0.42u AS=0.1428p
+ AD=0.0609p PS=1.52u PD=0.71u rfmode=0
M$870 \$I24339 \$2092 VGND VGND sg13_lv_nmos L=0.13u W=0.42u AS=0.0609p
+ AD=0.1626p PS=0.71u PD=1.415u rfmode=0
M$871 VGND \$I24337 \$I24330 VGND sg13_lv_nmos L=0.13u W=0.74u AS=0.1626p
+ AD=0.2516p PS=1.415u PD=2.16u rfmode=0
M$872 \$I24338 \$I24331 \$I24334 VGND sg13_lv_nmos L=0.13u W=0.42u AS=0.12665p
+ AD=0.1428p PS=1.145u PD=1.52u rfmode=0
M$873 \$I24330 \$I24342 \$I24338 VGND sg13_lv_nmos L=0.13u W=0.74u AS=0.3473p
+ AD=0.12665p PS=2.71u PD=1.145u rfmode=0
M$874 \$I24338 \$I24342 \$I24344 VPWR sg13_lv_pmos L=0.13u W=0.42u AS=0.2048p
+ AD=0.09345p PS=1.63u PD=0.865u rfmode=0
M$875 \$I24344 \$I24335 VPWR VPWR sg13_lv_pmos L=0.13u W=0.42u AS=0.09345p
+ AD=0.204p PS=0.865u PD=1.835u rfmode=0
M$876 VPWR \$2092 \$I24335 VPWR sg13_lv_pmos L=0.13u W=0.42u AS=0.204p
+ AD=0.0798p PS=1.835u PD=0.8u rfmode=0
M$877 \$I24335 \$I24338 VPWR VPWR sg13_lv_pmos L=0.13u W=0.42u AS=0.0798p
+ AD=0.4659p PS=0.8u PD=3.65u rfmode=0
M$878 \$I24330 \$I24331 \$I24338 VPWR sg13_lv_pmos L=0.13u W=1u AS=0.34p
+ AD=0.2048p PS=2.68u PD=1.63u rfmode=0
M$879 \$I24336 \$I24338 VPWR VPWR sg13_lv_pmos L=0.13u W=1.12u AS=0.3864p
+ AD=0.2128p PS=2.93u PD=1.5u rfmode=0
M$880 VPWR \$I24336 \$2011 VPWR sg13_lv_pmos L=0.13u W=1.12u AS=0.2128p
+ AD=0.3808p PS=1.5u PD=2.92u rfmode=0
M$881 VPWR \$2138 \$I24332 VPWR sg13_lv_pmos L=0.13u W=0.42u AS=0.1428p
+ AD=0.0798p PS=1.52u PD=0.8u rfmode=0
M$882 VPWR \$2092 \$I24332 VPWR sg13_lv_pmos L=0.13u W=0.42u AS=0.3623875p
+ AD=0.0798p PS=2.605u PD=0.8u rfmode=0
M$883 VPWR \$I24337 \$I24330 VPWR sg13_lv_pmos L=0.13u W=1u AS=0.3623875p
+ AD=0.34p PS=2.605u PD=2.68u rfmode=0
M$884 \$I24342 \$I24331 VPWR VPWR sg13_lv_pmos L=0.13u W=1.12u AS=0.3864p
+ AD=0.41165p PS=2.93u PD=2.12u rfmode=0
M$885 VPWR \$1887 \$I24331 VPWR sg13_lv_pmos L=0.13u W=1.12u AS=0.41165p
+ AD=0.4088p PS=2.12u PD=2.97u rfmode=0
M$886 \$I24337 \$2092 VPWR VPWR sg13_lv_pmos L=0.13u W=0.42u AS=0.147p
+ AD=0.1563p PS=1.54u PD=1.22u rfmode=0
M$887 VPWR \$I24330 \$I24343 VPWR sg13_lv_pmos L=0.13u W=0.42u AS=0.1563p
+ AD=0.063p PS=1.22u PD=0.72u rfmode=0
M$888 \$I24343 \$I24331 \$I24337 VPWR sg13_lv_pmos L=0.13u W=0.42u AS=0.063p
+ AD=0.0798p PS=0.72u PD=0.8u rfmode=0
M$889 \$I24337 \$I24342 \$I24332 VPWR sg13_lv_pmos L=0.13u W=0.42u AS=0.0798p
+ AD=0.1428p PS=0.8u PD=1.52u rfmode=0
M$890 \$I24347 \$I24346 \$I24352 VGND sg13_lv_nmos L=0.13u W=0.42u AS=0.1296p
+ AD=0.0798p PS=1.52u PD=0.8u rfmode=0
M$891 \$I24352 \$I24357 \$I24348 VGND sg13_lv_nmos L=0.13u W=0.42u AS=0.0798p
+ AD=0.2373p PS=0.8u PD=1.97u rfmode=0
M$892 \$I24351 \$I24353 VGND VGND sg13_lv_nmos L=0.13u W=0.74u AS=0.2516p
+ AD=0.1406p PS=2.16u PD=1.12u rfmode=0
M$893 VGND \$I24351 \$1776 VGND sg13_lv_nmos L=0.13u W=0.74u AS=0.1406p
+ AD=0.2516p PS=1.12u PD=2.16u rfmode=0
M$894 VGND \$1783 \$I24355 VGND sg13_lv_nmos L=0.13u W=0.42u AS=0.1701p
+ AD=0.0378p PS=1.65u PD=0.6u rfmode=0
M$895 \$I24355 \$I24345 \$I24348 VGND sg13_lv_nmos L=0.13u W=0.42u AS=0.0378p
+ AD=0.1428p PS=0.6u PD=1.52u rfmode=0
M$896 \$I24349 \$I24350 VGND VGND sg13_lv_nmos L=0.13u W=0.42u AS=0.1428p
+ AD=0.0798p PS=1.52u PD=0.8u rfmode=0
M$897 VGND \$1783 \$I24356 VGND sg13_lv_nmos L=0.13u W=0.42u AS=0.0798p
+ AD=0.0378p PS=0.8u PD=0.6u rfmode=0
M$898 \$I24356 \$I24353 \$I24350 VGND sg13_lv_nmos L=0.13u W=0.42u AS=0.0378p
+ AD=0.1428p PS=0.6u PD=1.52u rfmode=0
M$899 VGND \$I24346 \$I24357 VGND sg13_lv_nmos L=0.13u W=0.74u AS=0.317325p
+ AD=0.2516p PS=1.805u PD=2.16u rfmode=0
M$900 VGND \$1781 \$I24346 VGND sg13_lv_nmos L=0.13u W=0.74u AS=0.317325p
+ AD=0.2516p PS=1.805u PD=2.16u rfmode=0
M$901 \$I24347 \$1832 \$I24354 VGND sg13_lv_nmos L=0.13u W=0.42u AS=0.1428p
+ AD=0.0609p PS=1.52u PD=0.71u rfmode=0
M$902 \$I24354 \$1783 VGND VGND sg13_lv_nmos L=0.13u W=0.42u AS=0.0609p
+ AD=0.1626p PS=0.71u PD=1.415u rfmode=0
M$903 VGND \$I24352 \$I24345 VGND sg13_lv_nmos L=0.13u W=0.74u AS=0.1626p
+ AD=0.2516p PS=1.415u PD=2.16u rfmode=0
M$904 \$I24353 \$I24346 \$I24349 VGND sg13_lv_nmos L=0.13u W=0.42u AS=0.12665p
+ AD=0.1428p PS=1.145u PD=1.52u rfmode=0
M$905 \$I24345 \$I24357 \$I24353 VGND sg13_lv_nmos L=0.13u W=0.74u AS=0.3473p
+ AD=0.12665p PS=2.71u PD=1.145u rfmode=0
M$906 \$I24353 \$I24357 \$I24359 VPWR sg13_lv_pmos L=0.13u W=0.42u AS=0.2048p
+ AD=0.09345p PS=1.63u PD=0.865u rfmode=0
M$907 \$I24359 \$I24350 VPWR VPWR sg13_lv_pmos L=0.13u W=0.42u AS=0.09345p
+ AD=0.204p PS=0.865u PD=1.835u rfmode=0
M$908 VPWR \$1783 \$I24350 VPWR sg13_lv_pmos L=0.13u W=0.42u AS=0.204p
+ AD=0.0798p PS=1.835u PD=0.8u rfmode=0
M$909 \$I24350 \$I24353 VPWR VPWR sg13_lv_pmos L=0.13u W=0.42u AS=0.0798p
+ AD=0.4659p PS=0.8u PD=3.65u rfmode=0
M$910 \$I24345 \$I24346 \$I24353 VPWR sg13_lv_pmos L=0.13u W=1u AS=0.34p
+ AD=0.2048p PS=2.68u PD=1.63u rfmode=0
M$911 \$I24351 \$I24353 VPWR VPWR sg13_lv_pmos L=0.13u W=1.12u AS=0.3864p
+ AD=0.2128p PS=2.93u PD=1.5u rfmode=0
M$912 VPWR \$I24351 \$1776 VPWR sg13_lv_pmos L=0.13u W=1.12u AS=0.2128p
+ AD=0.3808p PS=1.5u PD=2.92u rfmode=0
M$913 VPWR \$1832 \$I24347 VPWR sg13_lv_pmos L=0.13u W=0.42u AS=0.1428p
+ AD=0.0798p PS=1.52u PD=0.8u rfmode=0
M$914 VPWR \$1783 \$I24347 VPWR sg13_lv_pmos L=0.13u W=0.42u AS=0.3623875p
+ AD=0.0798p PS=2.605u PD=0.8u rfmode=0
M$915 VPWR \$I24352 \$I24345 VPWR sg13_lv_pmos L=0.13u W=1u AS=0.3623875p
+ AD=0.34p PS=2.605u PD=2.68u rfmode=0
M$916 \$I24357 \$I24346 VPWR VPWR sg13_lv_pmos L=0.13u W=1.12u AS=0.3864p
+ AD=0.41165p PS=2.93u PD=2.12u rfmode=0
M$917 VPWR \$1781 \$I24346 VPWR sg13_lv_pmos L=0.13u W=1.12u AS=0.41165p
+ AD=0.4088p PS=2.12u PD=2.97u rfmode=0
M$918 \$I24352 \$1783 VPWR VPWR sg13_lv_pmos L=0.13u W=0.42u AS=0.147p
+ AD=0.1563p PS=1.54u PD=1.22u rfmode=0
M$919 VPWR \$I24345 \$I24358 VPWR sg13_lv_pmos L=0.13u W=0.42u AS=0.1563p
+ AD=0.063p PS=1.22u PD=0.72u rfmode=0
M$920 \$I24358 \$I24346 \$I24352 VPWR sg13_lv_pmos L=0.13u W=0.42u AS=0.063p
+ AD=0.0798p PS=0.72u PD=0.8u rfmode=0
M$921 \$I24352 \$I24357 \$I24347 VPWR sg13_lv_pmos L=0.13u W=0.42u AS=0.0798p
+ AD=0.1428p PS=0.8u PD=1.52u rfmode=0
R$922 \$2781 \$1651 VGND rhigh w=1.78u l=2u ps=0.18u b=3 m=1
M$923 \$2133 \$2133 \$2133 VAPWR sg13_hv_pmos L=0.5u W=4u AS=1.36p AD=1.36p
+ PS=8.68u PD=8.68u rfmode=0
M$924 \$2135 \$2135 \$2135 VAPWR sg13_hv_pmos L=0.5u W=4u AS=1.36p AD=1.36p
+ PS=8.68u PD=8.68u rfmode=0
M$925 \$3128 \$3128 \$3128 VAPWR sg13_hv_pmos L=0.5u W=4u AS=1.36p AD=1.36p
+ PS=8.68u PD=8.68u rfmode=0
M$926 \$3128 analog_1 \$3136 VAPWR sg13_hv_pmos L=0.5u W=16u AS=5.44p AD=5.44p
+ PS=34.72u PD=34.72u rfmode=0
M$928 \$3129 \$3129 \$3129 VAPWR sg13_hv_pmos L=0.5u W=4u AS=1.36p AD=1.36p
+ PS=8.68u PD=8.68u rfmode=0
M$931 \$3129 \$3026 \$3136 VAPWR sg13_hv_pmos L=0.5u W=16u AS=5.44p AD=5.44p
+ PS=34.72u PD=34.72u rfmode=0
M$935 \$3136 \$3136 \$3136 VAPWR sg13_hv_pmos L=0.5u W=12u AS=4.08p AD=4.08p
+ PS=26.04u PD=26.04u rfmode=0
R$937 VGND \$3140 VGND rhigh w=1.78u l=2u ps=0.18u b=2 m=1
R$938 \$1239 \$2039 VGND rhigh w=2u l=1.4u ps=0u b=0 m=1
R$939 \$2039 \$3026 VGND rhigh w=2u l=1.4u ps=0u b=0 m=1
M$940 \$3129 \$3128 VGND VGND sg13_hv_nmos L=0.5u W=8u AS=2.72p AD=2.72p
+ PS=18.72u PD=18.72u rfmode=0
M$943 \$3128 \$3128 VGND VGND sg13_hv_nmos L=0.5u W=8u AS=2.72p AD=2.72p
+ PS=18.72u PD=18.72u rfmode=0
R$945 \$3023 VGND VGND rhigh w=1.78u l=2u ps=0.18u b=8 m=1
M$946 \$3129 \$3129 \$3129 VGND sg13_hv_nmos L=0.5u W=2u AS=0.68p AD=0.68p
+ PS=4.68u PD=4.68u rfmode=0
R$947 \$1596 \$1475 VGND rsil w=0.5u l=0.5u ps=0u b=0 m=1
R$948 VGND \$4233 VGND rhigh w=2u l=10u ps=0u b=0 m=1
R$949 VGND \$4139 VGND rhigh w=2u l=8u ps=0u b=0 m=1
M$950 analog_1 analog_1 \$4139 \$4139 sg13_hv_pmos L=0.5u W=20u AS=4.1p AD=4.1p
+ PS=26.1u PD=26.1u rfmode=0
R$960 VGND \$4573 VGND rhigh w=1.78u l=2u ps=0.18u b=2 m=1
R$961 \$4396 \$3503 VGND rhigh w=1.78u l=2u ps=0.18u b=3 m=1
R$962 \$4396 VAPWR VGND rhigh w=1.78u l=2u ps=0.18u b=9 m=1
R$963 \$4498 VAPWR VGND rhigh w=1.78u l=2u ps=0.18u b=10 m=1
M$969 \$3128 \$3128 \$3128 VGND sg13_hv_nmos L=0.5u W=2u AS=0.68p AD=0.68p
+ PS=4.68u PD=4.68u rfmode=0
R$970 VGND \$4030 VGND rhigh w=1.78u l=2u ps=0.18u b=2 m=1
R$971 VAPWR \$4031 VGND rhigh w=1.78u l=2u ps=0.18u b=9 m=1
R$972 VAPWR \$3026 VGND rhigh w=2u l=28.8u ps=0u b=0 m=1
R$973 VGND \$3027 VGND rhigh w=1.78u l=2u ps=0.18u b=15 m=1
M$974 VGND \$766 \$I24360 VGND sg13_lv_nmos L=0.13u W=0.55u AS=0.14875p
+ AD=0.187p PS=1.16u PD=1.78u rfmode=0
M$975 VGND \$I24360 q0_d VGND sg13_lv_nmos L=0.13u W=0.74u AS=0.14875p
+ AD=0.2886p PS=1.16u PD=2.26u rfmode=0
M$976 VPWR \$766 \$I24360 VPWR sg13_lv_pmos L=0.13u W=0.84u AS=0.2114p
+ AD=0.2856p PS=1.54u PD=2.36u rfmode=0
M$977 VPWR \$I24360 q0_d VPWR sg13_lv_pmos L=0.13u W=1.12u AS=0.2114p AD=0.42p
+ PS=1.54u PD=2.99u rfmode=0
M$978 VGND \$1926 \$I24361 VGND sg13_lv_nmos L=0.13u W=0.55u AS=0.14875p
+ AD=0.187p PS=1.16u PD=1.78u rfmode=0
M$979 VGND \$I24361 q2_d VGND sg13_lv_nmos L=0.13u W=0.74u AS=0.14875p
+ AD=0.2886p PS=1.16u PD=2.26u rfmode=0
M$980 VPWR \$1926 \$I24361 VPWR sg13_lv_pmos L=0.13u W=0.84u AS=0.2114p
+ AD=0.2856p PS=1.54u PD=2.36u rfmode=0
M$981 VPWR \$I24361 q2_d VPWR sg13_lv_pmos L=0.13u W=1.12u AS=0.2114p AD=0.42p
+ PS=1.54u PD=2.99u rfmode=0
M$982 VGND \$1769 \$I24362 VGND sg13_lv_nmos L=0.13u W=0.55u AS=0.14875p
+ AD=0.187p PS=1.16u PD=1.78u rfmode=0
M$983 VGND \$I24362 q1_d VGND sg13_lv_nmos L=0.13u W=0.74u AS=0.14875p
+ AD=0.2886p PS=1.16u PD=2.26u rfmode=0
M$984 VPWR \$1769 \$I24362 VPWR sg13_lv_pmos L=0.13u W=0.84u AS=0.2114p
+ AD=0.2856p PS=1.54u PD=2.36u rfmode=0
M$985 VPWR \$I24362 q1_d VPWR sg13_lv_pmos L=0.13u W=1.12u AS=0.2114p AD=0.42p
+ PS=1.54u PD=2.99u rfmode=0
M$986 VGND q2 \$I24363 VGND sg13_lv_nmos L=0.13u W=0.55u AS=0.14875p AD=0.187p
+ PS=1.16u PD=1.78u rfmode=0
M$987 VGND \$I24363 \$3637 VGND sg13_lv_nmos L=0.13u W=0.74u AS=0.14875p
+ AD=0.2886p PS=1.16u PD=2.26u rfmode=0
M$988 VPWR q2 \$I24363 VPWR sg13_lv_pmos L=0.13u W=0.84u AS=0.2114p AD=0.2856p
+ PS=1.54u PD=2.36u rfmode=0
M$989 VPWR \$I24363 \$3637 VPWR sg13_lv_pmos L=0.13u W=1.12u AS=0.2114p
+ AD=0.42p PS=1.54u PD=2.99u rfmode=0
M$990 VGND q3 \$I24364 VGND sg13_lv_nmos L=0.13u W=0.55u AS=0.14875p AD=0.187p
+ PS=1.16u PD=1.78u rfmode=0
M$991 VGND \$I24364 \$4503 VGND sg13_lv_nmos L=0.13u W=0.74u AS=0.14875p
+ AD=0.2886p PS=1.16u PD=2.26u rfmode=0
M$992 VPWR q3 \$I24364 VPWR sg13_lv_pmos L=0.13u W=0.84u AS=0.2114p AD=0.2856p
+ PS=1.54u PD=2.36u rfmode=0
M$993 VPWR \$I24364 \$4503 VPWR sg13_lv_pmos L=0.13u W=1.12u AS=0.2114p
+ AD=0.42p PS=1.54u PD=2.99u rfmode=0
M$994 VGND \$1717 \$I24365 VGND sg13_lv_nmos L=0.13u W=0.55u AS=0.14875p
+ AD=0.187p PS=1.16u PD=1.78u rfmode=0
M$995 VGND \$I24365 \$1654 VGND sg13_lv_nmos L=0.13u W=0.74u AS=0.14875p
+ AD=0.2886p PS=1.16u PD=2.26u rfmode=0
M$996 VPWR \$1717 \$I24365 VPWR sg13_lv_pmos L=0.13u W=0.84u AS=0.2114p
+ AD=0.2856p PS=1.54u PD=2.36u rfmode=0
M$997 VPWR \$I24365 \$1654 VPWR sg13_lv_pmos L=0.13u W=1.12u AS=0.2114p
+ AD=0.42p PS=1.54u PD=2.99u rfmode=0
M$998 VGND data_in_tx \$I24366 VGND sg13_lv_nmos L=0.13u W=0.55u AS=0.14875p
+ AD=0.187p PS=1.16u PD=1.78u rfmode=0
M$999 VGND \$I24366 \$3782 VGND sg13_lv_nmos L=0.13u W=0.74u AS=0.14875p
+ AD=0.2886p PS=1.16u PD=2.26u rfmode=0
M$1000 VPWR data_in_tx \$I24366 VPWR sg13_lv_pmos L=0.13u W=0.84u AS=0.2114p
+ AD=0.2856p PS=1.54u PD=2.36u rfmode=0
M$1001 VPWR \$I24366 \$3782 VPWR sg13_lv_pmos L=0.13u W=1.12u AS=0.2114p
+ AD=0.42p PS=1.54u PD=2.99u rfmode=0
M$1002 VGND \$824 \$I24367 VGND sg13_lv_nmos L=0.13u W=0.55u AS=0.14875p
+ AD=0.187p PS=1.16u PD=1.78u rfmode=0
M$1003 VGND \$I24367 vctrl_in VGND sg13_lv_nmos L=0.13u W=0.74u AS=0.14875p
+ AD=0.2886p PS=1.16u PD=2.26u rfmode=0
M$1004 VPWR \$824 \$I24367 VPWR sg13_lv_pmos L=0.13u W=0.84u AS=0.2114p
+ AD=0.2856p PS=1.54u PD=2.36u rfmode=0
M$1005 VPWR \$I24367 vctrl_in VPWR sg13_lv_pmos L=0.13u W=1.12u AS=0.2114p
+ AD=0.42p PS=1.54u PD=2.99u rfmode=0
M$1006 VGND \$1682 \$I24368 VGND sg13_lv_nmos L=0.13u W=0.55u AS=0.14875p
+ AD=0.187p PS=1.16u PD=1.78u rfmode=0
M$1007 VGND \$I24368 \$2062 VGND sg13_lv_nmos L=0.13u W=0.74u AS=0.14875p
+ AD=0.2886p PS=1.16u PD=2.26u rfmode=0
M$1008 VPWR \$1682 \$I24368 VPWR sg13_lv_pmos L=0.13u W=0.84u AS=0.2114p
+ AD=0.2856p PS=1.54u PD=2.36u rfmode=0
M$1009 VPWR \$I24368 \$2062 VPWR sg13_lv_pmos L=0.13u W=1.12u AS=0.2114p
+ AD=0.42p PS=1.54u PD=2.99u rfmode=0
M$1010 VGND q1 \$I24369 VGND sg13_lv_nmos L=0.13u W=0.55u AS=0.14875p AD=0.187p
+ PS=1.16u PD=1.78u rfmode=0
M$1011 VGND \$I24369 \$3380 VGND sg13_lv_nmos L=0.13u W=0.74u AS=0.14875p
+ AD=0.2886p PS=1.16u PD=2.26u rfmode=0
M$1012 VPWR q1 \$I24369 VPWR sg13_lv_pmos L=0.13u W=0.84u AS=0.2114p AD=0.2856p
+ PS=1.54u PD=2.36u rfmode=0
M$1013 VPWR \$I24369 \$3380 VPWR sg13_lv_pmos L=0.13u W=1.12u AS=0.2114p
+ AD=0.42p PS=1.54u PD=2.99u rfmode=0
M$1014 VGND \$2411 \$I24370 VGND sg13_lv_nmos L=0.13u W=0.55u AS=0.14875p
+ AD=0.187p PS=1.16u PD=1.78u rfmode=0
M$1015 VGND \$I24370 q3_d VGND sg13_lv_nmos L=0.13u W=0.74u AS=0.14875p
+ AD=0.2886p PS=1.16u PD=2.26u rfmode=0
M$1016 VPWR \$2411 \$I24370 VPWR sg13_lv_pmos L=0.13u W=0.84u AS=0.2114p
+ AD=0.2856p PS=1.54u PD=2.36u rfmode=0
M$1017 VPWR \$I24370 q3_d VPWR sg13_lv_pmos L=0.13u W=1.12u AS=0.2114p AD=0.42p
+ PS=1.54u PD=2.99u rfmode=0
M$1018 VGND q0 \$I24371 VGND sg13_lv_nmos L=0.13u W=0.55u AS=0.14875p AD=0.187p
+ PS=1.16u PD=1.78u rfmode=0
M$1019 VGND \$I24371 \$2915 VGND sg13_lv_nmos L=0.13u W=0.74u AS=0.14875p
+ AD=0.2886p PS=1.16u PD=2.26u rfmode=0
M$1020 VPWR q0 \$I24371 VPWR sg13_lv_pmos L=0.13u W=0.84u AS=0.2114p AD=0.2856p
+ PS=1.54u PD=2.36u rfmode=0
M$1021 VPWR \$I24371 \$2915 VPWR sg13_lv_pmos L=0.13u W=1.12u AS=0.2114p
+ AD=0.42p PS=1.54u PD=2.99u rfmode=0
M$1022 VGND \$1654 \$I24372 VGND sg13_lv_nmos L=0.13u W=0.55u AS=0.14875p
+ AD=0.187p PS=1.16u PD=1.78u rfmode=0
M$1023 VGND \$I24372 clk_ref VGND sg13_lv_nmos L=0.13u W=0.74u AS=0.14875p
+ AD=0.2886p PS=1.16u PD=2.26u rfmode=0
M$1024 VPWR \$1654 \$I24372 VPWR sg13_lv_pmos L=0.13u W=0.84u AS=0.2114p
+ AD=0.2856p PS=1.54u PD=2.36u rfmode=0
M$1025 VPWR \$I24372 clk_ref VPWR sg13_lv_pmos L=0.13u W=1.12u AS=0.2114p
+ AD=0.42p PS=1.54u PD=2.99u rfmode=0
M$1026 VGND rst_n_in \$I24373 VGND sg13_lv_nmos L=0.13u W=0.55u AS=0.14875p
+ AD=0.187p PS=1.16u PD=1.78u rfmode=0
M$1027 VGND \$I24373 \$1682 VGND sg13_lv_nmos L=0.13u W=0.74u AS=0.14875p
+ AD=0.2886p PS=1.16u PD=2.26u rfmode=0
M$1028 VPWR rst_n_in \$I24373 VPWR sg13_lv_pmos L=0.13u W=0.84u AS=0.2114p
+ AD=0.2856p PS=1.54u PD=2.36u rfmode=0
M$1029 VPWR \$I24373 \$1682 VPWR sg13_lv_pmos L=0.13u W=1.12u AS=0.2114p
+ AD=0.42p PS=1.54u PD=2.99u rfmode=0
M$1030 VGND \$2062 \$I24374 VGND sg13_lv_nmos L=0.13u W=0.55u AS=0.14875p
+ AD=0.187p PS=1.16u PD=1.78u rfmode=0
M$1031 VGND \$I24374 rst_n VGND sg13_lv_nmos L=0.13u W=0.74u AS=0.14875p
+ AD=0.2886p PS=1.16u PD=2.26u rfmode=0
M$1032 VPWR \$2062 \$I24374 VPWR sg13_lv_pmos L=0.13u W=0.84u AS=0.2114p
+ AD=0.2856p PS=1.54u PD=2.36u rfmode=0
M$1033 VPWR \$I24374 rst_n VPWR sg13_lv_pmos L=0.13u W=1.12u AS=0.2114p
+ AD=0.42p PS=1.54u PD=2.99u rfmode=0
M$1034 VGND \$548 \$I24375 VGND sg13_lv_nmos L=0.13u W=0.55u AS=0.14875p
+ AD=0.187p PS=1.16u PD=1.78u rfmode=0
M$1035 VGND \$I24375 vctrl_b_in VGND sg13_lv_nmos L=0.13u W=0.74u AS=0.14875p
+ AD=0.2886p PS=1.16u PD=2.26u rfmode=0
M$1036 VPWR \$548 \$I24375 VPWR sg13_lv_pmos L=0.13u W=0.84u AS=0.2114p
+ AD=0.2856p PS=1.54u PD=2.36u rfmode=0
M$1037 VPWR \$I24375 vctrl_b_in VPWR sg13_lv_pmos L=0.13u W=1.12u AS=0.2114p
+ AD=0.42p PS=1.54u PD=2.99u rfmode=0
M$1038 VGND \$I24377 \$I24376 VGND sg13_lv_nmos L=0.5u W=0.42u AS=0.1426p
+ AD=0.1428p PS=1.16u PD=1.52u rfmode=0
M$1039 VGND \$I24376 \$2102 VGND sg13_lv_nmos L=0.13u W=0.74u AS=0.1426p
+ AD=0.2516p PS=1.16u PD=2.16u rfmode=0
M$1040 \$I24378 \$2103 VGND VGND sg13_lv_nmos L=0.13u W=0.42u AS=0.1428p
+ AD=0.0798p PS=1.52u PD=0.8u rfmode=0
M$1041 VGND \$I24378 \$I24377 VGND sg13_lv_nmos L=0.5u W=0.42u AS=0.0798p
+ AD=0.1428p PS=0.8u PD=1.52u rfmode=0
M$1042 \$I24376 \$I24377 VPWR VPWR sg13_lv_pmos L=0.5u W=1u AS=0.34p AD=0.2254p
+ PS=2.68u PD=1.53u rfmode=0
M$1043 VPWR \$I24376 \$2102 VPWR sg13_lv_pmos L=0.13u W=1.12u AS=0.2254p
+ AD=0.4256p PS=1.53u PD=3u rfmode=0
M$1044 VPWR \$2103 \$I24378 VPWR sg13_lv_pmos L=0.13u W=0.42u AS=0.1523p
+ AD=0.1428p PS=1.38u PD=1.52u rfmode=0
M$1045 VPWR \$I24378 \$I24377 VPWR sg13_lv_pmos L=0.5u W=1u AS=0.1523p AD=0.34p
+ PS=1.38u PD=2.68u rfmode=0
M$1046 VGND \$I24380 \$I24379 VGND sg13_lv_nmos L=0.5u W=0.42u AS=0.1426p
+ AD=0.1428p PS=1.16u PD=1.52u rfmode=0
M$1047 VGND \$I24379 \$4103 VGND sg13_lv_nmos L=0.13u W=0.74u AS=0.1426p
+ AD=0.2516p PS=1.16u PD=2.16u rfmode=0
M$1048 \$I24381 \$4148 VGND VGND sg13_lv_nmos L=0.13u W=0.42u AS=0.1428p
+ AD=0.0798p PS=1.52u PD=0.8u rfmode=0
M$1049 VGND \$I24381 \$I24380 VGND sg13_lv_nmos L=0.5u W=0.42u AS=0.0798p
+ AD=0.1428p PS=0.8u PD=1.52u rfmode=0
M$1050 \$I24379 \$I24380 VPWR VPWR sg13_lv_pmos L=0.5u W=1u AS=0.34p AD=0.2254p
+ PS=2.68u PD=1.53u rfmode=0
M$1051 VPWR \$I24379 \$4103 VPWR sg13_lv_pmos L=0.13u W=1.12u AS=0.2254p
+ AD=0.4256p PS=1.53u PD=3u rfmode=0
M$1052 VPWR \$4148 \$I24381 VPWR sg13_lv_pmos L=0.13u W=0.42u AS=0.1523p
+ AD=0.1428p PS=1.38u PD=1.52u rfmode=0
M$1053 VPWR \$I24381 \$I24380 VPWR sg13_lv_pmos L=0.5u W=1u AS=0.1523p AD=0.34p
+ PS=1.38u PD=2.68u rfmode=0
M$1054 VGND \$I24383 \$I24382 VGND sg13_lv_nmos L=0.5u W=0.42u AS=0.1426p
+ AD=0.1428p PS=1.16u PD=1.52u rfmode=0
M$1055 VGND \$I24382 \$1778 VGND sg13_lv_nmos L=0.13u W=0.74u AS=0.1426p
+ AD=0.2516p PS=1.16u PD=2.16u rfmode=0
M$1056 \$I24384 \$1775 VGND VGND sg13_lv_nmos L=0.13u W=0.42u AS=0.1428p
+ AD=0.0798p PS=1.52u PD=0.8u rfmode=0
M$1057 VGND \$I24384 \$I24383 VGND sg13_lv_nmos L=0.5u W=0.42u AS=0.0798p
+ AD=0.1428p PS=0.8u PD=1.52u rfmode=0
M$1058 \$I24382 \$I24383 VPWR VPWR sg13_lv_pmos L=0.5u W=1u AS=0.34p AD=0.2254p
+ PS=2.68u PD=1.53u rfmode=0
M$1059 VPWR \$I24382 \$1778 VPWR sg13_lv_pmos L=0.13u W=1.12u AS=0.2254p
+ AD=0.4256p PS=1.53u PD=3u rfmode=0
M$1060 VPWR \$1775 \$I24384 VPWR sg13_lv_pmos L=0.13u W=0.42u AS=0.1523p
+ AD=0.1428p PS=1.38u PD=1.52u rfmode=0
M$1061 VPWR \$I24384 \$I24383 VPWR sg13_lv_pmos L=0.5u W=1u AS=0.1523p AD=0.34p
+ PS=1.38u PD=2.68u rfmode=0
M$1062 VGND \$I24386 \$I24385 VGND sg13_lv_nmos L=0.5u W=0.42u AS=0.1426p
+ AD=0.1428p PS=1.16u PD=1.52u rfmode=0
M$1063 VGND \$I24385 \$2097 VGND sg13_lv_nmos L=0.13u W=0.74u AS=0.1426p
+ AD=0.2516p PS=1.16u PD=2.16u rfmode=0
M$1064 \$I24387 \$2094 VGND VGND sg13_lv_nmos L=0.13u W=0.42u AS=0.1428p
+ AD=0.0798p PS=1.52u PD=0.8u rfmode=0
M$1065 VGND \$I24387 \$I24386 VGND sg13_lv_nmos L=0.5u W=0.42u AS=0.0798p
+ AD=0.1428p PS=0.8u PD=1.52u rfmode=0
M$1066 \$I24385 \$I24386 VPWR VPWR sg13_lv_pmos L=0.5u W=1u AS=0.34p AD=0.2254p
+ PS=2.68u PD=1.53u rfmode=0
M$1067 VPWR \$I24385 \$2097 VPWR sg13_lv_pmos L=0.13u W=1.12u AS=0.2254p
+ AD=0.4256p PS=1.53u PD=3u rfmode=0
M$1068 VPWR \$2094 \$I24387 VPWR sg13_lv_pmos L=0.13u W=0.42u AS=0.1523p
+ AD=0.1428p PS=1.38u PD=1.52u rfmode=0
M$1069 VPWR \$I24387 \$I24386 VPWR sg13_lv_pmos L=0.5u W=1u AS=0.1523p AD=0.34p
+ PS=1.38u PD=2.68u rfmode=0
M$1070 VGND \$I24389 \$I24388 VGND sg13_lv_nmos L=0.5u W=0.42u AS=0.1426p
+ AD=0.1428p PS=1.16u PD=1.52u rfmode=0
M$1071 VGND \$I24388 \$1770 VGND sg13_lv_nmos L=0.13u W=0.74u AS=0.1426p
+ AD=0.2516p PS=1.16u PD=2.16u rfmode=0
M$1072 \$I24390 \$2011 VGND VGND sg13_lv_nmos L=0.13u W=0.42u AS=0.1428p
+ AD=0.0798p PS=1.52u PD=0.8u rfmode=0
M$1073 VGND \$I24390 \$I24389 VGND sg13_lv_nmos L=0.5u W=0.42u AS=0.0798p
+ AD=0.1428p PS=0.8u PD=1.52u rfmode=0
M$1074 \$I24388 \$I24389 VPWR VPWR sg13_lv_pmos L=0.5u W=1u AS=0.34p AD=0.2254p
+ PS=2.68u PD=1.53u rfmode=0
M$1075 VPWR \$I24388 \$1770 VPWR sg13_lv_pmos L=0.13u W=1.12u AS=0.2254p
+ AD=0.4256p PS=1.53u PD=3u rfmode=0
M$1076 VPWR \$2011 \$I24390 VPWR sg13_lv_pmos L=0.13u W=0.42u AS=0.1523p
+ AD=0.1428p PS=1.38u PD=1.52u rfmode=0
M$1077 VPWR \$I24390 \$I24389 VPWR sg13_lv_pmos L=0.5u W=1u AS=0.1523p AD=0.34p
+ PS=1.38u PD=2.68u rfmode=0
M$1078 VGND \$I24392 \$I24391 VGND sg13_lv_nmos L=0.5u W=0.42u AS=0.1426p
+ AD=0.1428p PS=1.16u PD=1.52u rfmode=0
M$1079 VGND \$I24391 \$2208 VGND sg13_lv_nmos L=0.13u W=0.74u AS=0.1426p
+ AD=0.2516p PS=1.16u PD=2.16u rfmode=0
M$1080 \$I24393 \$2270 VGND VGND sg13_lv_nmos L=0.13u W=0.42u AS=0.1428p
+ AD=0.0798p PS=1.52u PD=0.8u rfmode=0
M$1081 VGND \$I24393 \$I24392 VGND sg13_lv_nmos L=0.5u W=0.42u AS=0.0798p
+ AD=0.1428p PS=0.8u PD=1.52u rfmode=0
M$1082 \$I24391 \$I24392 VPWR VPWR sg13_lv_pmos L=0.5u W=1u AS=0.34p AD=0.2254p
+ PS=2.68u PD=1.53u rfmode=0
M$1083 VPWR \$I24391 \$2208 VPWR sg13_lv_pmos L=0.13u W=1.12u AS=0.2254p
+ AD=0.4256p PS=1.53u PD=3u rfmode=0
M$1084 VPWR \$2270 \$I24393 VPWR sg13_lv_pmos L=0.13u W=0.42u AS=0.1523p
+ AD=0.1428p PS=1.38u PD=1.52u rfmode=0
M$1085 VPWR \$I24393 \$I24392 VPWR sg13_lv_pmos L=0.5u W=1u AS=0.1523p AD=0.34p
+ PS=1.38u PD=2.68u rfmode=0
M$1086 VGND \$I24395 \$I24394 VGND sg13_lv_nmos L=0.5u W=0.42u AS=0.1426p
+ AD=0.1428p PS=1.16u PD=1.52u rfmode=0
M$1087 VGND \$I24394 \$2858 VGND sg13_lv_nmos L=0.13u W=0.74u AS=0.1426p
+ AD=0.2516p PS=1.16u PD=2.16u rfmode=0
M$1088 \$I24396 \$3153 VGND VGND sg13_lv_nmos L=0.13u W=0.42u AS=0.1428p
+ AD=0.0798p PS=1.52u PD=0.8u rfmode=0
M$1089 VGND \$I24396 \$I24395 VGND sg13_lv_nmos L=0.5u W=0.42u AS=0.0798p
+ AD=0.1428p PS=0.8u PD=1.52u rfmode=0
M$1090 \$I24394 \$I24395 VPWR VPWR sg13_lv_pmos L=0.5u W=1u AS=0.34p AD=0.2254p
+ PS=2.68u PD=1.53u rfmode=0
M$1091 VPWR \$I24394 \$2858 VPWR sg13_lv_pmos L=0.13u W=1.12u AS=0.2254p
+ AD=0.4256p PS=1.53u PD=3u rfmode=0
M$1092 VPWR \$3153 \$I24396 VPWR sg13_lv_pmos L=0.13u W=0.42u AS=0.1523p
+ AD=0.1428p PS=1.38u PD=1.52u rfmode=0
M$1093 VPWR \$I24396 \$I24395 VPWR sg13_lv_pmos L=0.5u W=1u AS=0.1523p AD=0.34p
+ PS=1.38u PD=2.68u rfmode=0
M$1094 VGND \$I24398 \$I24397 VGND sg13_lv_nmos L=0.5u W=0.42u AS=0.1426p
+ AD=0.1428p PS=1.16u PD=1.52u rfmode=0
M$1095 VGND \$I24397 \$2562 VGND sg13_lv_nmos L=0.13u W=0.74u AS=0.1426p
+ AD=0.2516p PS=1.16u PD=2.16u rfmode=0
M$1096 \$I24399 \$2616 VGND VGND sg13_lv_nmos L=0.13u W=0.42u AS=0.1428p
+ AD=0.0798p PS=1.52u PD=0.8u rfmode=0
M$1097 VGND \$I24399 \$I24398 VGND sg13_lv_nmos L=0.5u W=0.42u AS=0.0798p
+ AD=0.1428p PS=0.8u PD=1.52u rfmode=0
M$1098 \$I24397 \$I24398 VPWR VPWR sg13_lv_pmos L=0.5u W=1u AS=0.34p AD=0.2254p
+ PS=2.68u PD=1.53u rfmode=0
M$1099 VPWR \$I24397 \$2562 VPWR sg13_lv_pmos L=0.13u W=1.12u AS=0.2254p
+ AD=0.4256p PS=1.53u PD=3u rfmode=0
M$1100 VPWR \$2616 \$I24399 VPWR sg13_lv_pmos L=0.13u W=0.42u AS=0.1523p
+ AD=0.1428p PS=1.38u PD=1.52u rfmode=0
M$1101 VPWR \$I24399 \$I24398 VPWR sg13_lv_pmos L=0.5u W=1u AS=0.1523p AD=0.34p
+ PS=1.38u PD=2.68u rfmode=0
M$1102 VGND \$I24401 \$I24400 VGND sg13_lv_nmos L=0.5u W=0.42u AS=0.1426p
+ AD=0.1428p PS=1.16u PD=1.52u rfmode=0
M$1103 VGND \$I24400 \$2049 VGND sg13_lv_nmos L=0.13u W=0.74u AS=0.1426p
+ AD=0.2516p PS=1.16u PD=2.16u rfmode=0
M$1104 \$I24402 \$1928 VGND VGND sg13_lv_nmos L=0.13u W=0.42u AS=0.1428p
+ AD=0.0798p PS=1.52u PD=0.8u rfmode=0
M$1105 VGND \$I24402 \$I24401 VGND sg13_lv_nmos L=0.5u W=0.42u AS=0.0798p
+ AD=0.1428p PS=0.8u PD=1.52u rfmode=0
M$1106 \$I24400 \$I24401 VPWR VPWR sg13_lv_pmos L=0.5u W=1u AS=0.34p AD=0.2254p
+ PS=2.68u PD=1.53u rfmode=0
M$1107 VPWR \$I24400 \$2049 VPWR sg13_lv_pmos L=0.13u W=1.12u AS=0.2254p
+ AD=0.4256p PS=1.53u PD=3u rfmode=0
M$1108 VPWR \$1928 \$I24402 VPWR sg13_lv_pmos L=0.13u W=0.42u AS=0.1523p
+ AD=0.1428p PS=1.38u PD=1.52u rfmode=0
M$1109 VPWR \$I24402 \$I24401 VPWR sg13_lv_pmos L=0.5u W=1u AS=0.1523p AD=0.34p
+ PS=1.38u PD=2.68u rfmode=0
M$1110 VGND \$I24404 \$I24403 VGND sg13_lv_nmos L=0.5u W=0.42u AS=0.1426p
+ AD=0.1428p PS=1.16u PD=1.52u rfmode=0
M$1111 VGND \$I24403 \$2138 VGND sg13_lv_nmos L=0.13u W=0.74u AS=0.1426p
+ AD=0.2516p PS=1.16u PD=2.16u rfmode=0
M$1112 \$I24405 \$2203 VGND VGND sg13_lv_nmos L=0.13u W=0.42u AS=0.1428p
+ AD=0.0798p PS=1.52u PD=0.8u rfmode=0
M$1113 VGND \$I24405 \$I24404 VGND sg13_lv_nmos L=0.5u W=0.42u AS=0.0798p
+ AD=0.1428p PS=0.8u PD=1.52u rfmode=0
M$1114 \$I24403 \$I24404 VPWR VPWR sg13_lv_pmos L=0.5u W=1u AS=0.34p AD=0.2254p
+ PS=2.68u PD=1.53u rfmode=0
M$1115 VPWR \$I24403 \$2138 VPWR sg13_lv_pmos L=0.13u W=1.12u AS=0.2254p
+ AD=0.4256p PS=1.53u PD=3u rfmode=0
M$1116 VPWR \$2203 \$I24405 VPWR sg13_lv_pmos L=0.13u W=0.42u AS=0.1523p
+ AD=0.1428p PS=1.38u PD=1.52u rfmode=0
M$1117 VPWR \$I24405 \$I24404 VPWR sg13_lv_pmos L=0.5u W=1u AS=0.1523p AD=0.34p
+ PS=1.38u PD=2.68u rfmode=0
M$1118 VGND \$I24407 \$I24406 VGND sg13_lv_nmos L=0.5u W=0.42u AS=0.1426p
+ AD=0.1428p PS=1.16u PD=1.52u rfmode=0
M$1119 VGND \$I24406 \$2264 VGND sg13_lv_nmos L=0.13u W=0.74u AS=0.1426p
+ AD=0.2516p PS=1.16u PD=2.16u rfmode=0
M$1120 \$I24408 \$2142 VGND VGND sg13_lv_nmos L=0.13u W=0.42u AS=0.1428p
+ AD=0.0798p PS=1.52u PD=0.8u rfmode=0
M$1121 VGND \$I24408 \$I24407 VGND sg13_lv_nmos L=0.5u W=0.42u AS=0.0798p
+ AD=0.1428p PS=0.8u PD=1.52u rfmode=0
M$1122 \$I24406 \$I24407 VPWR VPWR sg13_lv_pmos L=0.5u W=1u AS=0.34p AD=0.2254p
+ PS=2.68u PD=1.53u rfmode=0
M$1123 VPWR \$I24406 \$2264 VPWR sg13_lv_pmos L=0.13u W=1.12u AS=0.2254p
+ AD=0.4256p PS=1.53u PD=3u rfmode=0
M$1124 VPWR \$2142 \$I24408 VPWR sg13_lv_pmos L=0.13u W=0.42u AS=0.1523p
+ AD=0.1428p PS=1.38u PD=1.52u rfmode=0
M$1125 VPWR \$I24408 \$I24407 VPWR sg13_lv_pmos L=0.5u W=1u AS=0.1523p AD=0.34p
+ PS=1.38u PD=2.68u rfmode=0
M$1126 VGND \$I24410 \$I24409 VGND sg13_lv_nmos L=0.5u W=0.42u AS=0.1426p
+ AD=0.1428p PS=1.16u PD=1.52u rfmode=0
M$1127 VGND \$I24409 \$2054 VGND sg13_lv_nmos L=0.13u W=0.74u AS=0.1426p
+ AD=0.2516p PS=1.16u PD=2.16u rfmode=0
M$1128 \$I24411 \$1938 VGND VGND sg13_lv_nmos L=0.13u W=0.42u AS=0.1428p
+ AD=0.0798p PS=1.52u PD=0.8u rfmode=0
M$1129 VGND \$I24411 \$I24410 VGND sg13_lv_nmos L=0.5u W=0.42u AS=0.0798p
+ AD=0.1428p PS=0.8u PD=1.52u rfmode=0
M$1130 \$I24409 \$I24410 VPWR VPWR sg13_lv_pmos L=0.5u W=1u AS=0.34p AD=0.2254p
+ PS=2.68u PD=1.53u rfmode=0
M$1131 VPWR \$I24409 \$2054 VPWR sg13_lv_pmos L=0.13u W=1.12u AS=0.2254p
+ AD=0.4256p PS=1.53u PD=3u rfmode=0
M$1132 VPWR \$1938 \$I24411 VPWR sg13_lv_pmos L=0.13u W=0.42u AS=0.1523p
+ AD=0.1428p PS=1.38u PD=1.52u rfmode=0
M$1133 VPWR \$I24411 \$I24410 VPWR sg13_lv_pmos L=0.5u W=1u AS=0.1523p AD=0.34p
+ PS=1.38u PD=2.68u rfmode=0
M$1134 VGND \$I24413 \$I24412 VGND sg13_lv_nmos L=0.5u W=0.42u AS=0.1426p
+ AD=0.1428p PS=1.16u PD=1.52u rfmode=0
M$1135 VGND \$I24412 \$2014 VGND sg13_lv_nmos L=0.13u W=0.74u AS=0.1426p
+ AD=0.2516p PS=1.16u PD=2.16u rfmode=0
M$1136 \$I24414 \$2100 VGND VGND sg13_lv_nmos L=0.13u W=0.42u AS=0.1428p
+ AD=0.0798p PS=1.52u PD=0.8u rfmode=0
M$1137 VGND \$I24414 \$I24413 VGND sg13_lv_nmos L=0.5u W=0.42u AS=0.0798p
+ AD=0.1428p PS=0.8u PD=1.52u rfmode=0
M$1138 \$I24412 \$I24413 VPWR VPWR sg13_lv_pmos L=0.5u W=1u AS=0.34p AD=0.2254p
+ PS=2.68u PD=1.53u rfmode=0
M$1139 VPWR \$I24412 \$2014 VPWR sg13_lv_pmos L=0.13u W=1.12u AS=0.2254p
+ AD=0.4256p PS=1.53u PD=3u rfmode=0
M$1140 VPWR \$2100 \$I24414 VPWR sg13_lv_pmos L=0.13u W=0.42u AS=0.1523p
+ AD=0.1428p PS=1.38u PD=1.52u rfmode=0
M$1141 VPWR \$I24414 \$I24413 VPWR sg13_lv_pmos L=0.5u W=1u AS=0.1523p AD=0.34p
+ PS=1.38u PD=2.68u rfmode=0
M$1142 VGND \$I24416 \$I24415 VGND sg13_lv_nmos L=0.5u W=0.42u AS=0.1426p
+ AD=0.1428p PS=1.16u PD=1.52u rfmode=0
M$1143 VGND \$I24415 \$3194 VGND sg13_lv_nmos L=0.13u W=0.74u AS=0.1426p
+ AD=0.2516p PS=1.16u PD=2.16u rfmode=0
M$1144 \$I24417 \$3333 VGND VGND sg13_lv_nmos L=0.13u W=0.42u AS=0.1428p
+ AD=0.0798p PS=1.52u PD=0.8u rfmode=0
M$1145 VGND \$I24417 \$I24416 VGND sg13_lv_nmos L=0.5u W=0.42u AS=0.0798p
+ AD=0.1428p PS=0.8u PD=1.52u rfmode=0
M$1146 \$I24415 \$I24416 VPWR VPWR sg13_lv_pmos L=0.5u W=1u AS=0.34p AD=0.2254p
+ PS=2.68u PD=1.53u rfmode=0
M$1147 VPWR \$I24415 \$3194 VPWR sg13_lv_pmos L=0.13u W=1.12u AS=0.2254p
+ AD=0.4256p PS=1.53u PD=3u rfmode=0
M$1148 VPWR \$3333 \$I24417 VPWR sg13_lv_pmos L=0.13u W=0.42u AS=0.1523p
+ AD=0.1428p PS=1.38u PD=1.52u rfmode=0
M$1149 VPWR \$I24417 \$I24416 VPWR sg13_lv_pmos L=0.5u W=1u AS=0.1523p AD=0.34p
+ PS=1.38u PD=2.68u rfmode=0
M$1150 VGND \$I24419 \$I24418 VGND sg13_lv_nmos L=0.5u W=0.42u AS=0.1426p
+ AD=0.1428p PS=1.16u PD=1.52u rfmode=0
M$1151 VGND \$I24418 \$1832 VGND sg13_lv_nmos L=0.13u W=0.74u AS=0.1426p
+ AD=0.2516p PS=1.16u PD=2.16u rfmode=0
M$1152 \$I24420 \$1818 VGND VGND sg13_lv_nmos L=0.13u W=0.42u AS=0.1428p
+ AD=0.0798p PS=1.52u PD=0.8u rfmode=0
M$1153 VGND \$I24420 \$I24419 VGND sg13_lv_nmos L=0.5u W=0.42u AS=0.0798p
+ AD=0.1428p PS=0.8u PD=1.52u rfmode=0
M$1154 \$I24418 \$I24419 VPWR VPWR sg13_lv_pmos L=0.5u W=1u AS=0.34p AD=0.2254p
+ PS=2.68u PD=1.53u rfmode=0
M$1155 VPWR \$I24418 \$1832 VPWR sg13_lv_pmos L=0.13u W=1.12u AS=0.2254p
+ AD=0.4256p PS=1.53u PD=3u rfmode=0
M$1156 VPWR \$1818 \$I24420 VPWR sg13_lv_pmos L=0.13u W=0.42u AS=0.1523p
+ AD=0.1428p PS=1.38u PD=1.52u rfmode=0
M$1157 VPWR \$I24420 \$I24419 VPWR sg13_lv_pmos L=0.5u W=1u AS=0.1523p AD=0.34p
+ PS=1.38u PD=2.68u rfmode=0
M$1158 VGND \$1686 \$I24423 VGND sg13_lv_nmos L=0.13u W=0.74u AS=0.2516p
+ AD=0.1406p PS=2.16u PD=1.12u rfmode=0
M$1159 \$I24423 \$2100 \$I24422 VGND sg13_lv_nmos L=0.13u W=0.74u AS=0.1406p
+ AD=0.1406p PS=1.12u PD=1.12u rfmode=0
M$1160 \$I24422 \$2094 \$I24421 VGND sg13_lv_nmos L=0.13u W=0.74u AS=0.1406p
+ AD=0.1406p PS=1.12u PD=1.12u rfmode=0
M$1161 \$I24421 \$2208 \$1888 VGND sg13_lv_nmos L=0.13u W=0.74u AS=0.1406p
+ AD=0.2516p PS=1.12u PD=2.16u rfmode=0
M$1162 VPWR \$1686 \$1888 VPWR sg13_lv_pmos L=0.13u W=1.12u AS=0.3808p
+ AD=0.2128p PS=2.92u PD=1.5u rfmode=0
M$1163 \$1888 \$2100 VPWR VPWR sg13_lv_pmos L=0.13u W=1.12u AS=0.2128p
+ AD=0.2128p PS=1.5u PD=1.5u rfmode=0
M$1164 VPWR \$2094 \$1888 VPWR sg13_lv_pmos L=0.13u W=1.12u AS=0.2128p
+ AD=0.2128p PS=1.5u PD=1.5u rfmode=0
M$1165 \$1888 \$2208 VPWR VPWR sg13_lv_pmos L=0.13u W=1.12u AS=0.2128p
+ AD=0.3808p PS=1.5u PD=2.92u rfmode=0
M$1166 VGND \$1686 \$I24424 VGND sg13_lv_nmos L=0.13u W=0.74u AS=0.2516p
+ AD=0.1406p PS=2.16u PD=1.12u rfmode=0
M$1167 \$I24424 \$2100 \$2420 VGND sg13_lv_nmos L=0.13u W=0.74u AS=0.1406p
+ AD=0.2516p PS=1.12u PD=2.16u rfmode=0
M$1168 VPWR \$1686 \$2420 VPWR sg13_lv_pmos L=0.13u W=1.12u AS=0.3808p
+ AD=0.2128p PS=2.92u PD=1.5u rfmode=0
M$1169 \$2420 \$2100 VPWR VPWR sg13_lv_pmos L=0.13u W=1.12u AS=0.2128p
+ AD=0.3808p PS=1.5u PD=2.92u rfmode=0
M$1170 VGND \$1682 \$1889 VGND sg13_lv_nmos L=0.13u W=0.74u AS=0.2516p
+ AD=0.2516p PS=2.16u PD=2.16u rfmode=0
M$1171 VPWR \$1682 \$1889 VPWR sg13_lv_pmos L=0.13u W=1.12u AS=0.3808p
+ AD=0.3808p PS=2.92u PD=2.92u rfmode=0
M$1172 VGND \$2208 \$2202 VGND sg13_lv_nmos L=0.13u W=0.74u AS=0.2516p
+ AD=0.2516p PS=2.16u PD=2.16u rfmode=0
M$1173 VPWR \$2208 \$2202 VPWR sg13_lv_pmos L=0.13u W=1.12u AS=0.3808p
+ AD=0.3808p PS=2.92u PD=2.92u rfmode=0
M$1174 VGND \$2097 \$1893 VGND sg13_lv_nmos L=0.13u W=0.74u AS=0.2516p
+ AD=0.2516p PS=2.16u PD=2.16u rfmode=0
M$1175 VPWR \$2097 \$1893 VPWR sg13_lv_pmos L=0.13u W=1.12u AS=0.3808p
+ AD=0.3808p PS=2.92u PD=2.92u rfmode=0
M$1176 VGND \$1770 \$1772 VGND sg13_lv_nmos L=0.13u W=0.74u AS=0.2516p
+ AD=0.2516p PS=2.16u PD=2.16u rfmode=0
M$1177 VPWR \$1770 \$1772 VPWR sg13_lv_pmos L=0.13u W=1.12u AS=0.3808p
+ AD=0.3808p PS=2.92u PD=2.92u rfmode=0
M$1178 VGND \$1778 \$1681 VGND sg13_lv_nmos L=0.13u W=0.74u AS=0.2516p
+ AD=0.2516p PS=2.16u PD=2.16u rfmode=0
M$1179 VPWR \$1778 \$1681 VPWR sg13_lv_pmos L=0.13u W=1.12u AS=0.3808p
+ AD=0.3808p PS=2.92u PD=2.92u rfmode=0
M$1180 VGND VPWR VGND VGND sg13_lv_nmos L=1u W=2020.2u AS=536.424p AD=536.424p
+ PS=5591.84u PD=5591.84u rfmode=0
M$1181 VPWR VGND VPWR VPWR sg13_lv_pmos L=1u W=4810u AS=1277.2p AD=1277.2p
+ PS=9786.4u PD=9786.4u rfmode=0
R$10800 \$4289 \$1596 VGND rhigh w=0.78u l=1u ps=0.18u b=2 m=1
R$10801 \$3036 VAPWR VGND rhigh w=1.78u l=2u ps=0.18u b=10 m=1
R$10802 \$2781 VAPWR VGND rhigh w=1.78u l=2u ps=0.18u b=9 m=1
M$10807 VGND VGND VGND VGND sg13_lv_nmos L=0.13u W=11u AS=3.74p AD=3.74p
+ PS=28.12u PD=28.12u rfmode=0
M$10808 analog_0 analog_0 analog_0 VGND sg13_lv_nmos L=0.13u W=4u AS=1.36p
+ AD=1.36p PS=8.68u PD=8.68u rfmode=0
M$10809 analog_0 \$56 VGND VGND sg13_lv_nmos L=0.13u W=80u AS=15.8p AD=15.8p
+ PS=91.9u PD=91.9u rfmode=0
M$10829 \$56 \$56 \$56 VPWR sg13_lv_pmos L=0.13u W=2u AS=0.68p AD=0.68p
+ PS=4.68u PD=4.68u rfmode=0
M$10830 VPWR VPWR VPWR VPWR sg13_lv_pmos L=0.13u W=10.25u AS=3.485p AD=3.485p
+ PS=26.62u PD=26.62u rfmode=0
M$10831 \$56 \$266 VPWR VPWR sg13_lv_pmos L=0.13u W=40u AS=7.9p AD=7.9p
+ PS=49.9u PD=49.9u rfmode=0
M$10852 \$56 \$56 \$56 VGND sg13_lv_nmos L=0.13u W=1.8u AS=0.612p AD=0.612p
+ PS=4.28u PD=4.28u rfmode=0
M$10853 \$56 \$266 VGND VGND sg13_lv_nmos L=0.13u W=18u AS=3.69p AD=3.69p
+ PS=23.9u PD=23.9u rfmode=0
M$10863 \$387 \$387 \$387 VGND sg13_lv_nmos L=0.13u W=2.4u AS=0.816p AD=0.816p
+ PS=6.16u PD=6.16u rfmode=0
M$10865 \$387 \$511 VGND VGND sg13_lv_nmos L=0.13u W=6u AS=1.32p AD=1.32p
+ PS=9.4u PD=9.4u rfmode=0
M$10870 \$387 \$387 \$387 VPWR sg13_lv_pmos L=0.13u W=2.6u AS=0.884p AD=0.884p
+ PS=6.56u PD=6.56u rfmode=0
M$10872 \$387 \$511 VPWR VPWR sg13_lv_pmos L=0.13u W=13.5u AS=2.7675p
+ AD=2.7675p PS=18.95u PD=18.95u rfmode=0
M$10882 \$916 \$916 \$916 VGND sg13_lv_nmos L=0.13u W=0.4u AS=0.136p AD=0.136p
+ PS=1.48u PD=1.48u rfmode=0
M$10883 \$1066 \$1066 \$1066 VGND sg13_lv_nmos L=0.13u W=1u AS=0.34p AD=0.34p
+ PS=3.36u PD=3.36u rfmode=0
M$10884 \$916 \$1065 \$1066 VGND sg13_lv_nmos L=0.13u W=2u AS=0.44p AD=0.44p
+ PS=4.6u PD=4.6u rfmode=0
M$10889 \$1063 \$1063 \$1063 VPWR sg13_lv_pmos L=0.13u W=0.95u AS=0.323p
+ AD=0.323p PS=3.26u PD=3.26u rfmode=0
M$10890 \$916 \$916 \$916 VPWR sg13_lv_pmos L=0.13u W=0.45u AS=0.153p AD=0.153p
+ PS=1.58u PD=1.58u rfmode=0
M$10891 \$916 \$1065 \$1063 VPWR sg13_lv_pmos L=0.13u W=4.5u AS=0.9225p
+ AD=0.9225p PS=9.05u PD=9.05u rfmode=0
M$10902 \$511 \$511 \$511 VPWR sg13_lv_pmos L=0.13u W=0.45u AS=0.153p AD=0.153p
+ PS=1.58u PD=1.58u rfmode=0
M$10903 \$511 \$916 VPWR VPWR sg13_lv_pmos L=0.13u W=4.5u AS=0.9225p AD=0.9225p
+ PS=9.05u PD=9.05u rfmode=0
M$10915 \$1063 \$1088 VPWR VPWR sg13_lv_pmos L=0.13u W=5u AS=1.025p AD=1.025p
+ PS=9.6u PD=9.6u rfmode=0
M$10927 \$1066 \$1081 VGND VGND sg13_lv_nmos L=0.13u W=3u AS=0.66p AD=0.66p
+ PS=5.8u PD=5.8u rfmode=0
M$10932 \$511 \$511 \$511 VGND sg13_lv_nmos L=0.13u W=0.4u AS=0.136p AD=0.136p
+ PS=1.48u PD=1.48u rfmode=0
M$10934 \$511 \$916 VGND VGND sg13_lv_nmos L=0.13u W=2u AS=0.44p AD=0.44p
+ PS=4.6u PD=4.6u rfmode=0
M$10939 VAPWR VAPWR VAPWR VAPWR sg13_hv_pmos L=4u W=8u AS=2.72p AD=2.72p
+ PS=18.72u PD=18.72u rfmode=0
M$10940 \$392 \$335 VAPWR VAPWR sg13_hv_pmos L=4u W=2u AS=0.68p AD=0.68p
+ PS=4.68u PD=4.68u rfmode=0
M$10941 \$392 \$392 \$392 VAPWR sg13_hv_pmos L=4u W=2u AS=0.68p AD=0.68p
+ PS=4.68u PD=4.68u rfmode=0
M$10942 \$266 \$266 \$266 VGND sg13_lv_nmos L=0.13u W=2.4u AS=0.816p AD=0.816p
+ PS=6.16u PD=6.16u rfmode=0
M$10944 \$266 \$419 VGND VGND sg13_lv_nmos L=0.13u W=6u AS=1.32p AD=1.32p
+ PS=9.4u PD=9.4u rfmode=0
M$10949 \$266 \$266 \$266 VPWR sg13_lv_pmos L=0.13u W=2.6u AS=0.884p AD=0.884p
+ PS=6.56u PD=6.56u rfmode=0
M$10950 VGND VGND VGND VPWR sg13_lv_pmos L=0.13u W=1.3u AS=0.442p AD=0.442p
+ PS=3.28u PD=3.28u rfmode=0
M$10951 \$266 \$429 VGND VPWR sg13_lv_pmos L=0.13u W=13.5u AS=2.7675p
+ AD=2.7675p PS=18.95u PD=18.95u rfmode=0
M$10963 \$266 \$429 \$387 VGND sg13_lv_nmos L=0.13u W=6u AS=1.32p AD=1.32p
+ PS=9.4u PD=9.4u rfmode=0
M$10968 VGND VGND VGND VGND sg13_hv_nmos L=4u W=8u AS=2.72p AD=2.72p PS=18.72u
+ PD=18.72u rfmode=0
M$10969 q0 \$392 VGND VGND sg13_hv_nmos L=4u W=2u AS=0.68p AD=0.68p PS=4.68u
+ PD=4.68u rfmode=0
M$10970 q0 q0 q0 VGND sg13_hv_nmos L=4u W=2u AS=0.68p AD=0.68p PS=4.68u
+ PD=4.68u rfmode=0
M$10971 analog_0 analog_0 analog_0 VPWR sg13_lv_pmos L=0.13u W=4u AS=1.36p
+ AD=1.36p PS=8.68u PD=8.68u rfmode=0
M$10973 analog_0 \$56 VPWR VPWR sg13_lv_pmos L=0.13u W=200u AS=38.6p AD=38.6p
+ PS=223.3u PD=223.3u rfmode=0
M$11023 VPWR VPWR VPWR VPWR sg13_hv_pmos L=4u W=8u AS=2.72p AD=2.72p PS=18.72u
+ PD=18.72u rfmode=0
M$11024 q0 \$392 VPWR VPWR sg13_hv_pmos L=4u W=2u AS=0.68p AD=0.68p PS=4.68u
+ PD=4.68u rfmode=0
M$11025 q0 q0 q0 VPWR sg13_hv_pmos L=4u W=2u AS=0.68p AD=0.68p PS=4.68u
+ PD=4.68u rfmode=0
M$11026 \$197 \$197 \$197 VGND sg13_hv_nmos L=4u W=2u AS=0.68p AD=0.68p
+ PS=4.68u PD=4.68u rfmode=0
M$11027 \$392 \$335 \$197 VGND sg13_hv_nmos L=4u W=2u AS=0.68p AD=0.68p
+ PS=4.68u PD=4.68u rfmode=0
M$11028 \$392 \$392 \$392 VGND sg13_hv_nmos L=4u W=2u AS=0.68p AD=0.68p
+ PS=4.68u PD=4.68u rfmode=0
M$11031 \$266 \$419 \$387 VPWR sg13_lv_pmos L=0.13u W=13.5u AS=2.7675p
+ AD=2.7675p PS=18.95u PD=18.95u rfmode=0
M$11041 \$1231 \$1231 \$1231 VPWR sg13_lv_pmos L=0.13u W=0.95u AS=0.323p
+ AD=0.323p PS=3.26u PD=3.26u rfmode=0
M$11043 \$1231 \$1088 VPWR VPWR sg13_lv_pmos L=0.13u W=5u AS=1.025p AD=1.025p
+ PS=9.6u PD=9.6u rfmode=0
M$11054 \$1088 \$1088 \$1088 VPWR sg13_lv_pmos L=0.13u W=0.5u AS=0.17p AD=0.17p
+ PS=1.68u PD=1.68u rfmode=0
M$11055 VPWR \$1088 \$1088 VPWR sg13_lv_pmos L=0.13u W=5u AS=1.025p AD=1.025p
+ PS=9.6u PD=9.6u rfmode=0
M$11066 \$1234 \$1234 \$1234 VGND sg13_lv_nmos L=0.13u W=1u AS=0.34p AD=0.34p
+ PS=3.36u PD=3.36u rfmode=0
M$11067 \$1234 \$1081 VGND VGND sg13_lv_nmos L=0.13u W=3u AS=0.66p AD=0.66p
+ PS=5.8u PD=5.8u rfmode=0
M$11072 \$1088 \$1088 \$1088 VGND sg13_lv_nmos L=0.13u W=2u AS=0.68p AD=0.68p
+ PS=4.68u PD=4.68u rfmode=0
M$11073 \$1235 \$1235 \$1235 VGND sg13_lv_nmos L=0.13u W=2u AS=0.68p AD=0.68p
+ PS=4.68u PD=4.68u rfmode=0
M$11074 \$1235 \$1475 \$1088 VGND sg13_lv_nmos L=0.13u W=40u AS=7.9p AD=7.9p
+ PS=49.9u PD=49.9u rfmode=0
M$11094 \$1151 \$1151 \$1151 VGND sg13_lv_nmos L=0.13u W=0.4u AS=0.136p
+ AD=0.136p PS=1.48u PD=1.48u rfmode=0
M$11096 \$1151 \$916 \$1234 VGND sg13_lv_nmos L=0.13u W=2u AS=0.44p AD=0.44p
+ PS=4.6u PD=4.6u rfmode=0
M$11102 \$1081 \$1081 \$1081 VGND sg13_lv_nmos L=0.13u W=0.6u AS=0.204p
+ AD=0.204p PS=1.88u PD=1.88u rfmode=0
M$11103 \$1081 \$1081 VGND VGND sg13_lv_nmos L=0.13u W=3u AS=0.66p AD=0.66p
+ PS=5.8u PD=5.8u rfmode=0
M$11108 \$1081 \$1081 \$1081 VPWR sg13_lv_pmos L=0.13u W=0.5u AS=0.17p AD=0.17p
+ PS=1.68u PD=1.68u rfmode=0
M$11110 \$1081 \$1088 VPWR VPWR sg13_lv_pmos L=0.13u W=5u AS=1.025p AD=1.025p
+ PS=9.6u PD=9.6u rfmode=0
M$11121 \$1151 \$1151 \$1151 VPWR sg13_lv_pmos L=0.13u W=0.45u AS=0.153p
+ AD=0.153p PS=1.58u PD=1.58u rfmode=0
M$11122 \$1151 \$916 \$1231 VPWR sg13_lv_pmos L=0.13u W=4.5u AS=0.9225p
+ AD=0.9225p PS=9.05u PD=9.05u rfmode=0
M$11133 q1 \$1516 VGND VGND sg13_hv_nmos L=4u W=2u AS=0.68p AD=0.68p PS=4.68u
+ PD=4.68u rfmode=0
M$11134 q1 q1 q1 VGND sg13_hv_nmos L=4u W=2u AS=0.68p AD=0.68p PS=4.68u
+ PD=4.68u rfmode=0
M$11135 \$1065 \$1065 \$1065 VGND sg13_lv_nmos L=0.13u W=0.4u AS=0.136p
+ AD=0.136p PS=1.48u PD=1.48u rfmode=0
M$11136 \$1152 \$1152 \$1152 VGND sg13_lv_nmos L=0.13u W=1u AS=0.34p AD=0.34p
+ PS=3.36u PD=3.36u rfmode=0
M$11137 \$1065 \$1151 \$1152 VGND sg13_lv_nmos L=0.13u W=2u AS=0.44p AD=0.44p
+ PS=4.6u PD=4.6u rfmode=0
M$11144 \$1152 \$1081 VGND VGND sg13_lv_nmos L=0.13u W=3u AS=0.66p AD=0.66p
+ PS=5.8u PD=5.8u rfmode=0
M$11149 \$1150 \$1150 \$1150 VPWR sg13_lv_pmos L=0.13u W=0.95u AS=0.323p
+ AD=0.323p PS=3.26u PD=3.26u rfmode=0
M$11151 \$1150 \$1088 VPWR VPWR sg13_lv_pmos L=0.13u W=5u AS=1.025p AD=1.025p
+ PS=9.6u PD=9.6u rfmode=0
M$11162 \$1065 \$1065 \$1065 VPWR sg13_lv_pmos L=0.13u W=0.45u AS=0.153p
+ AD=0.153p PS=1.58u PD=1.58u rfmode=0
M$11163 \$1065 \$1151 \$1150 VPWR sg13_lv_pmos L=0.13u W=4.5u AS=0.9225p
+ AD=0.9225p PS=9.05u PD=9.05u rfmode=0
M$11174 \$1516 \$1351 VAPWR VAPWR sg13_hv_pmos L=4u W=2u AS=0.68p AD=0.68p
+ PS=4.68u PD=4.68u rfmode=0
M$11175 \$1516 \$1516 \$1516 VAPWR sg13_hv_pmos L=4u W=2u AS=0.68p AD=0.68p
+ PS=4.68u PD=4.68u rfmode=0
M$11176 \$1236 \$1236 \$1236 VGND sg13_hv_nmos L=4u W=2u AS=0.68p AD=0.68p
+ PS=4.68u PD=4.68u rfmode=0
M$11177 \$1516 \$1351 \$1236 VGND sg13_hv_nmos L=4u W=2u AS=0.68p AD=0.68p
+ PS=4.68u PD=4.68u rfmode=0
M$11178 \$1516 \$1516 \$1516 VGND sg13_hv_nmos L=4u W=2u AS=0.68p AD=0.68p
+ PS=4.68u PD=4.68u rfmode=0
M$11180 q1 \$1516 VPWR VPWR sg13_hv_pmos L=4u W=2u AS=0.68p AD=0.68p PS=4.68u
+ PD=4.68u rfmode=0
M$11181 q1 q1 q1 VPWR sg13_hv_pmos L=4u W=2u AS=0.68p AD=0.68p PS=4.68u
+ PD=4.68u rfmode=0
M$11182 \$201 \$201 \$201 VAPWR sg13_hv_pmos L=0.5u W=4u AS=1.36p AD=1.36p
+ PS=8.68u PD=8.68u rfmode=0
M$11183 \$3027 \$3027 \$3027 VAPWR sg13_hv_pmos L=0.5u W=4u AS=1.36p AD=1.36p
+ PS=8.68u PD=8.68u rfmode=0
M$11184 \$1240 \$1240 \$1240 VAPWR sg13_hv_pmos L=0.5u W=4u AS=1.36p AD=1.36p
+ PS=8.68u PD=8.68u rfmode=0
M$11185 \$2041 \$2041 \$2041 VAPWR sg13_hv_pmos L=0.5u W=4u AS=1.36p AD=1.36p
+ PS=8.68u PD=8.68u rfmode=0
M$11186 \$201 \$201 VAPWR VAPWR sg13_hv_pmos L=0.5u W=4u AS=1.36p AD=1.36p
+ PS=8.68u PD=8.68u rfmode=0
M$11187 \$3027 \$3027 VAPWR VAPWR sg13_hv_pmos L=0.5u W=4u AS=1.36p AD=1.36p
+ PS=8.68u PD=8.68u rfmode=0
M$11188 \$1240 \$1240 VAPWR VAPWR sg13_hv_pmos L=0.5u W=4u AS=1.36p AD=1.36p
+ PS=8.68u PD=8.68u rfmode=0
M$11189 \$2041 \$2041 VAPWR VAPWR sg13_hv_pmos L=0.5u W=4u AS=1.36p AD=1.36p
+ PS=8.68u PD=8.68u rfmode=0
M$11190 VAPWR VAPWR VAPWR VAPWR sg13_hv_pmos L=0.5u W=60u AS=20.4p AD=20.4p
+ PS=134.96u PD=134.96u rfmode=0
M$11194 \$3023 \$3023 \$3023 VGND sg13_hv_nmos L=4u W=2u AS=0.68p AD=0.68p
+ PS=4.68u PD=4.68u rfmode=0
M$11195 \$3247 \$3129 \$3023 VGND sg13_hv_nmos L=4u W=2u AS=0.68p AD=0.68p
+ PS=4.68u PD=4.68u rfmode=0
M$11196 \$3247 \$3247 \$3247 VGND sg13_hv_nmos L=4u W=2u AS=0.68p AD=0.68p
+ PS=4.68u PD=4.68u rfmode=0
M$11198 q3 \$3247 VPWR VPWR sg13_hv_pmos L=4u W=2u AS=0.68p AD=0.68p PS=4.68u
+ PD=4.68u rfmode=0
M$11199 q3 q3 q3 VPWR sg13_hv_pmos L=4u W=2u AS=0.68p AD=0.68p PS=4.68u
+ PD=4.68u rfmode=0
M$11201 \$3247 \$3129 VAPWR VAPWR sg13_hv_pmos L=4u W=2u AS=0.68p AD=0.68p
+ PS=4.68u PD=4.68u rfmode=0
M$11202 \$3247 \$3247 \$3247 VAPWR sg13_hv_pmos L=4u W=2u AS=0.68p AD=0.68p
+ PS=4.68u PD=4.68u rfmode=0
M$11204 q3 \$3247 VGND VGND sg13_hv_nmos L=4u W=2u AS=0.68p AD=0.68p PS=4.68u
+ PD=4.68u rfmode=0
M$11205 q3 q3 q3 VGND sg13_hv_nmos L=4u W=2u AS=0.68p AD=0.68p PS=4.68u
+ PD=4.68u rfmode=0
M$11206 \$4233 \$4233 \$4233 VAPWR sg13_hv_pmos L=0.5u W=2u AS=0.68p AD=0.68p
+ PS=4.68u PD=4.68u rfmode=0
M$11208 \$4233 \$4233 VAPWR VAPWR sg13_hv_pmos L=0.5u W=14u AS=2.96p AD=2.96p
+ PS=18.96u PD=18.96u rfmode=0
M$11215 \$4139 \$4139 \$4139 VAPWR sg13_hv_pmos L=0.5u W=2u AS=0.68p AD=0.68p
+ PS=4.68u PD=4.68u rfmode=0
M$11217 \$4139 \$4233 VAPWR VAPWR sg13_hv_pmos L=0.5u W=14u AS=2.96p AD=2.96p
+ PS=18.96u PD=18.96u rfmode=0
M$11224 \$1246 \$1246 \$1246 VGND sg13_hv_nmos L=0.5u W=0.5u AS=0.17p AD=0.17p
+ PS=1.68u PD=1.68u rfmode=0
M$11225 \$4498 \$4498 \$4498 VGND sg13_hv_nmos L=0.5u W=0.5u AS=0.17p AD=0.17p
+ PS=1.68u PD=1.68u rfmode=0
M$11226 \$3036 \$3036 \$3036 VGND sg13_hv_nmos L=0.5u W=0.5u AS=0.17p AD=0.17p
+ PS=1.68u PD=1.68u rfmode=0
M$11227 \$1246 \$1246 VGND VGND sg13_hv_nmos L=0.5u W=0.5u AS=0.17p AD=0.17p
+ PS=1.68u PD=1.68u rfmode=0
M$11228 \$4498 \$4498 VGND VGND sg13_hv_nmos L=0.5u W=0.5u AS=0.17p AD=0.17p
+ PS=1.68u PD=1.68u rfmode=0
M$11229 \$3036 \$3036 VGND VGND sg13_hv_nmos L=0.5u W=0.5u AS=0.17p AD=0.17p
+ PS=1.68u PD=1.68u rfmode=0
M$11233 \$1450 \$1450 \$1450 VAPWR sg13_hv_pmos L=0.5u W=2u AS=0.68p AD=0.68p
+ PS=4.68u PD=4.68u rfmode=0
M$11234 \$3140 \$3140 \$3140 VAPWR sg13_hv_pmos L=0.5u W=2u AS=0.68p AD=0.68p
+ PS=4.68u PD=4.68u rfmode=0
M$11235 \$4573 \$4573 \$4573 VAPWR sg13_hv_pmos L=0.5u W=2u AS=0.68p AD=0.68p
+ PS=4.68u PD=4.68u rfmode=0
M$11239 \$1450 \$1450 VAPWR VAPWR sg13_hv_pmos L=0.5u W=14u AS=2.96p AD=2.96p
+ PS=18.96u PD=18.96u rfmode=0
M$11246 \$3140 \$3140 VAPWR VAPWR sg13_hv_pmos L=0.5u W=14u AS=2.96p AD=2.96p
+ PS=18.96u PD=18.96u rfmode=0
M$11253 \$4573 \$4573 VAPWR VAPWR sg13_hv_pmos L=0.5u W=14u AS=2.96p AD=2.96p
+ PS=18.96u PD=18.96u rfmode=0
M$11260 \$1153 \$1153 \$1153 VGND sg13_hv_nmos L=0.5u W=1.5u AS=0.51p AD=0.51p
+ PS=4.36u PD=4.36u rfmode=0
M$11261 \$4300 \$4300 \$4300 VGND sg13_hv_nmos L=0.5u W=1.5u AS=0.51p AD=0.51p
+ PS=4.36u PD=4.36u rfmode=0
M$11262 \$2913 \$2913 \$2913 VGND sg13_hv_nmos L=0.5u W=1.5u AS=0.51p AD=0.51p
+ PS=4.36u PD=4.36u rfmode=0
M$11263 \$1153 \$1246 VGND VGND sg13_hv_nmos L=0.5u W=0.5u AS=0.17p AD=0.17p
+ PS=1.68u PD=1.68u rfmode=0
M$11264 \$4300 \$4498 VGND VGND sg13_hv_nmos L=0.5u W=0.5u AS=0.17p AD=0.17p
+ PS=1.68u PD=1.68u rfmode=0
M$11265 \$2913 \$3036 VGND VGND sg13_hv_nmos L=0.5u W=0.5u AS=0.17p AD=0.17p
+ PS=1.68u PD=1.68u rfmode=0
M$11269 \$1153 \$1153 \$1153 VAPWR sg13_hv_pmos L=0.5u W=2.7u AS=0.918p
+ AD=0.918p PS=6.76u PD=6.76u rfmode=0
M$11270 \$4300 \$4300 \$4300 VAPWR sg13_hv_pmos L=0.5u W=2.7u AS=0.918p
+ AD=0.918p PS=6.76u PD=6.76u rfmode=0
M$11271 \$2913 \$2913 \$2913 VAPWR sg13_hv_pmos L=0.5u W=2.7u AS=0.918p
+ AD=0.918p PS=6.76u PD=6.76u rfmode=0
M$11275 \$1153 \$1450 VAPWR VAPWR sg13_hv_pmos L=0.5u W=14u AS=2.96p AD=2.96p
+ PS=18.96u PD=18.96u rfmode=0
M$11282 \$4300 \$4573 VAPWR VAPWR sg13_hv_pmos L=0.5u W=14u AS=2.96p AD=2.96p
+ PS=18.96u PD=18.96u rfmode=0
M$11289 \$2913 \$3140 VAPWR VAPWR sg13_hv_pmos L=0.5u W=14u AS=2.96p AD=2.96p
+ PS=18.96u PD=18.96u rfmode=0
M$11296 \$764 \$764 \$764 VGND sg13_hv_nmos L=0.5u W=0.5u AS=0.17p AD=0.17p
+ PS=1.68u PD=1.68u rfmode=0
M$11297 \$4306 \$4306 \$4306 VGND sg13_hv_nmos L=0.5u W=0.5u AS=0.17p AD=0.17p
+ PS=1.68u PD=1.68u rfmode=0
M$11298 \$2556 \$2556 \$2556 VGND sg13_hv_nmos L=0.5u W=0.5u AS=0.17p AD=0.17p
+ PS=1.68u PD=1.68u rfmode=0
M$11299 \$764 \$1153 VGND VGND sg13_hv_nmos L=0.5u W=0.5u AS=0.17p AD=0.17p
+ PS=1.68u PD=1.68u rfmode=0
M$11300 \$4306 \$4300 VGND VGND sg13_hv_nmos L=0.5u W=0.5u AS=0.17p AD=0.17p
+ PS=1.68u PD=1.68u rfmode=0
M$11301 \$2556 \$2913 VGND VGND sg13_hv_nmos L=0.5u W=0.5u AS=0.17p AD=0.17p
+ PS=1.68u PD=1.68u rfmode=0
M$11305 VGND VGND VGND VAPWR sg13_hv_pmos L=0.5u W=2.1u AS=0.714p AD=0.714p
+ PS=6.24u PD=6.24u rfmode=0
M$11308 VGND \$402 \$1153 VAPWR sg13_hv_pmos L=0.5u W=0.7u AS=0.238p AD=0.238p
+ PS=2.08u PD=2.08u rfmode=0
M$11309 VGND \$2046 \$2913 VAPWR sg13_hv_pmos L=0.5u W=0.7u AS=0.238p AD=0.238p
+ PS=2.08u PD=2.08u rfmode=0
M$11310 VGND \$4143 \$4300 VAPWR sg13_hv_pmos L=0.5u W=0.7u AS=0.238p AD=0.238p
+ PS=2.08u PD=2.08u rfmode=0
M$11314 \$1243 \$1243 \$1243 VGND sg13_hv_nmos L=0.5u W=2u AS=0.68p AD=0.68p
+ PS=5.36u PD=5.36u rfmode=0
M$11315 \$4493 \$4493 \$4493 VGND sg13_hv_nmos L=0.5u W=2u AS=0.68p AD=0.68p
+ PS=5.36u PD=5.36u rfmode=0
M$11316 \$3030 \$3030 \$3030 VGND sg13_hv_nmos L=0.5u W=2u AS=0.68p AD=0.68p
+ PS=5.36u PD=5.36u rfmode=0
M$11320 \$1153 VAPWR \$1243 VGND sg13_hv_nmos L=0.5u W=2u AS=0.53p AD=0.53p
+ PS=4.06u PD=4.06u rfmode=0
M$11322 \$4300 VAPWR \$4493 VGND sg13_hv_nmos L=0.5u W=2u AS=0.53p AD=0.53p
+ PS=4.06u PD=4.06u rfmode=0
M$11324 \$2913 VAPWR \$3030 VGND sg13_hv_nmos L=0.5u W=2u AS=0.53p AD=0.53p
+ PS=4.06u PD=4.06u rfmode=0
M$11332 \$1243 analog_2 VGND VGND sg13_hv_nmos L=0.5u W=18u AS=3.57p AD=3.57p
+ PS=26.14u PD=26.14u rfmode=0
M$11350 \$4493 \$3503 VGND VGND sg13_hv_nmos L=0.5u W=18u AS=3.57p AD=3.57p
+ PS=26.14u PD=26.14u rfmode=0
M$11368 \$3030 \$1651 VGND VGND sg13_hv_nmos L=0.5u W=18u AS=3.57p AD=3.57p
+ PS=26.14u PD=26.14u rfmode=0
M$11386 \$918 \$918 \$918 VGND sg13_hv_nmos L=0.5u W=1u AS=0.34p AD=0.34p
+ PS=2.68u PD=2.68u rfmode=0
M$11387 \$4396 \$4396 \$4396 VGND sg13_hv_nmos L=0.5u W=1u AS=0.34p AD=0.34p
+ PS=2.68u PD=2.68u rfmode=0
M$11388 \$2781 \$2781 \$2781 VGND sg13_hv_nmos L=0.5u W=1u AS=0.34p AD=0.34p
+ PS=2.68u PD=2.68u rfmode=0
M$11392 \$918 \$918 VGND VGND sg13_hv_nmos L=0.5u W=2u AS=0.53p AD=0.53p
+ PS=4.06u PD=4.06u rfmode=0
M$11394 \$4396 \$4396 VGND VGND sg13_hv_nmos L=0.5u W=2u AS=0.53p AD=0.53p
+ PS=4.06u PD=4.06u rfmode=0
M$11396 \$2781 \$2781 VGND VGND sg13_hv_nmos L=0.5u W=2u AS=0.53p AD=0.53p
+ PS=4.06u PD=4.06u rfmode=0
M$11398 VAPWR VAPWR VAPWR VGND sg13_hv_nmos L=0.5u W=4.5u AS=1.53p AD=1.53p
+ PS=11.04u PD=11.04u rfmode=0
M$11401 VAPWR \$4306 \$4143 VGND sg13_hv_nmos L=0.5u W=1.5u AS=0.51p AD=0.51p
+ PS=3.68u PD=3.68u rfmode=0
M$11402 VAPWR \$2556 \$2046 VGND sg13_hv_nmos L=0.5u W=1.5u AS=0.51p AD=0.51p
+ PS=3.68u PD=3.68u rfmode=0
M$11403 VAPWR \$764 \$402 VGND sg13_hv_nmos L=0.5u W=1.5u AS=0.51p AD=0.51p
+ PS=3.68u PD=3.68u rfmode=0
M$11404 \$4143 \$4143 \$4143 VGND sg13_hv_nmos L=0.5u W=3.5u AS=1.19p AD=1.19p
+ PS=8.36u PD=8.36u rfmode=0
M$11405 \$2046 \$2046 \$2046 VGND sg13_hv_nmos L=0.5u W=3.5u AS=1.19p AD=1.19p
+ PS=8.36u PD=8.36u rfmode=0
M$11406 \$402 \$402 \$402 VGND sg13_hv_nmos L=0.5u W=3.5u AS=1.19p AD=1.19p
+ PS=8.36u PD=8.36u rfmode=0
M$11410 \$260 \$260 \$260 VGND sg13_hv_nmos L=0.5u W=2u AS=0.68p AD=0.68p
+ PS=4.68u PD=4.68u rfmode=0
M$11411 \$1924 \$1924 \$1924 VGND sg13_hv_nmos L=0.5u W=2u AS=0.68p AD=0.68p
+ PS=4.68u PD=4.68u rfmode=0
M$11412 \$4031 \$4031 \$4031 VGND sg13_hv_nmos L=0.5u W=2u AS=0.68p AD=0.68p
+ PS=4.68u PD=4.68u rfmode=0
M$11413 \$260 \$260 VGND VGND sg13_hv_nmos L=0.5u W=10u AS=2.2p AD=2.2p
+ PS=14.2u PD=14.2u rfmode=0
M$11418 \$1924 \$1924 VGND VGND sg13_hv_nmos L=0.5u W=10u AS=2.2p AD=2.2p
+ PS=14.2u PD=14.2u rfmode=0
M$11423 \$4031 \$4031 VGND VGND sg13_hv_nmos L=0.5u W=10u AS=2.2p AD=2.2p
+ PS=14.2u PD=14.2u rfmode=0
M$11434 \$402 \$260 VGND VGND sg13_hv_nmos L=0.5u W=10u AS=2.2p AD=2.2p
+ PS=14.2u PD=14.2u rfmode=0
M$11439 \$4143 \$4031 VGND VGND sg13_hv_nmos L=0.5u W=10u AS=2.2p AD=2.2p
+ PS=14.2u PD=14.2u rfmode=0
M$11444 \$2046 \$1924 VGND VGND sg13_hv_nmos L=0.5u W=10u AS=2.2p AD=2.2p
+ PS=14.2u PD=14.2u rfmode=0
M$11450 \$2248 \$2133 VAPWR VAPWR sg13_hv_pmos L=4u W=2u AS=0.68p AD=0.68p
+ PS=4.68u PD=4.68u rfmode=0
M$11451 \$2248 \$2248 \$2248 VAPWR sg13_hv_pmos L=4u W=2u AS=0.68p AD=0.68p
+ PS=4.68u PD=4.68u rfmode=0
M$11455 \$764 \$764 \$764 VAPWR sg13_hv_pmos L=0.5u W=2u AS=0.68p AD=0.68p
+ PS=4.68u PD=4.68u rfmode=0
M$11456 \$4306 \$4306 \$4306 VAPWR sg13_hv_pmos L=0.5u W=2u AS=0.68p AD=0.68p
+ PS=4.68u PD=4.68u rfmode=0
M$11457 \$2556 \$2556 \$2556 VAPWR sg13_hv_pmos L=0.5u W=2u AS=0.68p AD=0.68p
+ PS=4.68u PD=4.68u rfmode=0
M$11458 \$764 \$259 VAPWR VAPWR sg13_hv_pmos L=0.5u W=14u AS=2.96p AD=2.96p
+ PS=18.96u PD=18.96u rfmode=0
M$11465 \$4306 \$4030 VAPWR VAPWR sg13_hv_pmos L=0.5u W=14u AS=2.96p AD=2.96p
+ PS=18.96u PD=18.96u rfmode=0
M$11472 \$2556 \$2043 VAPWR VAPWR sg13_hv_pmos L=0.5u W=14u AS=2.96p AD=2.96p
+ PS=18.96u PD=18.96u rfmode=0
M$11479 \$259 \$259 \$259 VAPWR sg13_hv_pmos L=0.5u W=2u AS=0.68p AD=0.68p
+ PS=4.68u PD=4.68u rfmode=0
M$11480 \$2043 \$2043 \$2043 VAPWR sg13_hv_pmos L=0.5u W=2u AS=0.68p AD=0.68p
+ PS=4.68u PD=4.68u rfmode=0
M$11481 \$4030 \$4030 \$4030 VAPWR sg13_hv_pmos L=0.5u W=2u AS=0.68p AD=0.68p
+ PS=4.68u PD=4.68u rfmode=0
M$11485 \$259 \$259 VAPWR VAPWR sg13_hv_pmos L=0.5u W=14u AS=2.96p AD=2.96p
+ PS=18.96u PD=18.96u rfmode=0
M$11492 \$2043 \$2043 VAPWR VAPWR sg13_hv_pmos L=0.5u W=14u AS=2.96p AD=2.96p
+ PS=18.96u PD=18.96u rfmode=0
M$11499 \$4030 \$4030 VAPWR VAPWR sg13_hv_pmos L=0.5u W=14u AS=2.96p AD=2.96p
+ PS=18.96u PD=18.96u rfmode=0
M$11507 q2 \$2248 VGND VGND sg13_hv_nmos L=4u W=2u AS=0.68p AD=0.68p PS=4.68u
+ PD=4.68u rfmode=0
M$11508 q2 q2 q2 VGND sg13_hv_nmos L=4u W=2u AS=0.68p AD=0.68p PS=4.68u
+ PD=4.68u rfmode=0
M$11509 \$2036 \$2036 \$2036 VGND sg13_hv_nmos L=4u W=2u AS=0.68p AD=0.68p
+ PS=4.68u PD=4.68u rfmode=0
M$11510 \$2248 \$2133 \$2036 VGND sg13_hv_nmos L=4u W=2u AS=0.68p AD=0.68p
+ PS=4.68u PD=4.68u rfmode=0
M$11511 \$2248 \$2248 \$2248 VGND sg13_hv_nmos L=4u W=2u AS=0.68p AD=0.68p
+ PS=4.68u PD=4.68u rfmode=0
M$11513 q2 \$2248 VPWR VPWR sg13_hv_pmos L=4u W=2u AS=0.68p AD=0.68p PS=4.68u
+ PD=4.68u rfmode=0
M$11514 q2 q2 q2 VPWR sg13_hv_pmos L=4u W=2u AS=0.68p AD=0.68p PS=4.68u
+ PD=4.68u rfmode=0
M$11519 \$336 \$201 VAPWR VAPWR sg13_hv_pmos L=0.5u W=4u AS=1.36p AD=1.36p
+ PS=8.68u PD=8.68u rfmode=0
M$11520 \$2136 \$2041 VAPWR VAPWR sg13_hv_pmos L=0.5u W=4u AS=1.36p AD=1.36p
+ PS=8.68u PD=8.68u rfmode=0
M$11521 \$3136 \$3027 VAPWR VAPWR sg13_hv_pmos L=0.5u W=4u AS=1.36p AD=1.36p
+ PS=8.68u PD=8.68u rfmode=0
M$11522 \$1352 \$1240 VAPWR VAPWR sg13_hv_pmos L=0.5u W=4u AS=1.36p AD=1.36p
+ PS=8.68u PD=8.68u rfmode=0
.ENDS heichips26_ook_soc

.SUBCKT sg13cmos5l_or4_1 VDD VSS B D A C X
M$1 VSS D \$7 VSS sg13_lv_nmos L=0.13u W=0.55u AS=0.187p AD=0.1045p PS=1.78u
+ PD=0.93u rfmode=0
M$2 VSS C \$7 VSS sg13_lv_nmos L=0.13u W=0.55u AS=0.16755p AD=0.1045p PS=1.165u
+ PD=0.93u rfmode=0
M$3 VSS B \$7 VSS sg13_lv_nmos L=0.13u W=0.55u AS=0.16755p AD=0.1045p PS=1.165u
+ PD=0.93u rfmode=0
M$4 VSS A \$7 VSS sg13_lv_nmos L=0.13u W=0.55u AS=0.14135p AD=0.1045p PS=1.14u
+ PD=0.93u rfmode=0
M$5 VSS \$7 X VSS sg13_lv_nmos L=0.13u W=0.74u AS=0.14135p AD=0.2516p PS=1.14u
+ PD=2.16u rfmode=0
M$6 \$7 D \$11 VDD sg13_lv_pmos L=0.13u W=1u AS=0.34p AD=0.19p PS=2.68u
+ PD=1.38u rfmode=0
M$7 \$11 C \$10 VDD sg13_lv_pmos L=0.13u W=1u AS=0.19p AD=0.2925p PS=1.38u
+ PD=1.585u rfmode=0
M$8 \$10 B \$9 VDD sg13_lv_pmos L=0.13u W=1u AS=0.2925p AD=0.19p PS=1.585u
+ PD=1.38u rfmode=0
M$9 VDD A \$9 VDD sg13_lv_pmos L=0.13u W=1u AS=0.2144p AD=0.19p PS=1.52u
+ PD=1.38u rfmode=0
M$10 VDD \$7 X VDD sg13_lv_pmos L=0.13u W=1.12u AS=0.2144p AD=0.3808p PS=1.52u
+ PD=2.92u rfmode=0
.ENDS sg13cmos5l_or4_1

.SUBCKT sg13cmos5l_nand4_1 VDD A VSS Y B C D
M$1 VSS D \$10 VSS sg13_lv_nmos L=0.13u W=0.74u AS=0.2516p AD=0.1406p PS=2.16u
+ PD=1.12u rfmode=0
M$2 \$10 C \$9 VSS sg13_lv_nmos L=0.13u W=0.74u AS=0.1406p AD=0.1406p PS=1.12u
+ PD=1.12u rfmode=0
M$3 \$9 B \$8 VSS sg13_lv_nmos L=0.13u W=0.74u AS=0.1406p AD=0.1406p PS=1.12u
+ PD=1.12u rfmode=0
M$4 \$8 A Y VSS sg13_lv_nmos L=0.13u W=0.74u AS=0.1406p AD=0.2516p PS=1.12u
+ PD=2.16u rfmode=0
M$5 VDD D Y VDD sg13_lv_pmos L=0.13u W=1.12u AS=0.3808p AD=0.2128p PS=2.92u
+ PD=1.5u rfmode=0
M$6 Y C VDD VDD sg13_lv_pmos L=0.13u W=1.12u AS=0.2128p AD=0.2128p PS=1.5u
+ PD=1.5u rfmode=0
M$7 VDD B Y VDD sg13_lv_pmos L=0.13u W=1.12u AS=0.2128p AD=0.2128p PS=1.5u
+ PD=1.5u rfmode=0
M$8 Y A VDD VDD sg13_lv_pmos L=0.13u W=1.12u AS=0.2128p AD=0.3808p PS=1.5u
+ PD=2.92u rfmode=0
.ENDS sg13cmos5l_nand4_1

.SUBCKT sg13cmos5l_tielo L_LO VDD VSS
M$1 VSS \$5 \$4 VSS sg13_lv_nmos L=0.13u W=0.385u AS=0.305425p AD=0.1309p
+ PS=2.07u PD=1.45u rfmode=0
M$2 VSS \$1 L_LO VSS sg13_lv_nmos L=0.13u W=0.88u AS=0.305425p AD=0.2992p
+ PS=2.07u PD=2.44u rfmode=0
M$3 VDD \$5 \$5 VDD sg13_lv_pmos L=0.13u W=0.3u AS=0.326925p AD=0.102p
+ PS=2.255u PD=1.28u rfmode=0
M$4 VDD \$4 \$1 VDD sg13_lv_pmos L=0.13u W=1.045u AS=0.326925p AD=0.3553p
+ PS=2.255u PD=2.77u rfmode=0
.ENDS sg13cmos5l_tielo

.SUBCKT sg13cmos5l_or3_1 VDD VSS C A B X
M$1 \$6 C VSS VSS sg13_lv_nmos L=0.13u W=0.55u AS=0.187p AD=0.1045p PS=1.78u
+ PD=0.93u rfmode=0
M$2 VSS B \$6 VSS sg13_lv_nmos L=0.13u W=0.55u AS=0.1045p AD=0.198p PS=0.93u
+ PD=1.27u rfmode=0
M$3 \$6 A VSS VSS sg13_lv_nmos L=0.13u W=0.55u AS=0.198p AD=0.13395p PS=1.27u
+ PD=1.12u rfmode=0
M$4 VSS \$6 X VSS sg13_lv_nmos L=0.13u W=0.74u AS=0.13395p AD=0.2516p PS=1.12u
+ PD=2.16u rfmode=0
M$5 \$6 C \$9 VDD sg13_lv_pmos L=0.13u W=1u AS=0.34p AD=0.19p PS=2.68u PD=1.38u
+ rfmode=0
M$6 \$9 B \$8 VDD sg13_lv_pmos L=0.13u W=1u AS=0.19p AD=0.1575p PS=1.38u
+ PD=1.315u rfmode=0
M$7 \$8 A VDD VDD sg13_lv_pmos L=0.13u W=1u AS=0.1575p AD=0.3822p PS=1.315u
+ PD=1.84u rfmode=0
M$8 VDD \$6 X VDD sg13_lv_pmos L=0.13u W=1.12u AS=0.3822p AD=0.3808p PS=1.84u
+ PD=2.92u rfmode=0
.ENDS sg13cmos5l_or3_1

.SUBCKT sg13cmos5l_nor2b_1 VSS VDD Y A B_N
M$1 VSS B_N \$5 VSS sg13_lv_nmos L=0.13u W=0.55u AS=0.17255p AD=0.187p PS=1.25u
+ PD=1.78u rfmode=0
M$2 VSS \$5 Y VSS sg13_lv_nmos L=0.13u W=0.74u AS=0.17255p AD=0.1406p PS=1.25u
+ PD=1.12u rfmode=0
M$3 Y A VSS VSS sg13_lv_nmos L=0.13u W=0.74u AS=0.1406p AD=0.2516p PS=1.12u
+ PD=2.16u rfmode=0
M$4 \$5 B_N VDD VDD sg13_lv_pmos L=0.13u W=0.84u AS=0.2856p AD=0.2618p PS=2.36u
+ PD=1.63u rfmode=0
M$5 VDD \$5 \$7 VDD sg13_lv_pmos L=0.13u W=1.12u AS=0.2618p AD=0.1176p PS=1.63u
+ PD=1.33u rfmode=0
M$6 \$7 A Y VDD sg13_lv_pmos L=0.13u W=1.12u AS=0.1176p AD=0.3808p PS=1.33u
+ PD=2.92u rfmode=0
.ENDS sg13cmos5l_nor2b_1

.SUBCKT sg13cmos5l_mux2_1 VSS X S A1 A0 VDD
M$1 VSS S \$2 VSS sg13_lv_nmos L=0.13u W=0.55u AS=0.18945p AD=0.187p PS=1.27u
+ PD=1.78u rfmode=0
M$2 VSS S \$8 VSS sg13_lv_nmos L=0.13u W=0.74u AS=0.18945p AD=0.13135p PS=1.27u
+ PD=1.095u rfmode=0
M$3 \$8 A1 \$3 VSS sg13_lv_nmos L=0.13u W=0.74u AS=0.13135p AD=0.1628p
+ PS=1.095u PD=1.18u rfmode=0
M$4 \$3 A0 \$9 VSS sg13_lv_nmos L=0.13u W=0.74u AS=0.1628p AD=0.3367p PS=1.18u
+ PD=1.65u rfmode=0
M$5 \$9 \$2 VSS VSS sg13_lv_nmos L=0.13u W=0.74u AS=0.3367p AD=0.148p PS=1.65u
+ PD=1.14u rfmode=0
M$6 VSS \$3 X VSS sg13_lv_nmos L=0.13u W=0.74u AS=0.148p AD=0.4033p PS=1.14u
+ PD=2.57u rfmode=0
M$7 \$2 S VDD VDD sg13_lv_pmos L=0.13u W=0.84u AS=0.2856p AD=0.253p PS=2.36u
+ PD=1.53u rfmode=0
M$8 VDD S \$10 VDD sg13_lv_pmos L=0.13u W=1u AS=0.253p AD=0.3325p PS=1.53u
+ PD=1.665u rfmode=0
M$9 \$10 A0 \$3 VDD sg13_lv_pmos L=0.13u W=1u AS=0.3325p AD=0.2225p PS=1.665u
+ PD=1.445u rfmode=0
M$10 \$3 A1 \$11 VDD sg13_lv_pmos L=0.13u W=1u AS=0.2225p AD=0.2975p PS=1.445u
+ PD=1.595u rfmode=0
M$11 \$11 \$2 VDD VDD sg13_lv_pmos L=0.13u W=1u AS=0.2975p AD=0.2198p PS=1.595u
+ PD=1.52u rfmode=0
M$12 VDD \$3 X VDD sg13_lv_pmos L=0.13u W=1.12u AS=0.2198p AD=0.6048p PS=1.52u
+ PD=3.32u rfmode=0
.ENDS sg13cmos5l_mux2_1

.SUBCKT sg13cmos5l_xnor2_1 VDD VSS Y B A
M$1 VSS A \$8 VSS sg13_lv_nmos L=0.13u W=0.64u AS=0.2272p AD=0.0784p PS=1.99u
+ PD=0.885u rfmode=0
M$2 \$8 B \$7 VSS sg13_lv_nmos L=0.13u W=0.64u AS=0.0784p AD=0.2176p PS=0.885u
+ PD=1.96u rfmode=0
M$3 VSS A \$3 VSS sg13_lv_nmos L=0.13u W=0.74u AS=0.1898p AD=0.2516p PS=1.36u
+ PD=2.16u rfmode=0
M$4 VSS B \$3 VSS sg13_lv_nmos L=0.13u W=0.74u AS=0.1898p AD=0.1406p PS=1.36u
+ PD=1.12u rfmode=0
M$5 \$3 \$7 Y VSS sg13_lv_nmos L=0.13u W=0.74u AS=0.1406p AD=0.2516p PS=1.12u
+ PD=2.16u rfmode=0
M$6 VDD A \$7 VDD sg13_lv_pmos L=0.13u W=0.84u AS=0.4536p AD=0.1596p PS=2.76u
+ PD=1.22u rfmode=0
M$7 VDD B \$7 VDD sg13_lv_pmos L=0.13u W=0.84u AS=0.2891p AD=0.1596p PS=1.695u
+ PD=1.22u rfmode=0
M$8 VDD A \$9 VDD sg13_lv_pmos L=0.13u W=1.12u AS=0.2891p AD=0.1428p PS=1.695u
+ PD=1.375u rfmode=0
M$9 \$9 B Y VDD sg13_lv_pmos L=0.13u W=1.12u AS=0.1428p AD=0.2408p PS=1.375u
+ PD=1.55u rfmode=0
M$10 Y \$7 VDD VDD sg13_lv_pmos L=0.13u W=1.12u AS=0.2408p AD=0.3808p PS=1.55u
+ PD=2.92u rfmode=0
.ENDS sg13cmos5l_xnor2_1

.SUBCKT sg13cmos5l_a22oi_1 Y VSS VDD A2 B2 B1 A1
M$1 VSS B1 \$10 VSS sg13_lv_nmos L=0.13u W=0.74u AS=0.2553p AD=0.13875p
+ PS=2.17u PD=1.115u rfmode=0
M$2 \$10 B2 Y VSS sg13_lv_nmos L=0.13u W=0.74u AS=0.13875p AD=0.2664p PS=1.115u
+ PD=1.46u rfmode=0
M$3 Y A1 \$9 VSS sg13_lv_nmos L=0.13u W=0.74u AS=0.2664p AD=0.0962p PS=1.46u
+ PD=1u rfmode=0
M$4 \$9 A2 VSS VSS sg13_lv_nmos L=0.13u W=0.74u AS=0.0962p AD=0.2516p PS=1u
+ PD=2.16u rfmode=0
M$5 VDD A1 \$5 VDD sg13_lv_pmos L=0.13u W=1.12u AS=0.3808p AD=0.2716p PS=2.92u
+ PD=1.605u rfmode=0
M$6 \$5 B1 Y VDD sg13_lv_pmos L=0.13u W=1.12u AS=0.2716p AD=0.2128p PS=1.605u
+ PD=1.5u rfmode=0
M$7 Y B2 \$5 VDD sg13_lv_pmos L=0.13u W=1.12u AS=0.2128p AD=0.2744p PS=1.5u
+ PD=1.61u rfmode=0
M$8 \$5 A2 VDD VDD sg13_lv_pmos L=0.13u W=1.12u AS=0.2744p AD=0.3808p PS=1.61u
+ PD=2.92u rfmode=0
.ENDS sg13cmos5l_a22oi_1

.SUBCKT sg13cmos5l_or2_1 A X B VDD VSS
M$1 VSS B \$6 VSS sg13_lv_nmos L=0.13u W=0.55u AS=0.187p AD=0.1045p PS=1.78u
+ PD=0.93u rfmode=0
M$2 \$6 A VSS VSS sg13_lv_nmos L=0.13u W=0.55u AS=0.1045p AD=0.1469p PS=0.93u
+ PD=1.155u rfmode=0
M$3 VSS \$6 X VSS sg13_lv_nmos L=0.13u W=0.74u AS=0.1469p AD=0.2516p PS=1.155u
+ PD=2.16u rfmode=0
M$4 \$6 B \$7 VDD sg13_lv_pmos L=0.13u W=0.84u AS=0.2856p AD=0.1596p PS=2.36u
+ PD=1.22u rfmode=0
M$5 VDD A \$7 VDD sg13_lv_pmos L=0.13u W=0.84u AS=0.2226p AD=0.1596p PS=1.535u
+ PD=1.22u rfmode=0
M$6 VDD \$6 X VDD sg13_lv_pmos L=0.13u W=1.12u AS=0.2226p AD=0.3976p PS=1.535u
+ PD=2.95u rfmode=0
.ENDS sg13cmos5l_or2_1

.SUBCKT sg13cmos5l_nor3_1 VDD VSS C Y B A
M$1 VSS A Y VSS sg13_lv_nmos L=0.13u W=0.77u AS=0.2618p AD=0.1694p PS=2.22u
+ PD=1.21u rfmode=0
M$2 Y B VSS VSS sg13_lv_nmos L=0.13u W=0.77u AS=0.1694p AD=0.1463p PS=1.21u
+ PD=1.15u rfmode=0
M$3 VSS C Y VSS sg13_lv_nmos L=0.13u W=0.77u AS=0.1463p AD=0.2618p PS=1.15u
+ PD=2.22u rfmode=0
M$4 VDD A \$8 VDD sg13_lv_pmos L=0.13u W=1.12u AS=0.3808p AD=0.2464p PS=2.92u
+ PD=1.56u rfmode=0
M$5 \$8 B \$7 VDD sg13_lv_pmos L=0.13u W=1.12u AS=0.2464p AD=0.2128p PS=1.56u
+ PD=1.5u rfmode=0
M$6 \$7 C Y VDD sg13_lv_pmos L=0.13u W=1.12u AS=0.2128p AD=0.3808p PS=1.5u
+ PD=2.92u rfmode=0
.ENDS sg13cmos5l_nor3_1

.SUBCKT sg13cmos5l_nand3_1 VDD VSS Y B C A
M$1 VSS C \$8 VSS sg13_lv_nmos L=0.13u W=0.74u AS=0.2886p AD=0.1406p PS=2.26u
+ PD=1.12u rfmode=0
M$2 \$8 B \$7 VSS sg13_lv_nmos L=0.13u W=0.74u AS=0.1406p AD=0.1406p PS=1.12u
+ PD=1.12u rfmode=0
M$3 \$7 A Y VSS sg13_lv_nmos L=0.13u W=0.74u AS=0.1406p AD=0.2516p PS=1.12u
+ PD=2.16u rfmode=0
M$4 VDD C Y VDD sg13_lv_pmos L=0.13u W=1.12u AS=0.3808p AD=0.2128p PS=2.92u
+ PD=1.5u rfmode=0
M$5 Y B VDD VDD sg13_lv_pmos L=0.13u W=1.12u AS=0.2128p AD=0.2128p PS=1.5u
+ PD=1.5u rfmode=0
M$6 VDD A Y VDD sg13_lv_pmos L=0.13u W=1.12u AS=0.2128p AD=0.3808p PS=1.5u
+ PD=2.92u rfmode=0
.ENDS sg13cmos5l_nand3_1

.SUBCKT sg13cmos5l_nand2_1 VDD VSS Y A B
M$1 VSS B \$6 VSS sg13_lv_nmos L=0.13u W=0.74u AS=0.2516p AD=0.1406p PS=2.16u
+ PD=1.12u rfmode=0
M$2 \$6 A Y VSS sg13_lv_nmos L=0.13u W=0.74u AS=0.1406p AD=0.2516p PS=1.12u
+ PD=2.16u rfmode=0
M$3 VDD B Y VDD sg13_lv_pmos L=0.13u W=1.12u AS=0.3808p AD=0.2128p PS=2.92u
+ PD=1.5u rfmode=0
M$4 Y A VDD VDD sg13_lv_pmos L=0.13u W=1.12u AS=0.2128p AD=0.3808p PS=1.5u
+ PD=2.92u rfmode=0
.ENDS sg13cmos5l_nand2_1

.SUBCKT sg13cmos5l_decap_4 VDD VSS
M$1 VSS VDD VSS VSS sg13_lv_nmos L=1u W=0.42u AS=0.1428p AD=0.1428p PS=1.52u
+ PD=1.52u rfmode=0
M$2 VDD VSS VDD VDD sg13_lv_pmos L=1u W=1u AS=0.34p AD=0.34p PS=2.68u PD=2.68u
+ rfmode=0
.ENDS sg13cmos5l_decap_4

.SUBCKT sg13cmos5l_buf_8 VSS A X VDD
M$1 \$2 A VSS VSS sg13_lv_nmos L=0.13u W=2.22u AS=0.5365p AD=0.4218p PS=4.41u
+ PD=3.36u rfmode=0
M$4 VSS \$2 X VSS sg13_lv_nmos L=0.13u W=5.92u AS=1.1248p AD=1.2358p PS=8.96u
+ PD=10u rfmode=0
M$12 \$2 A VDD VDD sg13_lv_pmos L=0.13u W=3.36u AS=0.8064p AD=0.6384p PS=5.92u
+ PD=4.5u rfmode=0
M$15 VDD \$2 X VDD sg13_lv_pmos L=0.13u W=8.96u AS=1.7024p AD=1.876p PS=12u
+ PD=13.43u rfmode=0
.ENDS sg13cmos5l_buf_8

.SUBCKT sg13cmos5l_nor4_1 VDD VSS B A C D Y
M$1 VSS A Y VSS sg13_lv_nmos L=0.13u W=0.74u AS=0.2516p AD=0.1406p PS=2.16u
+ PD=1.12u rfmode=0
M$2 Y B VSS VSS sg13_lv_nmos L=0.13u W=0.74u AS=0.1406p AD=0.1406p PS=1.12u
+ PD=1.12u rfmode=0
M$3 VSS C Y VSS sg13_lv_nmos L=0.13u W=0.74u AS=0.1406p AD=0.1406p PS=1.12u
+ PD=1.12u rfmode=0
M$4 Y D VSS VSS sg13_lv_nmos L=0.13u W=0.74u AS=0.1406p AD=0.237575p PS=1.12u
+ PD=2.16u rfmode=0
M$5 VDD A \$9 VDD sg13_lv_pmos L=0.13u W=1.12u AS=0.3808p AD=0.2128p PS=2.92u
+ PD=1.5u rfmode=0
M$6 \$9 B \$8 VDD sg13_lv_pmos L=0.13u W=1.12u AS=0.2128p AD=0.2128p PS=1.5u
+ PD=1.5u rfmode=0
M$7 \$8 C \$10 VDD sg13_lv_pmos L=0.13u W=1.12u AS=0.2128p AD=0.2128p PS=1.5u
+ PD=1.5u rfmode=0
M$8 \$10 D Y VDD sg13_lv_pmos L=0.13u W=1.12u AS=0.2128p AD=0.4368p PS=1.5u
+ PD=3.02u rfmode=0
.ENDS sg13cmos5l_nor4_1

.SUBCKT sg13cmos5l_and2_1 VDD VSS X A B
M$1 \$4 A \$7 VSS sg13_lv_nmos L=0.13u W=0.64u AS=0.2176p AD=0.1216p PS=1.96u
+ PD=1.02u rfmode=0
M$2 VSS B \$7 VSS sg13_lv_nmos L=0.13u W=0.64u AS=0.1331p AD=0.1216p PS=1.12u
+ PD=1.02u rfmode=0
M$3 VSS \$4 X VSS sg13_lv_nmos L=0.13u W=0.74u AS=0.1331p AD=0.2516p PS=1.12u
+ PD=2.16u rfmode=0
M$4 VDD A \$4 VDD sg13_lv_pmos L=0.13u W=0.84u AS=0.2856p AD=0.1596p PS=2.36u
+ PD=1.22u rfmode=0
M$5 VDD B \$4 VDD sg13_lv_pmos L=0.13u W=0.84u AS=0.1918p AD=0.1596p PS=1.5u
+ PD=1.22u rfmode=0
M$6 VDD \$4 X VDD sg13_lv_pmos L=0.13u W=1.12u AS=0.1918p AD=0.3808p PS=1.5u
+ PD=2.92u rfmode=0
.ENDS sg13cmos5l_and2_1

.SUBCKT sg13cmos5l_decap_8 VDD VSS
M$1 VSS VDD VSS VSS sg13_lv_nmos L=1u W=0.84u AS=0.2226p AD=0.2226p PS=2.32u
+ PD=2.32u rfmode=0
M$3 VDD VSS VDD VDD sg13_lv_pmos L=1u W=2u AS=0.53p AD=0.53p PS=4.06u PD=4.06u
+ rfmode=0
.ENDS sg13cmos5l_decap_8

.SUBCKT sg13cmos5l_a221oi_1 VSS B1 VDD Y B2 C1 A1 A2
M$1 Y A1 \$11 VSS sg13_lv_nmos L=0.13u W=0.74u AS=0.2516p AD=0.1406p PS=2.16u
+ PD=1.12u rfmode=0
M$2 \$11 A2 VSS VSS sg13_lv_nmos L=0.13u W=0.74u AS=0.1406p AD=0.2516p PS=1.12u
+ PD=2.16u rfmode=0
M$3 Y C1 VSS VSS sg13_lv_nmos L=0.13u W=0.74u AS=0.2516p AD=0.1406p PS=2.16u
+ PD=1.12u rfmode=0
M$4 VSS B2 \$12 VSS sg13_lv_nmos L=0.13u W=0.74u AS=0.1406p AD=0.1406p PS=1.12u
+ PD=1.12u rfmode=0
M$5 \$12 B1 Y VSS sg13_lv_nmos L=0.13u W=0.74u AS=0.1406p AD=0.2516p PS=1.12u
+ PD=2.16u rfmode=0
M$6 VDD A1 \$9 VDD sg13_lv_pmos L=0.13u W=1.12u AS=0.3808p AD=0.2128p PS=2.92u
+ PD=1.5u rfmode=0
M$7 \$9 A2 VDD VDD sg13_lv_pmos L=0.13u W=1.12u AS=0.2128p AD=0.3808p PS=1.5u
+ PD=2.92u rfmode=0
M$8 Y C1 \$6 VDD sg13_lv_pmos L=0.13u W=1.12u AS=0.3808p AD=0.2128p PS=2.92u
+ PD=1.5u rfmode=0
M$9 \$6 B2 \$9 VDD sg13_lv_pmos L=0.13u W=1.12u AS=0.2128p AD=0.2128p PS=1.5u
+ PD=1.5u rfmode=0
M$10 \$9 B1 \$6 VDD sg13_lv_pmos L=0.13u W=1.12u AS=0.2128p AD=0.3808p PS=1.5u
+ PD=2.92u rfmode=0
.ENDS sg13cmos5l_a221oi_1

.SUBCKT sg13cmos5l_tiehi L_HI VDD VSS
M$1 VSS \$5 \$5 VSS sg13_lv_nmos L=0.13u W=0.3u AS=0.2043375p AD=0.111p
+ PS=1.585u PD=1.34u rfmode=0
M$2 VSS \$3 \$1 VSS sg13_lv_nmos L=0.13u W=0.795u AS=0.2043375p AD=0.274275p
+ PS=1.585u PD=2.28u rfmode=0
M$3 \$3 \$5 VDD VDD sg13_lv_pmos L=0.13u W=0.66u AS=0.2442p AD=0.4657125p
+ PS=2.06u PD=2.54u rfmode=0
M$4 VDD \$1 L_HI VDD sg13_lv_pmos L=0.13u W=1.155u AS=0.4657125p AD=0.3927p
+ PS=2.54u PD=2.99u rfmode=0
.ENDS sg13cmos5l_tiehi

.SUBCKT sg13cmos5l_dfrbpq_1 VSS RESET_B Q D CLK VDD
M$1 \$5 \$4 \$12 VSS sg13_lv_nmos L=0.13u W=0.42u AS=0.1296p AD=0.0798p
+ PS=1.52u PD=0.8u rfmode=0
M$2 \$12 \$19 \$6 VSS sg13_lv_nmos L=0.13u W=0.42u AS=0.0798p AD=0.2373p
+ PS=0.8u PD=1.97u rfmode=0
M$3 \$9 \$14 VSS VSS sg13_lv_nmos L=0.13u W=0.74u AS=0.2516p AD=0.1406p
+ PS=2.16u PD=1.12u rfmode=0
M$4 VSS \$9 Q VSS sg13_lv_nmos L=0.13u W=0.74u AS=0.1406p AD=0.2516p PS=1.12u
+ PD=2.16u rfmode=0
M$5 VSS RESET_B \$16 VSS sg13_lv_nmos L=0.13u W=0.42u AS=0.1701p AD=0.0378p
+ PS=1.65u PD=0.6u rfmode=0
M$6 \$16 \$3 \$6 VSS sg13_lv_nmos L=0.13u W=0.42u AS=0.0378p AD=0.1428p PS=0.6u
+ PD=1.52u rfmode=0
M$7 \$7 \$8 VSS VSS sg13_lv_nmos L=0.13u W=0.42u AS=0.1428p AD=0.0798p PS=1.52u
+ PD=0.8u rfmode=0
M$8 VSS RESET_B \$17 VSS sg13_lv_nmos L=0.13u W=0.42u AS=0.0798p AD=0.0378p
+ PS=0.8u PD=0.6u rfmode=0
M$9 \$17 \$14 \$8 VSS sg13_lv_nmos L=0.13u W=0.42u AS=0.0378p AD=0.1428p
+ PS=0.6u PD=1.52u rfmode=0
M$10 VSS \$4 \$19 VSS sg13_lv_nmos L=0.13u W=0.74u AS=0.317325p AD=0.2516p
+ PS=1.805u PD=2.16u rfmode=0
M$11 VSS CLK \$4 VSS sg13_lv_nmos L=0.13u W=0.74u AS=0.317325p AD=0.2516p
+ PS=1.805u PD=2.16u rfmode=0
M$12 \$5 D \$15 VSS sg13_lv_nmos L=0.13u W=0.42u AS=0.1428p AD=0.0609p PS=1.52u
+ PD=0.71u rfmode=0
M$13 \$15 RESET_B VSS VSS sg13_lv_nmos L=0.13u W=0.42u AS=0.0609p AD=0.1626p
+ PS=0.71u PD=1.415u rfmode=0
M$14 VSS \$12 \$3 VSS sg13_lv_nmos L=0.13u W=0.74u AS=0.1626p AD=0.2516p
+ PS=1.415u PD=2.16u rfmode=0
M$15 \$14 \$4 \$7 VSS sg13_lv_nmos L=0.13u W=0.42u AS=0.12665p AD=0.1428p
+ PS=1.145u PD=1.52u rfmode=0
M$16 \$3 \$19 \$14 VSS sg13_lv_nmos L=0.13u W=0.74u AS=0.3473p AD=0.12665p
+ PS=2.71u PD=1.145u rfmode=0
M$17 \$14 \$19 \$21 VDD sg13_lv_pmos L=0.13u W=0.42u AS=0.2048p AD=0.09345p
+ PS=1.63u PD=0.865u rfmode=0
M$18 \$21 \$8 VDD VDD sg13_lv_pmos L=0.13u W=0.42u AS=0.09345p AD=0.204p
+ PS=0.865u PD=1.835u rfmode=0
M$19 VDD RESET_B \$8 VDD sg13_lv_pmos L=0.13u W=0.42u AS=0.204p AD=0.0798p
+ PS=1.835u PD=0.8u rfmode=0
M$20 \$8 \$14 VDD VDD sg13_lv_pmos L=0.13u W=0.42u AS=0.0798p AD=0.4659p
+ PS=0.8u PD=3.65u rfmode=0
M$21 \$3 \$4 \$14 VDD sg13_lv_pmos L=0.13u W=1u AS=0.34p AD=0.2048p PS=2.68u
+ PD=1.63u rfmode=0
M$22 \$9 \$14 VDD VDD sg13_lv_pmos L=0.13u W=1.12u AS=0.3864p AD=0.2128p
+ PS=2.93u PD=1.5u rfmode=0
M$23 VDD \$9 Q VDD sg13_lv_pmos L=0.13u W=1.12u AS=0.2128p AD=0.3808p PS=1.5u
+ PD=2.92u rfmode=0
M$24 VDD D \$5 VDD sg13_lv_pmos L=0.13u W=0.42u AS=0.1428p AD=0.0798p PS=1.52u
+ PD=0.8u rfmode=0
M$25 VDD RESET_B \$5 VDD sg13_lv_pmos L=0.13u W=0.42u AS=0.3623875p AD=0.0798p
+ PS=2.605u PD=0.8u rfmode=0
M$26 VDD \$12 \$3 VDD sg13_lv_pmos L=0.13u W=1u AS=0.3623875p AD=0.34p
+ PS=2.605u PD=2.68u rfmode=0
M$27 \$19 \$4 VDD VDD sg13_lv_pmos L=0.13u W=1.12u AS=0.3864p AD=0.41165p
+ PS=2.93u PD=2.12u rfmode=0
M$28 VDD CLK \$4 VDD sg13_lv_pmos L=0.13u W=1.12u AS=0.41165p AD=0.4088p
+ PS=2.12u PD=2.97u rfmode=0
M$29 \$12 RESET_B VDD VDD sg13_lv_pmos L=0.13u W=0.42u AS=0.147p AD=0.1563p
+ PS=1.54u PD=1.22u rfmode=0
M$30 VDD \$3 \$20 VDD sg13_lv_pmos L=0.13u W=0.42u AS=0.1563p AD=0.063p
+ PS=1.22u PD=0.72u rfmode=0
M$31 \$20 \$4 \$12 VDD sg13_lv_pmos L=0.13u W=0.42u AS=0.063p AD=0.0798p
+ PS=0.72u PD=0.8u rfmode=0
M$32 \$12 \$19 \$5 VDD sg13_lv_pmos L=0.13u W=0.42u AS=0.0798p AD=0.1428p
+ PS=0.8u PD=1.52u rfmode=0
.ENDS sg13cmos5l_dfrbpq_1

.SUBCKT sg13cmos5l_o21ai_1 VSS Y VDD B1 A2 A1
M$1 \$2 A1 VSS VSS sg13_lv_nmos L=0.15u W=0.74u AS=0.2516p AD=0.1406p PS=2.16u
+ PD=1.12u rfmode=0
M$2 VSS A2 \$2 VSS sg13_lv_nmos L=0.15u W=0.74u AS=0.1406p AD=0.1406p PS=1.12u
+ PD=1.12u rfmode=0
M$3 \$2 B1 Y VSS sg13_lv_nmos L=0.15u W=0.74u AS=0.1406p AD=0.2516p PS=1.12u
+ PD=2.16u rfmode=0
M$4 VDD A1 \$8 VDD sg13_lv_pmos L=0.15u W=1.12u AS=0.3808p AD=0.2128p PS=2.92u
+ PD=1.5u rfmode=0
M$5 \$8 A2 Y VDD sg13_lv_pmos L=0.15u W=1.12u AS=0.2128p AD=0.2128p PS=1.5u
+ PD=1.5u rfmode=0
M$6 Y B1 VDD VDD sg13_lv_pmos L=0.15u W=1.12u AS=0.2128p AD=0.3808p PS=1.5u
+ PD=2.92u rfmode=0
.ENDS sg13cmos5l_o21ai_1

.SUBCKT sg13cmos5l_nand3b_1 VDD VSS Y B C A_N
M$1 VSS A_N \$6 VSS sg13_lv_nmos L=0.13u W=0.55u AS=0.18575p AD=0.187p PS=1.26u
+ PD=1.78u rfmode=0
M$2 VSS C \$9 VSS sg13_lv_nmos L=0.13u W=0.74u AS=0.18575p AD=0.1406p PS=1.26u
+ PD=1.12u rfmode=0
M$3 \$9 B \$8 VSS sg13_lv_nmos L=0.13u W=0.74u AS=0.1406p AD=0.1406p PS=1.12u
+ PD=1.12u rfmode=0
M$4 \$8 \$6 Y VSS sg13_lv_nmos L=0.13u W=0.74u AS=0.1406p AD=0.3404p PS=1.12u
+ PD=2.4u rfmode=0
M$5 \$6 A_N VDD VDD sg13_lv_pmos L=0.13u W=0.84u AS=0.2856p AD=0.2198p PS=2.36u
+ PD=1.53u rfmode=0
M$6 VDD C Y VDD sg13_lv_pmos L=0.13u W=1.12u AS=0.2198p AD=0.2128p PS=1.53u
+ PD=1.5u rfmode=0
M$7 Y B VDD VDD sg13_lv_pmos L=0.13u W=1.12u AS=0.2128p AD=0.2128p PS=1.5u
+ PD=1.5u rfmode=0
M$8 VDD \$6 Y VDD sg13_lv_pmos L=0.13u W=1.12u AS=0.2128p AD=0.3808p PS=1.5u
+ PD=2.92u rfmode=0
.ENDS sg13cmos5l_nand3b_1

.SUBCKT sg13cmos5l_inv_1 VDD VSS A Y
M$1 VSS A Y VSS sg13_lv_nmos L=0.13u W=0.74u AS=0.2516p AD=0.2516p PS=2.16u
+ PD=2.16u rfmode=0
M$2 VDD A Y VDD sg13_lv_pmos L=0.13u W=1.12u AS=0.3808p AD=0.3808p PS=2.92u
+ PD=2.92u rfmode=0
.ENDS sg13cmos5l_inv_1

.SUBCKT sg13cmos5l_nor2_1 VDD VSS B A Y
M$1 VSS A Y VSS sg13_lv_nmos L=0.13u W=0.74u AS=0.2516p AD=0.1406p PS=2.16u
+ PD=1.12u rfmode=0
M$2 Y B VSS VSS sg13_lv_nmos L=0.13u W=0.74u AS=0.1406p AD=0.2516p PS=1.12u
+ PD=2.16u rfmode=0
M$3 VDD A \$6 VDD sg13_lv_pmos L=0.13u W=1.12u AS=0.4032p AD=0.1176p PS=2.96u
+ PD=1.33u rfmode=0
M$4 \$6 B Y VDD sg13_lv_pmos L=0.13u W=1.12u AS=0.1176p AD=0.3808p PS=1.33u
+ PD=2.92u rfmode=0
.ENDS sg13cmos5l_nor2_1

.SUBCKT sg13cmos5l_dlygate4sd3_1 VDD VSS X A
M$1 VSS \$5 \$4 VSS sg13_lv_nmos L=0.5u W=0.42u AS=0.1426p AD=0.1428p PS=1.16u
+ PD=1.52u rfmode=0
M$2 VSS \$4 X VSS sg13_lv_nmos L=0.13u W=0.74u AS=0.1426p AD=0.2516p PS=1.16u
+ PD=2.16u rfmode=0
M$3 \$6 A VSS VSS sg13_lv_nmos L=0.13u W=0.42u AS=0.1428p AD=0.0798p PS=1.52u
+ PD=0.8u rfmode=0
M$4 VSS \$6 \$5 VSS sg13_lv_nmos L=0.5u W=0.42u AS=0.0798p AD=0.1428p PS=0.8u
+ PD=1.52u rfmode=0
M$5 \$4 \$5 VDD VDD sg13_lv_pmos L=0.5u W=1u AS=0.34p AD=0.2254p PS=2.68u
+ PD=1.53u rfmode=0
M$6 VDD \$4 X VDD sg13_lv_pmos L=0.13u W=1.12u AS=0.2254p AD=0.4256p PS=1.53u
+ PD=3u rfmode=0
M$7 VDD A \$6 VDD sg13_lv_pmos L=0.13u W=0.42u AS=0.1523p AD=0.1428p PS=1.38u
+ PD=1.52u rfmode=0
M$8 VDD \$6 \$5 VDD sg13_lv_pmos L=0.5u W=1u AS=0.1523p AD=0.34p PS=1.38u
+ PD=2.68u rfmode=0
.ENDS sg13cmos5l_dlygate4sd3_1

.SUBCKT sg13cmos5l_and3_1 VDD VSS A C B X
M$1 \$7 A \$9 VSS sg13_lv_nmos L=0.13u W=0.64u AS=0.2176p AD=0.1216p PS=1.96u
+ PD=1.02u rfmode=0
M$2 \$9 B \$8 VSS sg13_lv_nmos L=0.13u W=0.64u AS=0.1216p AD=0.1216p PS=1.02u
+ PD=1.02u rfmode=0
M$3 VSS C \$8 VSS sg13_lv_nmos L=0.13u W=0.64u AS=0.1371p AD=0.1216p PS=1.12u
+ PD=1.02u rfmode=0
M$4 VSS \$7 X VSS sg13_lv_nmos L=0.13u W=0.74u AS=0.1371p AD=0.2516p PS=1.12u
+ PD=2.16u rfmode=0
M$5 \$7 A VDD VDD sg13_lv_pmos L=0.13u W=0.84u AS=0.2856p AD=0.1596p PS=2.36u
+ PD=1.22u rfmode=0
M$6 VDD B \$7 VDD sg13_lv_pmos L=0.13u W=0.84u AS=0.1596p AD=0.1596p PS=1.22u
+ PD=1.22u rfmode=0
M$7 VDD C \$7 VDD sg13_lv_pmos L=0.13u W=0.84u AS=0.36195p AD=0.1596p PS=1.84u
+ PD=1.22u rfmode=0
M$8 VDD \$7 X VDD sg13_lv_pmos L=0.13u W=1.12u AS=0.36195p AD=0.3808p PS=1.84u
+ PD=2.92u rfmode=0
.ENDS sg13cmos5l_and3_1

.SUBCKT sg13cmos5l_a21oi_1 Y VSS A2 VDD A1 B1
M$1 VSS B1 Y VSS sg13_lv_nmos L=0.13u W=0.74u AS=0.2516p AD=0.1406p PS=2.16u
+ PD=1.12u rfmode=0
M$2 Y A1 \$8 VSS sg13_lv_nmos L=0.13u W=0.74u AS=0.1406p AD=0.1406p PS=1.12u
+ PD=1.12u rfmode=0
M$3 \$8 A2 VSS VSS sg13_lv_nmos L=0.13u W=0.74u AS=0.1406p AD=0.2516p PS=1.12u
+ PD=2.16u rfmode=0
M$4 Y B1 \$3 VDD sg13_lv_pmos L=0.13u W=1.12u AS=0.3808p AD=0.2128p PS=2.92u
+ PD=1.5u rfmode=0
M$5 \$3 A1 VDD VDD sg13_lv_pmos L=0.13u W=1.12u AS=0.2128p AD=0.2128p PS=1.5u
+ PD=1.5u rfmode=0
M$6 VDD A2 \$3 VDD sg13_lv_pmos L=0.13u W=1.12u AS=0.2128p AD=0.3808p PS=1.5u
+ PD=2.92u rfmode=0
.ENDS sg13cmos5l_a21oi_1

.SUBCKT sg13cmos5l_buf_1 VSS X VDD A
M$1 VSS A \$1 VSS sg13_lv_nmos L=0.13u W=0.55u AS=0.14875p AD=0.187p PS=1.16u
+ PD=1.78u rfmode=0
M$2 VSS \$1 X VSS sg13_lv_nmos L=0.13u W=0.74u AS=0.14875p AD=0.2886p PS=1.16u
+ PD=2.26u rfmode=0
M$3 VDD A \$1 VDD sg13_lv_pmos L=0.13u W=0.84u AS=0.2114p AD=0.2856p PS=1.54u
+ PD=2.36u rfmode=0
M$4 VDD \$1 X VDD sg13_lv_pmos L=0.13u W=1.12u AS=0.2114p AD=0.42p PS=1.54u
+ PD=2.99u rfmode=0
.ENDS sg13cmos5l_buf_1

.SUBCKT sg13cmos5l_a21o_1 VDD VSS X B1 A1 A2
M$1 X \$4 VSS VSS sg13_lv_nmos L=0.13u W=0.74u AS=0.2351p AD=0.15745p PS=2.16u
+ PD=1.175u rfmode=0
M$2 VSS B1 \$4 VSS sg13_lv_nmos L=0.13u W=0.64u AS=0.15745p AD=0.1216p
+ PS=1.175u PD=1.02u rfmode=0
M$3 \$4 A1 \$9 VSS sg13_lv_nmos L=0.13u W=0.64u AS=0.1216p AD=0.0816p PS=1.02u
+ PD=0.895u rfmode=0
M$4 \$9 A2 VSS VSS sg13_lv_nmos L=0.13u W=0.64u AS=0.0816p AD=0.2176p PS=0.895u
+ PD=1.96u rfmode=0
M$5 \$4 B1 \$6 VDD sg13_lv_pmos L=0.13u W=1u AS=0.35p AD=0.2125p PS=2.7u
+ PD=1.425u rfmode=0
M$6 \$6 A1 VDD VDD sg13_lv_pmos L=0.13u W=1u AS=0.2125p AD=0.19p PS=1.425u
+ PD=1.38u rfmode=0
M$7 VDD A2 \$6 VDD sg13_lv_pmos L=0.13u W=1u AS=0.19p AD=0.34p PS=1.38u
+ PD=2.68u rfmode=0
M$8 X \$4 VDD VDD sg13_lv_pmos L=0.13u W=1.12u AS=0.3808p AD=0.3808p PS=2.92u
+ PD=2.92u rfmode=0
.ENDS sg13cmos5l_a21o_1

.SUBCKT sg13cmos5l_nand2b_1 VDD VSS B A_N Y
M$1 VSS A_N \$6 VSS sg13_lv_nmos L=0.13u W=0.55u AS=0.14505p AD=0.187p PS=1.15u
+ PD=1.78u rfmode=0
M$2 VSS B \$7 VSS sg13_lv_nmos L=0.13u W=0.74u AS=0.14505p AD=0.1406p PS=1.15u
+ PD=1.12u rfmode=0
M$3 \$7 \$6 Y VSS sg13_lv_nmos L=0.13u W=0.74u AS=0.1406p AD=0.333p PS=1.12u
+ PD=2.38u rfmode=0
M$4 \$6 A_N VDD VDD sg13_lv_pmos L=0.13u W=0.84u AS=0.2856p AD=0.2198p PS=2.36u
+ PD=1.53u rfmode=0
M$5 VDD B Y VDD sg13_lv_pmos L=0.13u W=1.12u AS=0.2198p AD=0.2128p PS=1.53u
+ PD=1.5u rfmode=0
M$6 Y \$6 VDD VDD sg13_lv_pmos L=0.13u W=1.12u AS=0.2128p AD=0.3808p PS=1.5u
+ PD=2.92u rfmode=0
.ENDS sg13cmos5l_nand2b_1

.SUBCKT sg13cmos5l_xor2_1 VSS X VDD B A
M$1 VSS A \$1 VSS sg13_lv_nmos L=0.13u W=0.55u AS=0.374p AD=0.174625p PS=2.46u
+ PD=1.185u rfmode=0
M$2 VSS B \$1 VSS sg13_lv_nmos L=0.13u W=0.55u AS=0.15245p AD=0.174625p
+ PS=1.17u PD=1.185u rfmode=0
M$3 VSS A \$8 VSS sg13_lv_nmos L=0.13u W=0.74u AS=0.15245p AD=0.0888p PS=1.17u
+ PD=0.98u rfmode=0
M$4 \$8 B X VSS sg13_lv_nmos L=0.13u W=0.74u AS=0.0888p AD=0.1628p PS=0.98u
+ PD=1.18u rfmode=0
M$5 X \$1 VSS VSS sg13_lv_nmos L=0.13u W=0.74u AS=0.1628p AD=0.3108p PS=1.18u
+ PD=2.32u rfmode=0
M$6 \$3 A VDD VDD sg13_lv_pmos L=0.13u W=1.12u AS=0.3808p AD=0.2128p PS=2.92u
+ PD=1.5u rfmode=0
M$7 VDD B \$3 VDD sg13_lv_pmos L=0.13u W=1.12u AS=0.2128p AD=0.2128p PS=1.5u
+ PD=1.5u rfmode=0
M$8 \$3 \$1 X VDD sg13_lv_pmos L=0.13u W=1.12u AS=0.2128p AD=0.3808p PS=1.5u
+ PD=2.92u rfmode=0
M$9 VDD A \$9 VDD sg13_lv_pmos L=0.13u W=1u AS=0.36p AD=0.1225p PS=2.72u
+ PD=1.245u rfmode=0
M$10 \$9 B \$1 VDD sg13_lv_pmos L=0.13u W=1u AS=0.1225p AD=0.34p PS=1.245u
+ PD=2.68u rfmode=0
.ENDS sg13cmos5l_xor2_1
