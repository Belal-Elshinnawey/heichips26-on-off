** sch_path: /home/belal/HeiChips/heichips26-on-off/macros/heichips26_ook_top/testbenches/xschem/b_mult_tb_tran.sch
**.subckt b_mult_tb_tran
VDDSRC VDD GND {1.5}
VDDSRC1 VDDA GND {3.3}
XM1 net2 net2 GND GND sg13_lv_nmos w=0.15u l=0.13u ng=1 m=1 mm_ok=1
XM2 net1 net1 VDD VDD sg13_lv_pmos w=4u l=0.13u ng=1 m=1 mm_ok=1
XR1 vout1 GND GND rhigh w=2e-6 l=3.85e-6 m=1 b=0 mm_ok=1
XM3 net2 net1 VDD VDD sg13_lv_pmos w=4u l=0.13u ng=1 m=1 mm_ok=1
XM4 net1 net2 vout1 GND sg13_lv_nmos w=0.83u l=0.13u ng=1 m=1 mm_ok=1
XM5 net4 net4 GND GND sg13_lv_nmos w=0.15u l=0.13u ng=1 m=1 mm_ok=1
XM6 net3 net3 VDD VDD sg13_lv_pmos w=4u l=0.13u ng=1 m=1 mm_ok=1
XR2 vout2 GND GND rhigh w=2e-6 l=3.85e-6 m=1 b=0 mm_ok=1
XM7 net4 net3 VDD VDD sg13_lv_pmos w=4u l=0.13u ng=1 m=1 mm_ok=1
XM8 net3 net4 vout2 GND sg13_lv_nmos w=1.02u l=0.13u ng=1 m=1 mm_ok=1
XM9 net6 net6 GND GND sg13_lv_nmos w=0.15u l=0.13u ng=1 m=1 mm_ok=1
XM10 net5 net5 VDD VDD sg13_lv_pmos w=4u l=0.13u ng=1 m=1 mm_ok=1
XR3 vout3 GND GND rhigh w=2e-6 l=3.85e-6 m=1 b=0 mm_ok=1
XM11 net6 net5 VDD VDD sg13_lv_pmos w=4u l=0.13u ng=1 m=1 mm_ok=1
XM12 net5 net6 vout3 GND sg13_lv_nmos w=1.48u l=0.13u ng=1 m=1 mm_ok=1
XM13 net8 net8 GND GND sg13_lv_nmos w=0.15u l=0.13u ng=1 m=1 mm_ok=1
XM14 net7 net7 VDD VDD sg13_lv_pmos w=4u l=0.13u ng=1 m=1 mm_ok=1
XR4 vout4 GND GND rhigh w=2e-6 l=3.85e-6 m=1 b=0 mm_ok=1
XM15 net8 net7 VDD VDD sg13_lv_pmos w=4u l=0.13u ng=1 m=1 mm_ok=1
XM16 net7 net8 vout4 GND sg13_lv_nmos w=2.77u l=0.13u ng=1 m=1 mm_ok=1
XM17 net9 net9 VDD VDD sg13_lv_pmos w=4u l=0.13u ng=1 m=1 mm_ok=1
XM18 net9 net2 GND GND sg13_lv_nmos w=0.15u l=0.13u ng=1 m=1 mm_ok=1
XM19 net2 net9 VDD GND sg13_lv_nmos w=0.15u l=0.13u ng=1 m=1 mm_ok=1
XM20 net10 net10 VDD VDD sg13_lv_pmos w=4u l=0.13u ng=1 m=1 mm_ok=1
XM21 net10 net4 GND GND sg13_lv_nmos w=0.15u l=0.13u ng=1 m=1 mm_ok=1
XM22 net4 net10 VDD GND sg13_lv_nmos w=0.15u l=0.13u ng=1 m=1 mm_ok=1
XM23 net11 net11 VDD VDD sg13_lv_pmos w=4u l=0.13u ng=1 m=1 mm_ok=1
XM24 net11 net6 GND GND sg13_lv_nmos w=0.15u l=0.13u ng=1 m=1 mm_ok=1
XM25 net6 net11 VDD GND sg13_lv_nmos w=0.15u l=0.13u ng=1 m=1 mm_ok=1
XM26 net12 net12 VDD VDD sg13_lv_pmos w=4u l=0.13u ng=1 m=1 mm_ok=1
XM27 net12 net8 GND GND sg13_lv_nmos w=0.15u l=0.13u ng=1 m=1 mm_ok=1
XM28 net8 net12 VDD GND sg13_lv_nmos w=0.15u l=0.13u ng=1 m=1 mm_ok=1
**** begin user architecture code

.param VDD=1.5
.param tr=1e-9
.param tr_data=50e-9
.options klu reltol=1e-3 abstol=1e-12 vntol=1e-6 gmin=1e-12 itl1=200 itl4=100 rshunt=1e9 trtol=20
.save vout1 vout2 vout3 vout4
.control
tran 10n 2u 0 10n uic
plot vout1 vout2 vout3 vout4
.endc

.lib cornerMOSlv.lib mos_tt
.lib cornerMOShv.lib mos_tt
.lib cornerRES.lib res_typ
.lib cornerDIO.lib dio_tt
.lib cornerCAP.lib cap_typ
.include /home/belal/HeiChips/heichips26-on-off/macros/heichips26_ook_top/macros/dac/netlist/xspice/dac.xspice
.include /home/belal/HeiChips/heichips26-on-off/macros/heichips26_ook_top/macros/ook_analog_system/netlist/pex/ook_transmitter_magic_pex_3.spice
.include /home/belal/HeiChips/heichips26-on-off/macros/heichips26_ook_top/macros/ook_analog_system/netlist/pex/ook_analog_system_magic_pex_3.spice
.include /home/belal/HeiChips/heichips26-on-off/IHP-Open-PDK/ihp-sg13cmos5l/libs.tech/ngspice/models/cap_mfringe.lib
.include /home/belal/HeiChips/heichips26-on-off/macros/heichips26_ook_top/macros/ook_analog_system/netlist/pex/vco_magic_pex_3.spice
.include /home/belal/HeiChips/heichips26-on-off/macros/heichips26_ook_top/macros/ook_analog_system/netlist/pex/output_buffer_magic_pex_3.spice
.include /home/belal/HeiChips/heichips26-on-off/macros/heichips26_ook_top/netlist/pex/heichips26_ook_top_magic_pex_3.spice
.include /home/belal/HeiChips/heichips26-on-off/IHP-Open-PDK/ihp-sg13cmos5l/libs.ref/sg13cmos5l_io/spice/sg13cmos5l_io.spi

**** end user architecture code
**.ends
.GLOBAL VDD
.GLOBAL GND
.GLOBAL VDDA
.end
