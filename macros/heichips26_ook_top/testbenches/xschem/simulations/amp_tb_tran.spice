** sch_path: /home/belal/HeiChips/heichips26-on-off/macros/heichips26_ook_top/testbenches/xschem/amp_tb_tran.sch
**.subckt amp_tb_tran
VDDSRC VDD GND {1.5}
XM1 net1 net2 GND GND sg13_lv_nmos w=2u l=0.13u ng=1 m=1 mm_ok=1
XM2 net1 net2 VDD VDD sg13_lv_pmos w=4u l=0.13u ng=1 m=1 mm_ok=1
XR1 net2 net1 GND rhigh w=2e-6 l=3.85e-6 m=1 b=0 mm_ok=1
C1 vin net2 10p
Bvin1 vin net3 V={(V(nenv)*sin(6.283185307*433.92e6*time))}
Venv nenv GND PULSE(1e-12 1e-3 0 {tr} {tr} 1e-6 10)
Vspike net3 GND PULSE(0 1e-3 0 50p 50p 1n 6.25n)
XM3 net4 net1 GND GND sg13_lv_nmos w=6u l=0.13u ng=3 m=1 mm_ok=1
XM4 net4 net1 VDD VDD sg13_lv_pmos w=12u l=0.13u ng=3 m=1 mm_ok=1
XM5 net5 net6 GND GND sg13_lv_nmos w=12u l=0.13u ng=3 m=1 mm_ok=1
XM6 net5 net6 VDD VDD sg13_lv_pmos w=24u l=0.13u ng=10 m=1 mm_ok=1
XR2 net6 net5 GND rhigh w=2e-6 l=3.85e-6 m=1 b=0 mm_ok=1
XC2 net6 net4 cap_mfringe w=10.0u l=10.0u mmin=3 mmax=4
XM7 net7 net5 GND GND sg13_lv_nmos w=24u l=0.13u ng=10 m=1 mm_ok=1
XM8 net7 net5 VDD VDD sg13_lv_pmos w=48u l=0.13u ng=20 m=1 mm_ok=1
C4 net8 net9 1p
L1 net9 GND 1u
D1 net7 vout D1N914 area=1
C3 vout GND 2.5p
R3 GND vout 250k
**** begin user architecture code

.param VDD=1.5
.param tr=1e-9
.param tr_data=50e-9
.param c4val=100f
.options klu reltol=1e-3 abstol=1e-12 vntol=1e-6 gmin=1e-12 itl1=200 itl4=100 rshunt=1e9 trtol=20
.save vin vout
.control
tran 100p 2u 0 100p
plot vout vin
.endc

.lib cornerMOSlv.lib mos_tt
.lib cornerMOShv.lib mos_tt
.lib cornerRES.lib res_typ
.lib cornerDIO.lib dio_tt
.lib cornerCAP.lib cap_typ
.model d1n914 D(IS=5.0e-9 RS=0.8 N=2.0 CJO=2.0e-12 M=0.4 TT=4.0e-9 BV=100 IBV=1e-4 EG=1.11 XTI=3)
.include /home/belal/HeiChips/heichips26-on-off/macros/heichips26_ook_top/macros/dac/netlist/xspice/dac.xspice
.include /home/belal/HeiChips/heichips26-on-off/macros/heichips26_ook_top/macros/ook_analog_system/netlist/pex/ook_transmitter_magic_pex_3.spice
.include /home/belal/HeiChips/heichips26-on-off/macros/heichips26_ook_top/macros/ook_analog_system/netlist/pex/ook_analog_system_magic_pex_3.spice
.include /home/belal/HeiChips/heichips26-on-off/IHP-Open-PDK/ihp-sg13cmos5l/libs.tech/ngspice/models/cap_mfringe.lib
.include /home/belal/HeiChips/heichips26-on-off/macros/heichips26_ook_top/macros/ook_analog_system/netlist/pex/vco_magic_pex_3.spice
.include /home/belal/HeiChips/heichips26-on-off/macros/heichips26_ook_top/macros/ook_analog_system/netlist/pex/output_buffer_magic_pex_3.spice
.include /home/belal/HeiChips/heichips26-on-off/macros/heichips26_ook_top/netlist/pex/heichips26_ook_top_magic_pex_3.spice
.include /home/belal/HeiChips/heichips26-on-off/IHP-Open-PDK/ihp-sg13cmos5l/libs.ref/sg13cmos5l_io/spice/sg13cmos5l_io.spi

**** end user architecture code
**.ends
.GLOBAL VDD
.GLOBAL GND
.end
