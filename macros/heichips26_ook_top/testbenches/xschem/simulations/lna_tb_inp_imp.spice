** sch_path: /home/belal/HeiChips/heichips26-on-off/macros/heichips26_ook_top/testbenches/xschem/lna_tb_inp_imp.sch
**.subckt lna_tb_inp_imp
x1 GND VDDA GND VDDA net1 net42 sg13cmos5l_IOPadAnalog
* noconn #net33
* noconn #net32
* noconn #net31
* noconn #net30
* noconn #net29
* noconn #net28
* noconn #net27
* noconn #net26
* noconn #net25
* noconn #net24
* noconn #net23
* noconn #net22
* noconn #net21
* noconn #net20
* noconn #net19
* noconn #net18
* noconn #net17
* noconn #net16
* noconn #net15
* noconn #net14
* noconn #net13
* noconn #net12
* noconn #net11
* noconn #net10
* noconn #net9
* noconn #net8
* noconn #net7
* noconn #net6
* noconn #net41
* noconn #net40
* noconn #net39
* noconn #net38
* noconn #net37
* noconn #net36
* noconn #net35
* noconn #net34
x3 net6 net24 net14 net7 net15 net25 net8 net26 net16 net27 net17 net9 net10 net18 net28 net29 net19 net11 VDD VDDA net12 net20
+ net30 net42 vout_accum net44 net2 net3 net4 net5 net13 net31 net21 GND VDD VDD net32 net22 GND net23 net33 net34 net35 net36 net37
+ net38 net39 net40 net41 heichips26_ook_top_pex
C5 VDD GND 10.0p
* noconn #net44
* noconn #net2
* noconn #net3
* noconn #net4
* noconn #net5
Cb5 vout_accum GND 2.5p
R2 GND vout_accum 250k
C6 vout_accum net43 1p
L7 net43 GND 1u
I0 GND i_in dc 0 ac 1
Cb1 net45 net1 20p
RBIAS1 i_in GND 10meg
VDD VDD GND {VDD}
VDDSRC1 VDDA GND {3.3}
Cb2 net49 net45 1.35p
L12 net45 GND 89.0n
C3 net46 net47 0.75p
L15 net49 net46 178n
C1 net47 GND 106p
L17 net47 GND 1.26n
C2 net48 i_in 0.75p
L19 net47 net48 178n
**** begin user architecture code

.param VDD=1.5
.param temp=27
.options savecurrents klu reltol=1e-4 abstol=1e-15 gmin=1e-15 rshunt=1e9

.control
let Rs = 50
let f_ism = 433.92e6

save all
op
print all
write lna_tb_inp_imp\.raw
set appendwrite

ac lin 401 200e6 600e6 uic

let Zin      = v(i_in)
let Zin_mag  = mag(Zin)
let Zin_re   = real(Zin)
let Zin_im   = imag(Zin)
let Zin_ph   = 180/PI*cphase(Zin)

let Zpin     = v(net1)
let Zpin_mag = mag(Zpin)
let Zpin_re  = real(Zpin)
let Zpin_im  = imag(Zpin)

let Gam    = (Zin - Rs)/(Zin + Rs)
let Gmag   = mag(Gam)
let S11_dB = db(Gmag)
let ML_dB  = -10*log10(1 - Gmag*Gmag)

remzerovec
write lna_tb_inp_imp.raw
unset appendwrite

meas ac Zmag_ism find Zin_mag  when frequency=$&f_ism
meas ac Zre_ism  find Zin_re   when frequency=$&f_ism
meas ac Zim_ism  find Zin_im   when frequency=$&f_ism
meas ac Zph_ism  find Zin_ph   when frequency=$&f_ism

meas ac Zpre_ism find Zpin_re  when frequency=$&f_ism
meas ac Zpim_ism find Zpin_im  when frequency=$&f_ism

meas ac S11_ism  find S11_dB   when frequency=$&f_ism
meas ac ML_ism   find ML_dB    when frequency=$&f_ism

echo
echo   Zin  magnitude = $&Zmag_ism ohm
echo   Zin  real      = $&Zre_ism ohm
echo   Zin  imag      = $&Zim_ism ohm
echo   Zin  phase     = $&Zph_ism deg
echo
echo   Zpin real      = $&Zpre_ism ohm
echo   Zpin imag      = $&Zpim_ism ohm
echo
echo   S11            = $&S11_ism dB
echo   mismatch loss  = $&ML_ism dB
echo

plot Zin_re Zin_im xlimit 200e6 600e6 ylabel 'Zin real / imag [ohm]' xlabel 'Frequency [Hz]'

.endc

.lib cornerMOSlv.lib mos_tt
.lib cornerMOShv.lib mos_tt
.lib cornerRES.lib res_typ
.lib cornerDIO.lib dio_tt
.include /home/belal/HeiChips/heichips26-on-off/macros/heichips26_ook_top/macros/ook_analog_system/netlist/pex/lna_magic_pex_3.spice
.include /home/belal/HeiChips/heichips26-on-off/IHP-Open-PDK/ihp-sg13cmos5l/libs.ref/sg13cmos5l_io/spice/sg13cmos5l_io.spi
.include /home/belal/HeiChips/heichips26-on-off/macros/heichips26_ook_top/netlist/pex/heichips26_ook_top_magic_pex_3.spice

**** end user architecture code
**.ends
.GLOBAL GND
.GLOBAL VDD
.GLOBAL VDDA
.end
