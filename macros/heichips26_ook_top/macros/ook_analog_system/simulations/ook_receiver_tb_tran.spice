** sch_path: /home/belal/HeiChips/heichips26-on-off/macros/heichips26_ook/macros/ook_analog_system/testbenches/xschem/ook_receiver_tb_tran.sch
**.subckt ook_receiver_tb_tran
VDD3_3 VDD3_3 GND {VDD3_3}
VDD1_5 VDD1_5 GND {VDD1_5}
vclk clk GND PULSE(0 1.5 13n 0.1n 0.1n 50n 100n)
Cb5 vout GND 2.4p
R2 GND vout 250k
L20 net2 net3 8.33u
R1 net2 vin 50
Cb1 net1 GND 1.25n
Cb3 net3 net1 16.14f
L22 net1 GND 107p
L24 net1 net4 344n
Cb4 net4 GND 330f
Cb2 net4 net5 10p
x1 net6 net7 net8 net9 net10 net11 net12 net13 VDD3_3 VDD1_5 q3 q2 net5 q1 q0 vout GND net14 ook_receiver
**** begin user architecture code

.param VDD3_3=3.3
.param VDD1_5=1.5
.options rshunt=1G
.param temp=27
.options savecurrents klu reltol=1e-3 abstol=1e-12 vntol=1e-6 gmin=1e-12
.options itl4=500
.options method=gear maxord=2
.options trtol=10
Vcarrier ncar 0 SINE(0 100m 433.92e6)
Venv nenv 0 PULSE(0 1 5.4u 0.6u 0.6u 5.4u 12u)
*Vnoise nnoise 0 DC 0 TRNOISE(223.6n 1p 0 0)
Bvin1 vin 0 V={(V(nenv)*V(ncar) + 1e-12)}
.control
save vin i(vdd3_3) i(vdd1_5) vout q0 q1 q2 q3 x1.ampo
op
print all
write ook_receiver_tb_tran\.raw
set appendwrite
tran 100p 36u 0u 100p uic
*tran 10p 11.6u 11.2u 100p
write ook_receiver_tb_tran\.raw
unset appendwrite
plot i(vdd3_3)
plot i(vdd1_5)
plot v(vout) vin
plot v(vout) q0 q1 q2 q3
plot x1.ampo
.endc

.lib cornerMOSlv.lib mos_tt
.lib cornerMOShv.lib mos_tt
.lib cornerRES.lib res_typ
.lib cornerDIO.lib dio_tt
.lib cornerCAP.lib cap_typ

**** end user architecture code
**.ends

* expanding   symbol:  ook_receiver.sym # of pins=18
** sym_path: /home/belal/HeiChips/heichips26-on-off/macros/heichips26_ook/macros/ook_analog_system/schematic/xschem/ook_receiver.sym
** sch_path: /home/belal/HeiChips/heichips26-on-off/macros/heichips26_ook/macros/ook_analog_system/schematic/xschem/ook_receiver.sch
.subckt ook_receiver vref0 vref1 vref2 vref3 Cap_M1 Cap_M2 Cap_M21 Cap_M11 VDD3_3 VDD1_5 q3 q2 vin q1 q0 ACC_CAP VSS vamp
*.iopin VSS
*.ipin vin
*.iopin q3
*.iopin VDD3_3
*.iopin VDD1_5
*.iopin q2
*.iopin q1
*.iopin q0
*.iopin ACC_CAP
*.iopin Cap_M2
*.iopin Cap_M1
*.iopin Cap_M21
*.iopin Cap_M11
*.iopin vamp
*.iopin vref3
*.iopin vref2
*.iopin vref1
*.iopin vref0
x2 VDD1_5 VDD3_3 ACC_CAP q0 vref0 VSS q1 vref1 q2 vref2 q3 vref3 simple_comparator_stage
x3 VSS net1 ACC_CAP VDD3_3 vamp peak_detector
x1 Cap_M2 Cap_M1 VDD3_3 net1 vin VSS Cap_M21 Cap_M11 lna_stage
.ends

* expanding   symbol:  simple_comparator_stage.sym # of pins=12
** sym_path: /home/belal/HeiChips/heichips26-on-off/macros/heichips26_ook/macros/ook_analog_system/schematic/xschem/simple_comparator_stage.sym
** sch_path: /home/belal/HeiChips/heichips26-on-off/macros/heichips26_ook/macros/ook_analog_system/schematic/xschem/simple_comparator_stage.sch
.subckt simple_comparator_stage VDDL VDD vin q0 vref0 VSS q1 vref1 q2 vref2 q3 vref3
*.iopin VDD
*.iopin VSS
*.opin q0
*.iopin VDDL
*.ipin vin
*.opin q1
*.opin q2
*.opin q3
*.ipin vref3
*.ipin vref2
*.ipin vref1
*.ipin vref0
x1 vin vref0 VDD VSS q0 VDDL simple_comparator
x2 vin vref1 VDD VSS q1 VDDL simple_comparator
x3 vin vref2 VDD VSS q2 VDDL simple_comparator
x4 vin vref3 VDD VSS q3 VDDL simple_comparator
XR1 VDD vref3 VSS rhigh w=2e-6 l=4.2e-5 m=1 b=0 mm_ok=1
XR2 vref3 vref2 VSS rppd w=2e-6 l=2.0e-6 m=1 b=0 mm_ok=1
XR4 vref1 vref0 VSS rppd w=2e-6 l=3.6e-6 m=1 b=0 mm_ok=1
XR3 vref2 vref1 VSS rppd w=2e-6 l=1.28e-6 m=1 b=0 mm_ok=1
XR5 vref0 VSS VSS rhigh w=2e-6 l=3.49e-6 m=1 b=0 mm_ok=1
.ends

* expanding   symbol:  peak_detector.sym # of pins=5
** sym_path: /home/belal/HeiChips/heichips26-on-off/macros/heichips26_ook/macros/ook_analog_system/schematic/xschem/peak_detector.sym
** sch_path: /home/belal/HeiChips/heichips26-on-off/macros/heichips26_ook/macros/ook_analog_system/schematic/xschem/peak_detector.sch
.subckt peak_detector VSS vin vout VDD vamp
*.ipin vin
*.iopin vout
*.iopin VSS
*.iopin VDD
*.iopin vamp
XM1 vamp vamp vout VSS sg13_hv_nmos w=20.0u l=0.5u ng=10 m=1 mm_ok=1
XM24 net1 net1 VDD VDD sg13_hv_pmos w=14u l=0.5u ng=7 m=1 mm_ok=1
XM25 vamp net1 VDD VDD sg13_hv_pmos w=14u l=0.5u ng=7 m=1 mm_ok=1
XR5 net1 VSS VSS rhigh w=2e-6 l=10e-6 m=1 b=0 ps=0.18e-6 mm_ok=1
XM13 VDD VDD VDD VDD sg13_hv_pmos w=2u l=0.5u ng=1 m=1 mm_ok=1
XM26 VDD VDD VDD VDD sg13_hv_pmos w=2u l=0.5u ng=1 m=1 mm_ok=1
XM27 vamp vamp vamp VDD sg13_hv_pmos w=2u l=0.5u ng=1 m=1 mm_ok=1
XM28 net1 net1 net1 VDD sg13_hv_pmos w=2u l=0.5u ng=1 m=1 mm_ok=1
XR3 vamp VSS VSS rhigh w=2e-6 l=3e-6 m=1 b=0 ps=0.18e-6 mm_ok=1
.ends

* expanding   symbol:  lna_stage.sym # of pins=8
** sym_path: /home/belal/HeiChips/heichips26-on-off/macros/heichips26_ook/macros/ook_analog_system/schematic/xschem/lna_stage.sym
** sch_path: /home/belal/HeiChips/heichips26-on-off/macros/heichips26_ook/macros/ook_analog_system/schematic/xschem/lna_stage.sch
.subckt lna_stage Cap_M2 Cap_M1 VDD vout vin VSS Cap_M21 Cap_M11
*.ipin vin
*.iopin VSS
*.iopin VDD
*.iopin Cap_M2
*.iopin Cap_M1
*.iopin vout
*.iopin Cap_M21
*.iopin Cap_M11
x2 VDD Cap_M1 vin VSS lna
x1 VDD Cap_M11 Cap_M2 VSS lna
x3 VDD vout Cap_M21 VSS lna
.ends

* expanding   symbol:  simple_comparator.sym # of pins=6
** sym_path: /home/belal/HeiChips/heichips26-on-off/macros/heichips26_ook/macros/ook_analog_system/schematic/xschem/simple_comparator.sym
** sch_path: /home/belal/HeiChips/heichips26-on-off/macros/heichips26_ook/macros/ook_analog_system/schematic/xschem/simple_comparator.sch
.subckt simple_comparator vin vref VDD VSS comp_out VDDL
*.ipin vin
*.ipin vref
*.iopin VDD
*.iopin VSS
*.opin comp_out
*.iopin VDDL
XMBIAS vbias vbias VDD VDD sg13_hv_pmos w=4u l=0.5u ng=1 m=1 mm_ok=1
XRBIAS vbias VSS VSS rhigh w=2e-6 l=120.08e-6 m=1 b=0 mm_ok=1
XM3P net1 vbias VDD VDD sg13_hv_pmos w=4u l=0.5u ng=1 m=1 mm_ok=1
XM1P outn vin net1 VDD sg13_hv_pmos w=4u l=0.5u ng=1 m=1 mm_ok=1
XM2P net2 vref net1 VDD sg13_hv_pmos w=4u l=0.5u ng=1 m=1 mm_ok=1
XM4N outn outn VSS VSS sg13_hv_nmos w=2u l=0.5u ng=1 m=1 mm_ok=1
XM5N net2 outn VSS VSS sg13_hv_nmos w=2u l=0.5u ng=1 m=1 mm_ok=1
XMP1 net3 net2 VDD VDD sg13_hv_pmos w=4u l=0.5u ng=1 m=1 mm_ok=1
XMN1 net3 net2 VSS VSS sg13_hv_nmos w=2u l=0.5u ng=1 m=1 mm_ok=1
XMP2 comp_out net3 VDDL VDDL sg13_hv_pmos w=4u l=0.5u ng=1 m=1 mm_ok=1
XMN2 comp_out net3 VSS VSS sg13_hv_nmos w=2u l=0.5u ng=1 m=1 mm_ok=1
.ends

* expanding   symbol:  lna.sym # of pins=4
** sym_path: /home/belal/HeiChips/heichips26-on-off/macros/heichips26_ook/macros/ook_analog_system/schematic/xschem/lna.sym
** sch_path: /home/belal/HeiChips/heichips26-on-off/macros/heichips26_ook/macros/ook_analog_system/schematic/xschem/lna.sch
.subckt lna VDD vout vin VSS
*.iopin VDD
*.iopin VSS
*.ipin vin
*.iopin vout
XM14 vout VDD net6 VSS sg13_hv_nmos w=2.0u l=0.5u ng=2 m=1 mm_ok=1
XM15 net6 vin VSS VSS sg13_hv_nmos w=18.0u l=0.5u ng=18 m=1 mm_ok=1
XM16 net1 net1 VSS VSS sg13_hv_nmos w=2.00u l=0.5u ng=2 m=1 mm_ok=1
XM17 isource1 vout VSS VSS sg13_hv_nmos w=0.5u l=0.5u ng=1 m=1 mm_ok=1
XM18 VDD isource1 isink1 VSS sg13_hv_nmos w=1.5u l=0.5u ng=1 m=1 mm_ok=1
XM19 VSS isink1 vout VDD sg13_hv_pmos w=0.7u l=0.5u ng=1 m=1 mm_ok=1
XM20 net2 net2 VSS VSS sg13_hv_nmos w=10.0u l=0.5u ng=5 m=1 mm_ok=1
XM21 isink1 net2 VSS VSS sg13_hv_nmos w=10.0u l=0.5u ng=5 m=1 mm_ok=1
XM22 net3 net3 VDD VDD sg13_hv_pmos w=14u l=0.5u ng=7 m=1 mm_ok=1
XM23 isource1 net3 VDD VDD sg13_hv_pmos w=14u l=0.5u ng=7 m=1 mm_ok=1
XM24 net4 net4 VDD VDD sg13_hv_pmos w=14u l=0.5u ng=7 m=1 mm_ok=1
XM25 vout net4 VDD VDD sg13_hv_pmos w=14u l=0.5u ng=7 m=1 mm_ok=1
XR2 net1 vin VSS rhigh w=2.0e-6 l=9.96e-6 m=1 b=3 ps=0.18e-6 mm_ok=1
XR5 net4 VSS VSS rhigh w=2e-6 l=4.95e-6 m=1 b=2 ps=0.18e-6 mm_ok=1
XR1 VDD net1 VSS rhigh w=2e-6 l=19.995e-6 m=1 b=9 ps=0.18e-6 mm_ok=1
XR6 VDD net2 VSS rhigh w=2.0e-6 l=19.995e-6 m=1 b=9 ps=0.18e-6 mm_ok=1
XM2 net5 net5 VSS VSS sg13_hv_nmos w=0.5u l=0.5u ng=1 m=1 mm_ok=1
XM3 vout net5 VSS VSS sg13_hv_nmos w=0.5u l=0.5u ng=1 m=1 mm_ok=1
XR4 net3 VSS VSS rhigh w=2e-6 l=4.95e-6 m=1 b=2 ps=0.18e-6 mm_ok=1
XR13 VDD net5 VSS rhigh w=2e-6 l=22.72e-6 m=1 b=10 ps=0.18e-6 mm_ok=1
XM1 VSS VSS VSS VDD sg13_hv_pmos w=0.7u l=0.5u ng=1 m=1 mm_ok=1
XM4 vout vout vout VDD sg13_hv_pmos w=0.7u l=0.5u ng=1 m=1 mm_ok=1
XM5 VSS VSS VSS VSS sg13_hv_nmos w=0.5u l=0.5u ng=1 m=1 mm_ok=1
XM6 isource1 isource1 isource1 VSS sg13_hv_nmos w=0.5u l=0.5u ng=1 m=1 mm_ok=1
XM7 isink1 isink1 isink1 VSS sg13_hv_nmos w=1.5u l=0.5u ng=1 m=1 mm_ok=1
XM8 VDD VDD VDD VSS sg13_hv_nmos w=1.5u l=0.5u ng=1 m=1 mm_ok=1
XM9 isource1 isource1 isource1 VDD sg13_hv_pmos w=2u l=0.5u ng=1 m=1 mm_ok=1
XM10 VDD VDD VDD VDD sg13_hv_pmos w=2u l=0.5u ng=1 m=1 mm_ok=1
XM11 VDD VDD VDD VDD sg13_hv_pmos w=2u l=0.5u ng=1 m=1 mm_ok=1
XM12 net3 net3 net3 VDD sg13_hv_pmos w=2u l=0.5u ng=1 m=1 mm_ok=1
XM13 VDD VDD VDD VDD sg13_hv_pmos w=2u l=0.5u ng=1 m=1 mm_ok=1
XM26 VDD VDD VDD VDD sg13_hv_pmos w=2u l=0.5u ng=1 m=1 mm_ok=1
XM27 vout vout vout VDD sg13_hv_pmos w=2u l=0.5u ng=1 m=1 mm_ok=1
XM28 net4 net4 net4 VDD sg13_hv_pmos w=2u l=0.5u ng=1 m=1 mm_ok=1
XM29 isink1 isink1 isink1 VSS sg13_hv_nmos w=2.0u l=0.5u ng=1 m=1 mm_ok=1
XM30 VSS VSS VSS VSS sg13_hv_nmos w=2.0u l=0.5u ng=1 m=1 mm_ok=1
XM31 net2 net2 net2 VSS sg13_hv_nmos w=2.0u l=0.5u ng=1 m=1 mm_ok=1
XM32 VSS VSS VSS VSS sg13_hv_nmos w=2.0u l=0.5u ng=1 m=1 mm_ok=1
XM33 vout vout vout VSS sg13_hv_nmos w=0.5u l=0.5u ng=1 m=1 mm_ok=1
XM34 VSS VSS VSS VSS sg13_hv_nmos w=0.5u l=0.5u ng=1 m=1 mm_ok=1
XM35 net5 net5 net5 VSS sg13_hv_nmos w=0.5u l=0.5u ng=1 m=1 mm_ok=1
XM36 VSS VSS VSS VSS sg13_hv_nmos w=0.5u l=0.5u ng=1 m=1 mm_ok=1
XM37 vout vout vout VSS sg13_hv_nmos w=1.0u l=0.5u ng=1 m=1 mm_ok=1
XM38 net6 net6 net6 VSS sg13_hv_nmos w=1.0u l=0.5u ng=1 m=1 mm_ok=1
XM39 net6 net6 net6 VSS sg13_hv_nmos w=1.0u l=0.5u ng=1 m=1 mm_ok=1
XM40 VSS VSS VSS VSS sg13_hv_nmos w=1.0u l=0.5u ng=1 m=1 mm_ok=1
XM41 net1 net1 net1 VSS sg13_hv_nmos w=1.00u l=0.5u ng=1 m=1 mm_ok=1
XM42 VSS VSS VSS VSS sg13_hv_nmos w=1.00u l=0.5u ng=1 m=1 mm_ok=1
.ends

.GLOBAL GND
.GLOBAL VDD3_3
.GLOBAL VDD1_5
.end
