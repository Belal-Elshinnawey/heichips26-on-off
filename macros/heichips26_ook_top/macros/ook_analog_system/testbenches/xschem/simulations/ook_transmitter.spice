** sch_path: /home/belal/HeiChips/heichips26-on-off/macros/heichips26_ook/macros/ook_analog_system/schematic/xschem/ook_transmitter.sch
**.subckt ook_transmitter clk_ref rst_ni vctrl_in vctrl_b_in dac_out clk_fb vcl VGND VPWR vout vctrl_out vctrl_b_out
*.iopin vout
*.iopin VPWR
*.iopin VGND
*.iopin vcl
*.iopin dac_out
*.iopin clk_fb
*.iopin clk_ref
*.iopin rst_ni
*.iopin vctrl_in
*.iopin vctrl_b_in
*.iopin vctrl_out
*.iopin vctrl_b_out
XR1 vcl dac_out VGND rhigh w=1e-6 l=61.395e-6 m=1 b=2 ps=0.18e-6 mm_ok=1
x1 net1 VPWR VGND net2 vco
x2 clk_fb vctrl_out VPWR net1 vout VGND vctrl_b_out output_buffer
XR2 net2 vcl VGND rsil w=0.5e-6 l=0.5e-6 m=1 mm_ok=1
x7 VGND VPWR clk_fb clk_ref dac_out rst_ni vctrl_b_in vctrl_b_out vctrl_in vctrl_out dac
**.ends

* expanding   symbol:  vco.sym # of pins=4
** sym_path: /home/belal/HeiChips/heichips26-on-off/macros/heichips26_ook/macros/ook_analog_system/schematic/xschem/vco.sym
** sch_path: /home/belal/HeiChips/heichips26-on-off/macros/heichips26_ook/macros/ook_analog_system/schematic/xschem/vco.sch
.subckt vco vout VDD VSS VCL
*.opin vout
*.iopin VDD
*.iopin VSS
*.ipin VCL
XM1 net1 vosc net4 VDD sg13_lv_pmos w=4.5u l=0.13u ng=10 m=1 mm_ok=1
XM2 net1 vosc net7 VSS sg13_lv_nmos w=2u l=0.13u ng=5 m=1 mm_ok=1
XM3 net2 net1 net5 VDD sg13_lv_pmos w=4.5u l=0.13u ng=10 m=1 mm_ok=1
XM4 net2 net1 net8 VSS sg13_lv_nmos w=2u l=0.13u ng=5 m=1 mm_ok=1
XM5 vosc net2 net6 VDD sg13_lv_pmos w=4.5u l=0.13u ng=10 m=1 mm_ok=1
XM6 vosc net2 net9 VSS sg13_lv_nmos w=2u l=0.13u ng=5 m=1 mm_ok=1
XM7 vout vosc VDD VDD sg13_lv_pmos w=4.5u l=0.13u ng=10 m=1 mm_ok=1
XM8 vout vosc VSS VSS sg13_lv_nmos w=2u l=0.13u ng=5 m=1 mm_ok=1
XM9 net4 VCH VDD VDD sg13_lv_pmos w=5u l=0.13u ng=10 m=1 mm_ok=1
XM10 net5 VCH VDD VDD sg13_lv_pmos w=5u l=0.13u ng=10 m=1 mm_ok=1
XM11 net6 VCH VDD VDD sg13_lv_pmos w=5u l=0.13u ng=10 m=1 mm_ok=1
XM12 net7 VCL_L VSS VSS sg13_lv_nmos w=3u l=0.13u ng=5 m=1 mm_ok=1
XM13 net8 VCL_L VSS VSS sg13_lv_nmos w=3u l=0.13u ng=5 m=1 mm_ok=1
XM14 net9 VCL_L VSS VSS sg13_lv_nmos w=3u l=0.13u ng=5 m=1 mm_ok=1
XM15 VCH VCH VDD VDD sg13_lv_pmos w=5u l=0.13u ng=10 m=1 mm_ok=1
XM16 VCH VCL net3 VSS sg13_lv_nmos w=40u l=0.13u ng=20 m=1 mm_ok=1
XM17 VCL_L VCH VDD VDD sg13_lv_pmos w=5u l=0.13u ng=10 m=1 mm_ok=1
XM18 VCL_L VCL_L VSS VSS sg13_lv_nmos w=3u l=0.13u ng=5 m=1 mm_ok=1
XR1 net3 VSS VSS rhigh w=2e-6 l=3.5e-6 m=1 b=0 mm_ok=1
XM19 VDD VDD VDD VDD sg13_lv_pmos w=0.5u l=0.13u ng=1 m=1 mm_ok=1
XM20 VCH VCH VCH VDD sg13_lv_pmos w=0.5u l=0.13u ng=1 m=1 mm_ok=1
XM21 VCH VCH VCH VSS sg13_lv_nmos w=2u l=0.13u ng=1 m=1 mm_ok=1
XM22 net3 net3 net3 VSS sg13_lv_nmos w=2u l=0.13u ng=1 m=1 mm_ok=1
XM23 VDD VDD VDD VDD sg13_lv_pmos w=0.5u l=0.13u ng=1 m=1 mm_ok=1
XM24 VCL_L VCL_L VCL_L VDD sg13_lv_pmos w=0.5u l=0.13u ng=1 m=1 mm_ok=1
XM25 VCL_L VCL_L VCL_L VSS sg13_lv_nmos w=0.6u l=0.13u ng=1 m=1 mm_ok=1
XM26 VSS VSS VSS VSS sg13_lv_nmos w=0.6u l=0.13u ng=1 m=1 mm_ok=1
XM27 VDD VDD VDD VDD sg13_lv_pmos w=0.5u l=0.13u ng=1 m=1 mm_ok=1
XM28 VDD VDD VDD VDD sg13_lv_pmos w=0.5u l=0.13u ng=1 m=1 mm_ok=1
XM29 VDD VDD VDD VDD sg13_lv_pmos w=0.5u l=0.13u ng=1 m=1 mm_ok=1
XM30 net4 net4 net4 VDD sg13_lv_pmos w=0.5u l=0.13u ng=1 m=1 mm_ok=1
XM31 net5 net5 net5 VDD sg13_lv_pmos w=0.5u l=0.13u ng=1 m=1 mm_ok=1
XM32 net6 net6 net6 VDD sg13_lv_pmos w=0.5u l=0.13u ng=1 m=1 mm_ok=1
XM33 net7 net7 net7 VSS sg13_lv_nmos w=0.6u l=0.13u ng=1 m=1 mm_ok=1
XM34 net8 net8 net8 VSS sg13_lv_nmos w=0.6u l=0.13u ng=1 m=1 mm_ok=1
XM35 net9 net9 net9 VSS sg13_lv_nmos w=0.6u l=0.13u ng=1 m=1 mm_ok=1
XM36 VSS VSS VSS VSS sg13_lv_nmos w=0.6u l=0.13u ng=1 m=1 mm_ok=1
XM37 VSS VSS VSS VSS sg13_lv_nmos w=0.6u l=0.13u ng=1 m=1 mm_ok=1
XM38 VSS VSS VSS VSS sg13_lv_nmos w=0.6u l=0.13u ng=1 m=1 mm_ok=1
XM39 net7 net7 net7 VSS sg13_lv_nmos w=0.4u l=0.13u ng=1 m=1 mm_ok=1
XM40 net8 net8 net8 VSS sg13_lv_nmos w=0.4u l=0.13u ng=1 m=1 mm_ok=1
XM41 net9 net9 net9 VSS sg13_lv_nmos w=0.4u l=0.13u ng=1 m=1 mm_ok=1
XM42 net1 net1 net1 VSS sg13_lv_nmos w=0.4u l=0.13u ng=1 m=1 mm_ok=1
XM43 net2 net2 net2 VSS sg13_lv_nmos w=0.4u l=0.13u ng=1 m=1 mm_ok=1
XM44 vosc vosc vosc VSS sg13_lv_nmos w=0.4u l=0.13u ng=1 m=1 mm_ok=1
XM45 net1 net1 net1 VDD sg13_lv_pmos w=0.45u l=0.13u ng=1 m=1 mm_ok=1
XM46 net2 net2 net2 VDD sg13_lv_pmos w=0.45u l=0.13u ng=1 m=1 mm_ok=1
XM47 vosc vosc vosc VDD sg13_lv_pmos w=0.45u l=0.13u ng=1 m=1 mm_ok=1
XM48 net4 net4 net4 VDD sg13_lv_pmos w=0.45u l=0.13u ng=1 m=1 mm_ok=1
XM49 net5 net5 net5 VDD sg13_lv_pmos w=0.45u l=0.13u ng=1 m=1 mm_ok=1
XM50 net6 net6 net6 VDD sg13_lv_pmos w=0.45u l=0.13u ng=1 m=1 mm_ok=1
XM51 VSS VSS VSS VSS sg13_lv_nmos w=0.4u l=0.13u ng=1 m=1 mm_ok=1
XM52 vout vout vout VSS sg13_lv_nmos w=0.4u l=0.13u ng=1 m=1 mm_ok=1
XM53 vout vout vout VDD sg13_lv_pmos w=0.45u l=0.13u ng=1 m=1 mm_ok=1
XM54 VDD VDD VDD VDD sg13_lv_pmos w=0.45u l=0.13u ng=1 m=1 mm_ok=1
.ends

* expanding   symbol:  output_buffer.sym # of pins=7
** sym_path: /home/belal/HeiChips/heichips26-on-off/macros/heichips26_ook/macros/ook_analog_system/schematic/xschem/output_buffer.sym
** sch_path: /home/belal/HeiChips/heichips26-on-off/macros/heichips26_ook/macros/ook_analog_system/schematic/xschem/output_buffer.sch
.subckt output_buffer vout_fb vctrl VDD vin vout VSS vctrl_b
*.iopin VDD
*.iopin VSS
*.ipin vin
*.opin vout
*.ipin vctrl
*.opin vout_fb
*.ipin vctrl_b
XM7 vout_fb vin VDD VDD sg13_lv_pmos w=13.5u l=0.13u ng=10 m=1 mm_ok=1
XM8 vout_fb vin VSS VSS sg13_lv_nmos w=6u l=0.13u ng=5 m=1 mm_ok=1
XM3 net2 net1 VDD VDD sg13_lv_pmos w=40u l=0.13u ng=20 m=1 mm_ok=1
XM4 net2 net1 VSS VSS sg13_lv_nmos w=18u l=0.13u ng=10 m=1 mm_ok=1
XM1 vout net2 VDD VDD sg13_lv_pmos w=200u l=0.13u ng=50 m=1 mm_ok=1
XM2 vout net2 VSS VSS sg13_lv_nmos w=80u l=0.13u ng=20 m=1 mm_ok=1
XM5 net1 vctrl_b vout_fb VDD sg13_lv_pmos w=13.5u l=0.13u ng=10 m=1 mm_ok=1
XM6 net1 vctrl vout_fb VSS sg13_lv_nmos w=6u l=0.13u ng=5 m=1 mm_ok=1
XM11 net1 vctrl VSS VDD sg13_lv_pmos w=13.5u l=0.13u ng=10 m=1 mm_ok=1
XM12 net1 vctrl_b VSS VSS sg13_lv_nmos w=6u l=0.13u ng=5 m=1 mm_ok=1
XM17 VDD VDD VDD VDD sg13_lv_pmos w=1.3u l=0.13u ng=1 m=1 mm_ok=1
XM18 vout_fb vout_fb vout_fb VDD sg13_lv_pmos w=1.3u l=0.13u ng=1 m=1 mm_ok=1
XM19 vout_fb vout_fb vout_fb VSS sg13_lv_nmos w=1.2u l=0.13u ng=1 m=1 mm_ok=1
XM20 VSS VSS VSS VSS sg13_lv_nmos w=1.2u l=0.13u ng=1 m=1 mm_ok=1
XM21 vout_fb vout_fb vout_fb VDD sg13_lv_pmos w=1.3u l=0.13u ng=1 m=1 mm_ok=1
XM22 vout_fb vout_fb vout_fb VSS sg13_lv_nmos w=1.2u l=0.13u ng=1 m=1 mm_ok=1
XM23 VSS VSS VSS VSS sg13_lv_nmos w=1.2u l=0.13u ng=1 m=1 mm_ok=1
XM24 VSS VSS VSS VDD sg13_lv_pmos w=1.3u l=0.13u ng=1 m=1 mm_ok=1
XM25 net1 net1 net1 VDD sg13_lv_pmos w=1.3u l=0.13u ng=1 m=1 mm_ok=1
XM26 net1 net1 net1 VSS sg13_lv_nmos w=1.2u l=0.13u ng=1 m=1 mm_ok=1
XM27 net1 net1 net1 VSS sg13_lv_nmos w=1.2u l=0.13u ng=1 m=1 mm_ok=1
XM28 net1 net1 net1 VDD sg13_lv_pmos w=1.3u l=0.13u ng=1 m=1 mm_ok=1
XM29 VDD VDD VDD VDD sg13_lv_pmos w=2u l=0.13u ng=1 m=1 mm_ok=1
XM30 net2 net2 net2 VDD sg13_lv_pmos w=2u l=0.13u ng=1 m=1 mm_ok=1
XM31 net2 net2 net2 VSS sg13_lv_nmos w=1.8u l=0.13u ng=1 m=1 mm_ok=1
XM32 VSS VSS VSS VSS sg13_lv_nmos w=1.8u l=0.13u ng=1 m=1 mm_ok=1
XM33 VDD VDD VDD VDD sg13_lv_pmos w=4u l=0.13u ng=1 m=1 mm_ok=1
XM34 vout vout vout VDD sg13_lv_pmos w=4u l=0.13u ng=1 m=1 mm_ok=1
XM35 vout vout vout VSS sg13_lv_nmos w=4u l=0.13u ng=1 m=1 mm_ok=1
XM36 VSS VSS VSS VSS sg13_lv_nmos w=4u l=0.13u ng=1 m=1 mm_ok=1
.ends

.end
