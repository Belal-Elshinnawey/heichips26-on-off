** sch_path: /home/belal/HeiChips/heichips26-on-off/macros/heichips26_ook/macros/ook_analog_system/testbenches/xschem/simple_comparator_tb_tran.sch
**.subckt simple_comparator_tb_tran
VDDSRC VDD GND {VDD}
VIN vin GND PWL(0 {VIN_LOW} {T1} {VIN_LOW} {T2} {VIN_HIGH} {T3} {VIN_HIGH} {T4} {VIN_HOVER} {T5} {VIN_HOVER})
VREF vref GND {VREF_LEVEL}
VDDSRC1 VDDL GND {VDD/2}
x2 VDDL GND VDD vref vin comp_out simple_comparator
**** begin user architecture code

.param VDD=3.3
.param VREF_LEVEL=0.86
.param VIN_LOW=0
.param VIN_HIGH=0.92
.param VIN_HOVER=0.92
.param T1=1u
.param T2=2u
.param T3=4u
.param T4=5u
.param T5=10u
.options savecurrents klu reltol=1e-3 abstol=1e-12 vntol=1e-6 gmin=1e-9
.control
save v(vin) v(vref) v(comp_out) v(VDD) v(VSS) i(VDDSRC) i(VDDSRC1)
tran 1n 10u
write simple_comparator_tb_tran\.raw
meas tran t_cross_high TRIG v(vin) VAL={VREF_LEVEL} RISE=1 TARG v(comp_out) VAL={VDD/2} CROSS=1
meas tran t_hover_settle TRIG v(vin) VAL={VIN_HOVER} FALL=1 TARG v(comp_out) VAL={VDD/2} CROSS=1
print t_cross_high
print t_hover_settle
plot vin vref comp_out
plot i(VDDSRC)
plot i(VDDSRC1)
.endc

.lib cornerMOSlv.lib mos_tt
.lib cornerMOShv.lib mos_tt
.lib cornerRES.lib res_typ
.lib cornerDIO.lib dio_tt
.lib cornerCAP.lib cap_typ
.include /home/belal/HeiChips/heichips26-on-off/macros/heichips26_ook/macros/ook_analog_system/netlist/pex/simple_comparator_magic_pex_3.spice
.include /home/belal/HeiChips/heichips26-on-off/IHP-Open-PDK/ihp-sg13cmos5l/libs.tech/ngspice/models/cap_mfringe.lib

**** end user architecture code
**.ends

* expanding   symbol:  simple_comparator.sym # of pins=6
** sym_path: /home/belal/HeiChips/heichips26-on-off/macros/heichips26_ook/macros/ook_analog_system/schematic/xschem/simple_comparator.sym
** sch_path: /home/belal/HeiChips/heichips26-on-off/macros/heichips26_ook/macros/ook_analog_system/schematic/xschem/simple_comparator.sch
.subckt simple_comparator VDDL VSS VDD vref vin comp_out
*.ipin vin
*.ipin vref
*.iopin VDD
*.iopin VSS
*.opin comp_out
*.iopin VDDL
XMBIAS vbias vbias VDD VDD sg13_hv_pmos w=4u l=0.5u ng=1 m=1 mm_ok=1
XRBIAS vbias VSS VSS rhigh w=2e-6 l=120.08e-6 m=1 b=0 mm_ok=1
XM3P net4 vbias VDD VDD sg13_hv_pmos w=4u l=0.5u ng=1 m=1 mm_ok=1
XM1P outn vin net4 VDD sg13_hv_pmos w=4u l=0.5u ng=1 m=4 mm_ok=1
XM2P net1 vref net4 VDD sg13_hv_pmos w=4u l=0.5u ng=1 m=4 mm_ok=1
XM4N outn outn VSS VSS sg13_hv_nmos w=2u l=0.5u ng=1 m=4 mm_ok=1
XM5N net1 outn VSS VSS sg13_hv_nmos w=2u l=0.5u ng=1 m=4 mm_ok=1
XMP1 net2 net1 VDD VDD sg13_hv_pmos w=4u l=4u ng=1 m=1 mm_ok=1
XMN1 net2 net1 net3 VSS sg13_hv_nmos w=2u l=4u ng=1 m=1 mm_ok=1
XMP2 comp_out net2 VDDL VDDL sg13_hv_pmos w=4u l=4u ng=1 m=1 mm_ok=1
XMBIAS1 vbias vbias vbias VDD sg13_hv_pmos w=4u l=0.5u ng=1 m=1 mm_ok=1
XMBIAS2 VDD VDD VDD VDD sg13_hv_pmos w=4u l=0.5u ng=1 m=1 mm_ok=1
XM1 VDD VDD VDD VDD sg13_hv_pmos w=4u l=0.5u ng=1 m=1 mm_ok=1
XM2 net4 net4 net4 VDD sg13_hv_pmos w=4u l=0.5u ng=1 m=1 mm_ok=1
XMP3 net2 net2 net2 VDD sg13_hv_pmos w=4u l=4u ng=1 m=1 mm_ok=1
XMP4 VDD VDD VDD VDD sg13_hv_pmos w=4u l=4u ng=1 m=1 mm_ok=1
XMP5 VDDL VDDL VDDL VDDL sg13_hv_pmos w=4u l=4u ng=1 m=1 mm_ok=1
XMP6 comp_out comp_out comp_out VDDL sg13_hv_pmos w=4u l=4u ng=1 m=1 mm_ok=1
XMN3 comp_out comp_out comp_out VSS sg13_hv_nmos w=2u l=4u ng=1 m=1 mm_ok=1
XMN4 VSS VSS VSS VSS sg13_hv_nmos w=2u l=4u ng=1 m=1 mm_ok=1
XMN5 net2 net2 net2 VSS sg13_hv_nmos w=2u l=4u ng=1 m=1 mm_ok=1
XMN6 net3 net3 net3 VSS sg13_hv_nmos w=2u l=4u ng=1 m=1 mm_ok=1
XM3 net4 net4 net4 VDD sg13_hv_pmos w=4u l=0.5u ng=1 m=1 mm_ok=1
XM4 outn outn outn VDD sg13_hv_pmos w=4u l=0.5u ng=1 m=1 mm_ok=1
XM5 net1 net1 net1 VSS sg13_hv_nmos w=2u l=0.5u ng=1 m=1 mm_ok=1
XM6 VSS VSS VSS VSS sg13_hv_nmos w=2u l=0.5u ng=1 m=1 mm_ok=1
XM7 net4 net4 net4 VDD sg13_hv_pmos w=4u l=0.5u ng=1 m=1 mm_ok=1
XM8 net1 net1 net1 VDD sg13_hv_pmos w=4u l=0.5u ng=1 m=1 mm_ok=1
XM9 outn outn outn VSS sg13_hv_nmos w=2u l=0.5u ng=1 m=1 mm_ok=1
XM10 VSS VSS VSS VSS sg13_hv_nmos w=2u l=0.5u ng=1 m=1 mm_ok=1
XRBIAS1 net3 VSS VSS rhigh w=2e-6 l=10.0e-6 m=1 b=8 mm_ok=1
XMN8 comp_out net2 VSS VSS sg13_hv_nmos w=2u l=4u ng=1 m=1 mm_ok=1
.ends

.GLOBAL VDD
.GLOBAL GND
.GLOBAL VDDL
.end
