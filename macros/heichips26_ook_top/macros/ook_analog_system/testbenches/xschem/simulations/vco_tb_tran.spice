** sch_path: /home/belal/HeiChips/heichips26-on-off/macros/heichips26_ook/macros/ook_analog_system/testbenches/xschem/vco_tb_tran.sch
**.subckt vco_tb_tran vout
*.iopin vout
x1 net1 VDD GND VCL vco_pex
VDDSRC VDD GND {VDD}
VCLSRC VCL GND PWL(0 0.4 99n 0.4 100n 0.5 199n 0.5 200n 0.6 299n 0.6 300n 0.7 399n 0.7 400n 0.8 499n 0.8 500n 0.9 599n 0.9 600n
+ 1.0 699n 1.0 700n 1.1 799n 1.1 800n 1.2 899n 1.2 900n 1.3 999n 1.3 1000n 1.4 1099n 1.4 1100n 1.5 1200n 1.5)
x2 net2 VDD VDD net1 vout GND GND output_buffer_pex
**** begin user architecture code

.param VDD=1.5
.options klu reltol=1e-3 abstol=1e-12 vntol=1e-6 gmin=1e-12
.save vout VCL
.tran 10p 1.2u 0 uic

.lib cornerMOSlv.lib mos_tt
.lib cornerMOShv.lib mos_tt
.lib cornerRES.lib res_typ
.lib cornerDIO.lib dio_tt
.lib cornerCAP.lib cap_typ
.include /home/belal/HeiChips/heichips26-on-off/macros/heichips26_ook/macros/ook_analog_system/netlist/pex/vco_magic_pex_3.spice
.include /home/belal/HeiChips/heichips26-on-off/macros/heichips26_ook/macros/ook_analog_system/netlist/pex/output_buffer_magic_pex_3.spice

**** end user architecture code
**.ends
.GLOBAL VDD
.GLOBAL GND
.end
