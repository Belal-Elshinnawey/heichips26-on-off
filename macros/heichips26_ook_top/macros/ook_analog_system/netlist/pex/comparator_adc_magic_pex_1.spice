* PEX produced on Mon Sep 14 05:23:12 CEST 2026 using scripts/sak-pex.sh with m=1 and s=1
* NGSPICE file created from comparator_adc_pex.ext - technology: ihp-sg13cmos5l

.subckt comparator_adc_pex VDDL VDD vin q3 VSS q2 q1 q0 clk vref_1 vref_2 vref_3
+ vref_4
X0 q3 q3 q3 VDDL sg13_hv_pmos ad=1.36p pd=8.68u as=24.1098p ps=0.13178m w=4u l=0.5u
X1 GROUP5_3.pmosHV_priv15_0.S vin GROUP7_3.pmosHV$1_priv1_0.S VDD sg13_hv_pmos ad=1.7p pd=10.68u as=1.7p ps=10.68u w=5u l=0.5u
X2 GROUP23_0.nmosHV$1_priv1_0.S VDD GROUP21_2.G VSS sg13_hv_nmos ad=0.38p pd=2.38u as=0.38p ps=2.38u w=2u l=0.5u
X3 VSS VSS VSS VSS sg13_hv_nmos ad=0.34p pd=2.68u as=1.11222n ps=2.34322m w=1u l=0.5u
X4 GROUP9_1.nmosHV_priv4_0.S GROUP9_1.nmosHV_priv4_0.S GROUP9_1.nmosHV_priv4_0.S VDD sg13_hv_pmos ad=0.68p pd=4.68u as=13.2594p ps=51.74u w=2u l=0.5u
X5 GROUP21_0.G VSS GROUP23_0.nmosHV$1_priv1_0.S VDD sg13_hv_pmos ad=0.38p pd=2.38u as=0.38p ps=2.38u w=2u l=0.5u
X6 VSS VSS VSS VSS sg13_hv_nmos ad=0.34p pd=2.68u as=0 ps=0 w=1u l=0.5u
X7 pmosHV_priv2_0.D GROUP4$1_0/pmos_priv5_0.D VSS VSS sg13_hv_nmos ad=3.4p pd=20.68u as=3.4p ps=20.68u w=10u l=0.5u
X8 VSS VSS VSS VSS sg13_hv_nmos ad=0.34p pd=2.68u as=0 ps=0 w=1u l=0.5u
X9 GROUP7$1_0/nmosHV$1_priv1$1_0.D GROUP7$1_0/nmosHV$1_priv1$1_0.D GROUP7$1_0/nmosHV$1_priv1$1_0.D VDD sg13_hv_pmos ad=1.02p pd=6.68u as=8.3388p ps=36.52u w=3u l=0.5u
X10 VDD VDD VDD VDD sg13_hv_pmos ad=1.7p pd=10.68u as=0.24757n ps=0.78144m w=5u l=0.5u
X11 GROUP16_3.pmosHV$2_priv10_0.D GROUP16_3.pmosHV$2_priv10_0.D GROUP16_3.pmosHV$2_priv10_0.D VDDL sg13_hv_pmos ad=1.36p pd=8.68u as=12.0396p ps=45.16u w=4u l=0.5u
X12 VSS GROUP3_0/nmos_priv6_0.D GROUP4$1_0/pmos_priv5_0.D VSS sg13_lv_nmos ad=0.34p pd=2.68u as=0.34p ps=2.68u w=1u l=0.13u
X13 GROUP18_1.nmosHV_priv16_0.D GROUP21_0.nmosHV_priv25_0.S VSS VSS sg13_hv_nmos ad=0.34p pd=2.68u as=0.34p ps=2.68u w=1u l=0.5u
X14 GROUP7_2.pmosHV$1_priv1_0.S GROUP7_2.pmosHV$1_priv1_0.S GROUP7_2.pmosHV$1_priv1_0.S VDD sg13_hv_pmos ad=1.7p pd=10.68u as=13.2594p ps=51.74u w=5u l=0.5u
X15 GROUP23_0.nmosHV$1_priv1_0.S VDD GROUP21_2.G VSS sg13_hv_nmos ad=0.38p pd=2.38u as=0.38p ps=2.38u w=2u l=0.5u
X16 GROUP16_0.pmosHV$2_priv10_0.D GROUP18_0.nmosHV_priv16_0.D q3 VDDL sg13_hv_pmos ad=1.36p pd=8.68u as=1.36p ps=8.68u w=4u l=0.5u
X17 GROUP9_1.nmosHV_priv4_0.S GROUP9_1.nmosHV_priv4_0.S GROUP9_1.nmosHV_priv4_0.S VDD sg13_hv_pmos ad=1.7p pd=10.68u as=0 ps=0 w=5u l=0.5u
X18 GROUP21_0.nmosHV_priv25_0.S GROUP21_0.nmosHV_priv25_0.S GROUP21_0.nmosHV_priv25_0.S VDD sg13_hv_pmos ad=0.68p pd=4.68u as=45.658p ps=0.23585m w=2u l=0.5u
X19 GROUP21_0.G VSS GROUP23_0.nmosHV$1_priv1_0.S VDD sg13_hv_pmos ad=0.68p pd=4.68u as=0.38p ps=2.38u w=2u l=0.5u
X20 GROUP21_2.G VSS GROUP23_0.nmosHV$1_priv1_0.S VDD sg13_hv_pmos ad=0.38p pd=2.38u as=0.38p ps=2.38u w=2u l=0.5u
X21 q3 GROUP18_0.nmosHV_priv16_0.D VSS VSS sg13_hv_nmos ad=0.34p pd=2.68u as=0.34p ps=2.68u w=1u l=0.5u
X22 q1 q1 q1 VSS sg13_hv_nmos ad=0.34p pd=2.68u as=24.1098p ps=0.13178m w=1u l=0.5u
X23 GROUP21_3.G VDD GROUP23_0.nmosHV$1_priv1_0.S VSS sg13_hv_nmos ad=0.38p pd=2.38u as=0.38p ps=2.38u w=2u l=0.5u
X24 GROUP21_3.G VSS GROUP23_0.nmosHV$1_priv1_0.S VDD sg13_hv_pmos ad=0.38p pd=2.38u as=0.38p ps=2.38u w=2u l=0.5u
X25 GROUP23_0.nmosHV$1_priv1_0.S VSS GROUP21_1.G VDD sg13_hv_pmos ad=0.38p pd=2.38u as=0.38p ps=2.38u w=2u l=0.5u
X26 GROUP21_0.G VDD GROUP23_0.nmosHV$1_priv1_0.S VSS sg13_hv_nmos ad=0.38p pd=2.38u as=0.38p ps=2.38u w=2u l=0.5u
X27 GROUP22_2.nmosHV_priv28_0.D GROUP21_2.G VSS VSS sg13_hv_nmos ad=0.34p pd=2.68u as=0.34p ps=2.68u w=1u l=0.5u
X28 GROUP5_2.pmosHV_priv15_0.S vin GROUP7_2.pmosHV$1_priv1_0.S VDD sg13_hv_pmos ad=1.7p pd=10.68u as=1.7p ps=10.68u w=5u l=0.5u
X29 GROUP7_0.pmosHV$1_priv1_0.S GROUP7_0.pmosHV$1_priv1_0.S GROUP7_0.pmosHV$1_priv1_0.S VDD sg13_hv_pmos ad=1.7p pd=10.68u as=13.2594p ps=51.74u w=5u l=0.5u
X30 VSS pmosHV_priv2_0.D GROUP7$1_0/nmosHV$1_priv1$1_0.D VSS sg13_hv_nmos ad=0.34p pd=2.68u as=0.34p ps=2.68u w=1u l=0.5u
X31 VSS VSS VSS VSS sg13_hv_nmos ad=0.34p pd=2.68u as=0 ps=0 w=1u l=0.5u
X32 GROUP5_1.pmosHV_priv15_0.S vref_3 GROUP9_1.nmosHV_priv4_0.S VDD sg13_hv_pmos ad=1.7p pd=10.68u as=1.7p ps=10.68u w=5u l=0.5u
X33 GROUP9_3.nmosHV_priv4_0.S GROUP9_3.nmosHV_priv4_0.S GROUP9_3.nmosHV_priv4_0.S VDD sg13_hv_pmos ad=1.7p pd=10.68u as=13.2594p ps=51.74u w=5u l=0.5u
X34 GROUP21_2.nmosHV_priv25_0.S GROUP22_2.nmosHV_priv28_0.D VSS VSS sg13_hv_nmos ad=0.34p pd=2.68u as=0.34p ps=2.68u w=1u l=0.5u
X35 GROUP23_0.nmosHV$1_priv1_0.S VSS GROUP21_1.G VDD sg13_hv_pmos ad=0.38p pd=2.38u as=0.38p ps=2.38u w=2u l=0.5u
X36 GROUP18_1.nmosHV_priv16_0.D GROUP18_1.nmosHV_priv16_0.D GROUP18_1.nmosHV_priv16_0.D VSS sg13_hv_nmos ad=0.34p pd=2.68u as=24.5292p ps=0.13411m w=1u l=0.5u
X37 VSS VSS VSS VSS sg13_hv_nmos ad=0.34p pd=2.68u as=0 ps=0 w=1u l=0.5u
X38 GROUP21_0.G VDD GROUP23_0.nmosHV$1_priv1_0.S VSS sg13_hv_nmos ad=0.38p pd=2.38u as=0.38p ps=2.38u w=2u l=0.5u
X39 GROUP3_0/nmos_priv6_0.D GROUP3_0/nmos_priv6_0.D GROUP3_0/nmos_priv6_0.D VDDL sg13_lv_pmos ad=0.34p pd=2.68u as=14.5676p ps=72.93999u w=1u l=0.13u
X40 GROUP21_2.nmosHV_priv25_0.S GROUP21_2.nmosHV_priv25_0.S GROUP21_2.nmosHV_priv25_0.S VSS sg13_hv_nmos ad=0.34p pd=2.68u as=45.658p ps=0.23585m w=1u l=0.5u
X41 GROUP22_0.nmosHV_priv28_0.D GROUP22_0.nmosHV_priv28_0.D GROUP22_0.nmosHV_priv28_0.D VSS sg13_hv_nmos ad=0.34p pd=2.68u as=45.5261p ps=0.23483m w=1u l=0.5u
X42 VDDL VDDL VDDL VDDL sg13_hv_pmos ad=1.36p pd=8.68u as=66.73879p ps=0.259m w=4u l=0.5u
X43 GROUP21_1.G VDD GROUP23_0.nmosHV$1_priv1_0.S VSS sg13_hv_nmos ad=0.38p pd=2.38u as=0.38p ps=2.38u w=2u l=0.5u
X44 GROUP5_0.pmosHV_priv15_0.S vin GROUP7_0.pmosHV$1_priv1_0.S VDD sg13_hv_pmos ad=1.7p pd=10.68u as=1.7p ps=10.68u w=5u l=0.5u
X45 VSS VSS VSS VSS sg13_hv_nmos ad=0.34p pd=2.68u as=0 ps=0 w=1u l=0.5u
X46 q1 GROUP22_1.nmosHV_priv28_0.D VSS VSS sg13_hv_nmos ad=0.34p pd=2.68u as=0.34p ps=2.68u w=1u l=0.5u
X47 GROUP5_3.pmosHV_priv15_0.S vref_1 GROUP9_3.nmosHV_priv4_0.S VDD sg13_hv_pmos ad=1.7p pd=10.68u as=1.7p ps=10.68u w=5u l=0.5u
X48 GROUP21_2.nmosHV_priv25_0.S GROUP21_2.nmosHV_priv25_0.S GROUP21_2.nmosHV_priv25_0.S VSS sg13_hv_nmos ad=0.34p pd=2.68u as=0 ps=0 w=1u l=0.5u
X49 GROUP21_3.nmosHV_priv25_0.S GROUP21_3.G VSS VSS sg13_hv_nmos ad=0.34p pd=2.68u as=0.34p ps=2.68u w=1u l=0.5u
X50 vref_3 vref_2 VSS rppd l=1.28u w=2u
X51 VSS VSS VSS VSS sg13_hv_nmos ad=0.34p pd=2.68u as=0 ps=0 w=1u l=0.5u
X52 GROUP23_0.nmosHV$1_priv1_0.S VSS GROUP21_0.G VDD sg13_hv_pmos ad=0.38p pd=2.38u as=0.38p ps=2.38u w=2u l=0.5u
X53 VSS VSS VSS VSS sg13_hv_nmos ad=0.34p pd=2.68u as=0 ps=0 w=1u l=0.5u
X54 VSS VSS VSS VSS sg13_hv_nmos ad=0.34p pd=2.68u as=0 ps=0 w=1u l=0.5u
X55 GROUP23_0.nmosHV$1_priv1_0.S VSS GROUP21_2.G VDD sg13_hv_pmos ad=0.38p pd=2.38u as=0.38p ps=2.38u w=2u l=0.5u
X56 GROUP21_2.G VDD GROUP23_0.nmosHV$1_priv1_0.S VSS sg13_hv_nmos ad=0.38p pd=2.38u as=0.38p ps=2.38u w=2u l=0.5u
X57 GROUP23_0.nmosHV$1_priv1_0.S GROUP23_0.nmosHV$1_priv1_0.S GROUP23_0.nmosHV$1_priv1_0.S VDD sg13_hv_pmos ad=0.68p pd=4.68u as=46.4076p ps=0.3389m w=2u l=0.5u
X58 GROUP18_2.nmosHV_priv16_0.D GROUP18_2.nmosHV_priv16_0.D GROUP18_2.nmosHV_priv16_0.D VDDL sg13_hv_pmos ad=1.36p pd=8.68u as=24.5292p ps=0.13411m w=4u l=0.5u
X59 VSS VSS VSS VSS sg13_lv_nmos ad=0.34p pd=2.68u as=0 ps=0 w=1u l=0.13u
X60 VDD GROUP21_1.G GROUP5_2.pmosHV_priv15_0.S VDD sg13_hv_pmos ad=1.7p pd=10.68u as=1.7p ps=10.68u w=5u l=0.5u
X61 GROUP4$1_0/pmos_priv5_0.D GROUP4$1_0/pmos_priv5_0.D GROUP4$1_0/pmos_priv5_0.D VDDL sg13_lv_pmos ad=0.34p pd=2.68u as=4.34p ps=25.58u w=1u l=0.13u
X62 GROUP18_1.nmosHV_priv16_0.D q2 VSS VSS sg13_hv_nmos ad=0.34p pd=2.68u as=0.34p ps=2.68u w=1u l=0.5u
X63 GROUP23_0.nmosHV$1_priv1_0.S VSS GROUP21_0.G VDD sg13_hv_pmos ad=0.38p pd=2.38u as=0.38p ps=2.38u w=2u l=0.5u
X64 GROUP23_0.nmosHV$1_priv1_0.S GROUP23_0.nmosHV$1_priv1_0.S GROUP23_0.nmosHV$1_priv1_0.S VDD sg13_hv_pmos ad=0.68p pd=4.68u as=0 ps=0 w=2u l=0.5u
X65 GROUP21_1.nmosHV_priv25_0.S GROUP21_1.nmosHV_priv25_0.S GROUP21_1.nmosHV_priv25_0.S VSS sg13_hv_nmos ad=0.34p pd=2.68u as=45.658p ps=0.23585m w=1u l=0.5u
X66 GROUP5_2.pmosHV_priv15_0.S GROUP5_2.pmosHV_priv15_0.S GROUP5_2.pmosHV_priv15_0.S VDD sg13_hv_pmos ad=1.7p pd=10.68u as=21.6594p ps=79.74u w=5u l=0.5u
X67 GROUP23_0.nmosHV$1_priv1_0.S VSS GROUP21_3.G VDD sg13_hv_pmos ad=0.38p pd=2.38u as=0.38p ps=2.38u w=2u l=0.5u
X68 GROUP23_0.nmosHV$1_priv1_0.S VSS GROUP21_2.G VDD sg13_hv_pmos ad=0.38p pd=2.38u as=0.38p ps=2.38u w=2u l=0.5u
X69 GROUP23_0.nmosHV$1_priv1_0.S VDD GROUP21_3.G VSS sg13_hv_nmos ad=0.38p pd=2.38u as=0.38p ps=2.38u w=2u l=0.5u
X70 VDDL GROUP22_2.nmosHV_priv28_0.D GROUP16_2.pmosHV$2_priv10_0.D VDDL sg13_hv_pmos ad=1.36p pd=8.68u as=1.36p ps=8.68u w=4u l=0.5u
X71 GROUP16_2.pmosHV$2_priv10_0.D GROUP16_2.pmosHV$2_priv10_0.D GROUP16_2.pmosHV$2_priv10_0.D VDDL sg13_hv_pmos ad=1.36p pd=8.68u as=12.0396p ps=45.16u w=4u l=0.5u
X72 GROUP23_0.nmosHV$1_priv1_0.S VSS GROUP21_3.G VDD sg13_hv_pmos ad=0.38p pd=2.38u as=0.38p ps=2.38u w=2u l=0.5u
X73 GROUP15_2.pmosHV$2_priv7_0.D q0 GROUP18_2.nmosHV_priv16_0.D VDDL sg13_hv_pmos ad=1.36p pd=8.68u as=1.36p ps=8.68u w=4u l=0.5u
X74 GROUP3_0/nmos_priv6_0.D GROUP3_0/nmos_priv6_0.D GROUP3_0/nmos_priv6_0.D VSS sg13_lv_nmos ad=0.34p pd=2.68u as=0 ps=0 w=1u l=0.13u
X75 GROUP21_2.nmosHV_priv25_0.S GROUP21_2.G VSS VSS sg13_hv_nmos ad=0.34p pd=2.68u as=0.34p ps=2.68u w=1u l=0.5u
X76 GROUP5_1.pmosHV_priv15_0.S GROUP5_1.pmosHV_priv15_0.S GROUP5_1.pmosHV_priv15_0.S VDD sg13_hv_pmos ad=1.7p pd=10.68u as=21.6594p ps=79.74u w=5u l=0.5u
X77 GROUP9_3.nmosHV_priv4_0.S GROUP9_3.nmosHV_priv4_0.S GROUP9_3.nmosHV_priv4_0.S VSS sg13_hv_nmos ad=0.34p pd=2.68u as=0 ps=0 w=1u l=0.5u
X78 GROUP21_1.G GROUP21_1.G GROUP21_1.G VDD sg13_hv_pmos ad=0.68p pd=4.68u as=71.9421p ps=0.3071m w=2u l=0.5u
X79 VSS VSS VSS VSS sg13_hv_nmos ad=0.34p pd=2.68u as=0 ps=0 w=1u l=0.5u
X80 GROUP21_1.G VSS GROUP23_0.nmosHV$1_priv1_0.S VDD sg13_hv_pmos ad=0.38p pd=2.38u as=0.38p ps=2.38u w=2u l=0.5u
X81 GROUP9_3.nmosHV_priv4_0.S GROUP21_2.G VSS VSS sg13_hv_nmos ad=0.34p pd=2.68u as=0.34p ps=2.68u w=1u l=0.5u
X82 VSS VSS VSS VSS sg13_hv_nmos ad=0.34p pd=2.68u as=0 ps=0 w=1u l=0.5u
X83 GROUP23_0.nmosHV$1_priv1_0.S VDD GROUP21_0.G VSS sg13_hv_nmos ad=0.38p pd=2.38u as=0.68p ps=4.68u w=2u l=0.5u
X84 GROUP21_3.nmosHV_priv25_0.S GROUP22_3.nmosHV_priv28_0.D VSS VSS sg13_hv_nmos ad=0.34p pd=2.68u as=0.34p ps=2.68u w=1u l=0.5u
X85 GROUP16_1.pmosHV$2_priv10_0.D GROUP16_1.pmosHV$2_priv10_0.D GROUP16_1.pmosHV$2_priv10_0.D VDDL sg13_hv_pmos ad=1.36p pd=8.68u as=12.0396p ps=45.16u w=4u l=0.5u
X86 GROUP18_3.nmosHV_priv16_0.D GROUP18_3.nmosHV_priv16_0.D GROUP18_3.nmosHV_priv16_0.D VDDL sg13_hv_pmos ad=1.36p pd=8.68u as=24.5292p ps=0.13411m w=4u l=0.5u
X87 GROUP18_0.nmosHV_priv16_0.D GROUP18_0.nmosHV_priv16_0.D GROUP18_0.nmosHV_priv16_0.D VSS sg13_hv_nmos ad=0.34p pd=2.68u as=24.5292p ps=0.13411m w=1u l=0.5u
X88 GROUP23_0.nmosHV$1_priv1_0.S VDD GROUP21_1.G VSS sg13_hv_nmos ad=0.38p pd=2.38u as=0.38p ps=2.38u w=2u l=0.5u
X89 GROUP23_0.nmosHV$1_priv1_0.S GROUP23_0.nmosHV$1_priv1_0.S GROUP23_0.nmosHV$1_priv1_0.S VSS sg13_hv_nmos ad=0.68p pd=4.68u as=0 ps=0 w=2u l=0.5u
X90 GROUP23_0.nmosHV$1_priv1_0.S VDD GROUP21_2.G VSS sg13_hv_nmos ad=0.38p pd=2.38u as=0.38p ps=2.38u w=2u l=0.5u
X91 VSS VSS VSS VSS sg13_hv_nmos ad=0.34p pd=2.68u as=0 ps=0 w=1u l=0.5u
X92 VDDL VDDL VDDL VDDL sg13_hv_pmos ad=1.36p pd=8.68u as=0 ps=0 w=4u l=0.5u
X93 GROUP21_3.G GROUP21_3.G GROUP21_3.G VSS sg13_hv_nmos ad=0.68p pd=4.68u as=71.9421p ps=0.3071m w=2u l=0.5u
X94 GROUP5_2.pmosHV_priv15_0.S GROUP5_2.pmosHV_priv15_0.S GROUP5_2.pmosHV_priv15_0.S VDD sg13_hv_pmos ad=1.7p pd=10.68u as=0 ps=0 w=5u l=0.5u
X95 GROUP18_0.nmosHV_priv16_0.D GROUP18_0.nmosHV_priv16_0.D GROUP18_0.nmosHV_priv16_0.D VDDL sg13_hv_pmos ad=1.36p pd=8.68u as=0 ps=0 w=4u l=0.5u
X96 GROUP7$1_0/nmosHV$1_priv1$1_0.D pmosHV_priv2_0.D VDD VDD sg13_hv_pmos ad=1.02p pd=6.68u as=1.02p ps=6.68u w=3u l=0.5u
X97 VSS VSS VSS VSS sg13_hv_nmos ad=0.34p pd=2.68u as=0 ps=0 w=1u l=0.5u
X98 GROUP21_3.nmosHV_priv25_0.S GROUP21_3.nmosHV_priv25_0.S GROUP21_3.nmosHV_priv25_0.S VSS sg13_hv_nmos ad=0.34p pd=2.68u as=45.658p ps=0.23585m w=1u l=0.5u
X99 GROUP23_0.nmosHV$1_priv1_0.S VDD GROUP21_2.G VSS sg13_hv_nmos ad=0.38p pd=2.38u as=0.38p ps=2.38u w=2u l=0.5u
X100 GROUP15_3.pmosHV$2_priv7_0.D q1 GROUP18_3.nmosHV_priv16_0.D VDDL sg13_hv_pmos ad=1.36p pd=8.68u as=1.36p ps=8.68u w=4u l=0.5u
X101 GROUP21_0.G GROUP21_0.G GROUP21_0.G VDD sg13_hv_pmos ad=0.68p pd=4.68u as=71.9421p ps=0.3071m w=2u l=0.5u
X102 GROUP21_0.G VSS GROUP23_0.nmosHV$1_priv1_0.S VDD sg13_hv_pmos ad=0.38p pd=2.38u as=0.38p ps=2.38u w=2u l=0.5u
X103 GROUP21_3.G VDD GROUP23_0.nmosHV$1_priv1_0.S VSS sg13_hv_nmos ad=0.38p pd=2.38u as=0.38p ps=2.38u w=2u l=0.5u
X104 q1 q1 q1 VSS sg13_hv_nmos ad=0.34p pd=2.68u as=0 ps=0 w=1u l=0.5u
X105 GROUP5_0.pmosHV_priv15_0.S GROUP5_0.pmosHV_priv15_0.S GROUP5_0.pmosHV_priv15_0.S VDD sg13_hv_pmos ad=1.7p pd=10.68u as=21.6594p ps=79.74u w=5u l=0.5u
X106 GROUP21_1.G GROUP21_1.G GROUP21_1.G VSS sg13_hv_nmos ad=0.68p pd=4.68u as=0 ps=0 w=2u l=0.5u
X107 GROUP21_2.G VSS GROUP23_0.nmosHV$1_priv1_0.S VDD sg13_hv_pmos ad=0.38p pd=2.38u as=0.38p ps=2.38u w=2u l=0.5u
X108 GROUP15_0.pmosHV$2_priv7_0.D q3 GROUP18_0.nmosHV_priv16_0.D VDDL sg13_hv_pmos ad=1.36p pd=8.68u as=1.36p ps=8.68u w=4u l=0.5u
X109 GROUP18_0.nmosHV_priv16_0.D GROUP21_3.nmosHV_priv25_0.S VSS VSS sg13_hv_nmos ad=0.34p pd=2.68u as=0.34p ps=2.68u w=1u l=0.5u
X110 GROUP21_3.G VDD GROUP23_0.nmosHV$1_priv1_0.S VSS sg13_hv_nmos ad=0.68p pd=4.68u as=0.38p ps=2.38u w=2u l=0.5u
X111 VDDL GROUP22_3.nmosHV_priv28_0.D GROUP16_0.pmosHV$2_priv10_0.D VDDL sg13_hv_pmos ad=1.36p pd=8.68u as=1.36p ps=8.68u w=4u l=0.5u
X112 q1 q1 q1 VDDL sg13_hv_pmos ad=1.36p pd=8.68u as=0 ps=0 w=4u l=0.5u
X113 GROUP7$1_0/nmosHV$1_priv1$1_0.D GROUP7$1_0/nmosHV$1_priv1$1_0.D GROUP7$1_0/nmosHV$1_priv1$1_0.D VSS sg13_hv_nmos ad=0.34p pd=2.68u as=0 ps=0 w=1u l=0.5u
X114 GROUP21_3.G VSS GROUP23_0.nmosHV$1_priv1_0.S VDD sg13_hv_pmos ad=0.38p pd=2.38u as=0.38p ps=2.38u w=2u l=0.5u
X115 GROUP21_2.G VSS GROUP23_0.nmosHV$1_priv1_0.S VDD sg13_hv_pmos ad=0.38p pd=2.38u as=0.38p ps=2.38u w=2u l=0.5u
X116 GROUP16_0.pmosHV$2_priv10_0.D GROUP16_0.pmosHV$2_priv10_0.D GROUP16_0.pmosHV$2_priv10_0.D VDDL sg13_hv_pmos ad=1.36p pd=8.68u as=12.0396p ps=45.16u w=4u l=0.5u
X117 VSS VSS VSS VSS sg13_hv_nmos ad=0.34p pd=2.68u as=0 ps=0 w=1u l=0.5u
X118 GROUP7_3.pmosHV$1_priv1_0.S GROUP7_3.pmosHV$1_priv1_0.S GROUP7_3.pmosHV$1_priv1_0.S VSS sg13_hv_nmos ad=0.34p pd=2.68u as=13.2594p ps=51.74u w=1u l=0.5u
X119 GROUP7_3.pmosHV$1_priv1_0.S GROUP21_2.G VSS VSS sg13_hv_nmos ad=0.34p pd=2.68u as=0.34p ps=2.68u w=1u l=0.5u
X120 GROUP22_0.nmosHV_priv28_0.D GROUP21_0.nmosHV_priv25_0.S VSS VSS sg13_hv_nmos ad=0.34p pd=2.68u as=0.34p ps=2.68u w=1u l=0.5u
X121 GROUP21_1.G VDD GROUP23_0.nmosHV$1_priv1_0.S VSS sg13_hv_nmos ad=0.38p pd=2.38u as=0.38p ps=2.38u w=2u l=0.5u
X122 GROUP21_3.G VSS GROUP23_0.nmosHV$1_priv1_0.S VDD sg13_hv_pmos ad=0.38p pd=2.38u as=0.38p ps=2.38u w=2u l=0.5u
X123 GROUP9_0.nmosHV_priv4_0.S GROUP9_0.nmosHV_priv4_0.S GROUP9_0.nmosHV_priv4_0.S VSS sg13_hv_nmos ad=0.34p pd=2.68u as=13.2594p ps=51.74u w=1u l=0.5u
X124 VDD GROUP21_0.G GROUP5_1.pmosHV_priv15_0.S VDD sg13_hv_pmos ad=1.7p pd=10.68u as=1.7p ps=10.68u w=5u l=0.5u
X125 GROUP9_0.nmosHV_priv4_0.S GROUP21_3.G VSS VSS sg13_hv_nmos ad=0.34p pd=2.68u as=0.34p ps=2.68u w=1u l=0.5u
X126 GROUP16_3.pmosHV$2_priv10_0.D GROUP18_3.nmosHV_priv16_0.D q1 VDDL sg13_hv_pmos ad=1.36p pd=8.68u as=1.36p ps=8.68u w=4u l=0.5u
X127 GROUP5_1.pmosHV_priv15_0.S GROUP5_1.pmosHV_priv15_0.S GROUP5_1.pmosHV_priv15_0.S VDD sg13_hv_pmos ad=1.7p pd=10.68u as=0 ps=0 w=5u l=0.5u
X128 q1 GROUP18_3.nmosHV_priv16_0.D VSS VSS sg13_hv_nmos ad=0.34p pd=2.68u as=0.34p ps=2.68u w=1u l=0.5u
X129 GROUP7_3.pmosHV$1_priv1_0.S GROUP21_2.nmosHV_priv25_0.S GROUP22_2.nmosHV_priv28_0.D VDD sg13_hv_pmos ad=0.68p pd=4.68u as=0.68p ps=4.68u w=2u l=0.5u
X130 GROUP9_3.nmosHV_priv4_0.S GROUP22_2.nmosHV_priv28_0.D GROUP21_2.nmosHV_priv25_0.S VDD sg13_hv_pmos ad=0.68p pd=4.68u as=0.68p ps=4.68u w=2u l=0.5u
X131 GROUP21_1.G VDD GROUP23_0.nmosHV$1_priv1_0.S VSS sg13_hv_nmos ad=0.68p pd=4.68u as=0.38p ps=2.38u w=2u l=0.5u
X132 GROUP21_1.nmosHV_priv25_0.S GROUP21_1.G VSS VSS sg13_hv_nmos ad=0.34p pd=2.68u as=0.34p ps=2.68u w=1u l=0.5u
X133 GROUP22_3.nmosHV_priv28_0.D GROUP22_3.nmosHV_priv28_0.D GROUP22_3.nmosHV_priv28_0.D VSS sg13_hv_nmos ad=0.34p pd=2.68u as=45.5261p ps=0.23483m w=1u l=0.5u
X134 GROUP22_0.nmosHV_priv28_0.D GROUP22_0.nmosHV_priv28_0.D GROUP22_0.nmosHV_priv28_0.D VSS sg13_hv_nmos ad=0.34p pd=2.68u as=0 ps=0 w=1u l=0.5u
X135 GROUP21_0.G VDD GROUP23_0.nmosHV$1_priv1_0.S VSS sg13_hv_nmos ad=0.38p pd=2.38u as=0.38p ps=2.38u w=2u l=0.5u
X136 GROUP21_2.G VDD GROUP23_0.nmosHV$1_priv1_0.S VSS sg13_hv_nmos ad=0.38p pd=2.38u as=0.38p ps=2.38u w=2u l=0.5u
X137 VDDL VDDL VDDL VDDL sg13_hv_pmos ad=1.36p pd=8.68u as=0 ps=0 w=4u l=0.5u
X138 GROUP15_1.pmosHV$2_priv7_0.D GROUP15_1.pmosHV$2_priv7_0.D GROUP15_1.pmosHV$2_priv7_0.D VDDL sg13_hv_pmos ad=1.36p pd=8.68u as=12.0396p ps=45.16u w=4u l=0.5u
X139 GROUP7_3.pmosHV$1_priv1_0.S GROUP7_3.pmosHV$1_priv1_0.S GROUP7_3.pmosHV$1_priv1_0.S VDD sg13_hv_pmos ad=0.68p pd=4.68u as=0 ps=0 w=2u l=0.5u
X140 VSS VSS VSS VSS sg13_hv_nmos ad=0.34p pd=2.68u as=0 ps=0 w=1u l=0.5u
X141 GROUP23_0.nmosHV$1_priv1_0.S VDD GROUP21_3.G VSS sg13_hv_nmos ad=0.38p pd=2.38u as=0.38p ps=2.38u w=2u l=0.5u
X142 GROUP9_3.nmosHV_priv4_0.S GROUP9_3.nmosHV_priv4_0.S GROUP9_3.nmosHV_priv4_0.S VDD sg13_hv_pmos ad=0.68p pd=4.68u as=0 ps=0 w=2u l=0.5u
X143 GROUP21_2.G VDD GROUP23_0.nmosHV$1_priv1_0.S VSS sg13_hv_nmos ad=0.38p pd=2.38u as=0.38p ps=2.38u w=2u l=0.5u
X144 GROUP23_0.nmosHV$1_priv1_0.S VSS GROUP21_2.G VDD sg13_hv_pmos ad=0.38p pd=2.38u as=0.38p ps=2.38u w=2u l=0.5u
X145 VDD VDD VDD VDD sg13_hv_pmos ad=1.7p pd=10.68u as=0 ps=0 w=5u l=0.5u
X146 GROUP22_2.nmosHV_priv28_0.D GROUP22_2.nmosHV_priv28_0.D GROUP22_2.nmosHV_priv28_0.D VDD sg13_hv_pmos ad=0.68p pd=4.68u as=45.5261p ps=0.23483m w=2u l=0.5u
X147 GROUP21_2.nmosHV_priv25_0.S GROUP21_2.nmosHV_priv25_0.S GROUP21_2.nmosHV_priv25_0.S VDD sg13_hv_pmos ad=0.68p pd=4.68u as=0 ps=0 w=2u l=0.5u
X148 GROUP23_0.nmosHV$1_priv1_0.S VDD GROUP21_3.G VSS sg13_hv_nmos ad=0.38p pd=2.38u as=0.38p ps=2.38u w=2u l=0.5u
X149 GROUP23_0.nmosHV$1_priv1_0.S VSS GROUP21_3.G VDD sg13_hv_pmos ad=0.38p pd=2.38u as=0.38p ps=2.38u w=2u l=0.5u
X150 GROUP7_2.pmosHV$1_priv1_0.S GROUP21_1.nmosHV_priv25_0.S GROUP22_1.nmosHV_priv28_0.D VDD sg13_hv_pmos ad=0.68p pd=4.68u as=0.68p ps=4.68u w=2u l=0.5u
X151 GROUP23_0.nmosHV$1_priv1_0.S VSS GROUP21_2.G VDD sg13_hv_pmos ad=0.38p pd=2.38u as=0.68p ps=4.68u w=2u l=0.5u
X152 GROUP23_0.nmosHV$1_priv1_0.S VDD GROUP21_1.G VSS sg13_hv_nmos ad=0.38p pd=2.38u as=0.38p ps=2.38u w=2u l=0.5u
X153 GROUP23_0.nmosHV$1_priv1_0.S VSS GROUP21_3.G VDD sg13_hv_pmos ad=0.38p pd=2.38u as=0.68p ps=4.68u w=2u l=0.5u
X154 GROUP7_0.pmosHV$1_priv1_0.S GROUP7_0.pmosHV$1_priv1_0.S GROUP7_0.pmosHV$1_priv1_0.S VSS sg13_hv_nmos ad=0.34p pd=2.68u as=0 ps=0 w=1u l=0.5u
X155 VDDL VDDL VDDL VDDL sg13_hv_pmos ad=1.36p pd=8.68u as=0 ps=0 w=4u l=0.5u
X156 VDDL GROUP21_2.nmosHV_priv25_0.S GROUP15_2.pmosHV$2_priv7_0.D VDDL sg13_hv_pmos ad=1.36p pd=8.68u as=1.36p ps=8.68u w=4u l=0.5u
X157 GROUP18_2.nmosHV_priv16_0.D GROUP18_2.nmosHV_priv16_0.D GROUP18_2.nmosHV_priv16_0.D VSS sg13_hv_nmos ad=0.34p pd=2.68u as=0 ps=0 w=1u l=0.5u
X158 GROUP7_0.pmosHV$1_priv1_0.S GROUP21_3.nmosHV_priv25_0.S GROUP22_3.nmosHV_priv28_0.D VDD sg13_hv_pmos ad=0.68p pd=4.68u as=0.68p ps=4.68u w=2u l=0.5u
X159 GROUP7_0.pmosHV$1_priv1_0.S GROUP21_3.G VSS VSS sg13_hv_nmos ad=0.34p pd=2.68u as=0.34p ps=2.68u w=1u l=0.5u
X160 GROUP15_2.pmosHV$2_priv7_0.D GROUP15_2.pmosHV$2_priv7_0.D GROUP15_2.pmosHV$2_priv7_0.D VDDL sg13_hv_pmos ad=1.36p pd=8.68u as=12.0396p ps=45.16u w=4u l=0.5u
X161 GROUP22_0.nmosHV_priv28_0.D GROUP21_0.G VSS VSS sg13_hv_nmos ad=0.34p pd=2.68u as=0.34p ps=2.68u w=1u l=0.5u
X162 q2 q2 q2 VSS sg13_hv_nmos ad=0.34p pd=2.68u as=24.1098p ps=0.13178m w=1u l=0.5u
X163 GROUP7_2.pmosHV$1_priv1_0.S GROUP7_2.pmosHV$1_priv1_0.S GROUP7_2.pmosHV$1_priv1_0.S VDD sg13_hv_pmos ad=0.68p pd=4.68u as=0 ps=0 w=2u l=0.5u
X164 GROUP23_0.nmosHV$1_priv1_0.S VDD GROUP21_1.G VSS sg13_hv_nmos ad=0.38p pd=2.38u as=0.38p ps=2.38u w=2u l=0.5u
X165 GROUP7_1.pmosHV$1_priv1_0.S GROUP7_1.pmosHV$1_priv1_0.S GROUP7_1.pmosHV$1_priv1_0.S VDD sg13_hv_pmos ad=1.7p pd=10.68u as=13.2594p ps=51.74u w=5u l=0.5u
X166 VSS VSS VSS VSS sg13_hv_nmos ad=0.34p pd=2.68u as=0 ps=0 w=1u l=0.5u
X167 GROUP21_1.G VSS GROUP23_0.nmosHV$1_priv1_0.S VDD sg13_hv_pmos ad=0.38p pd=2.38u as=0.38p ps=2.38u w=2u l=0.5u
X168 GROUP22_2.nmosHV_priv28_0.D GROUP22_2.nmosHV_priv28_0.D GROUP22_2.nmosHV_priv28_0.D VSS sg13_hv_nmos ad=0.34p pd=2.68u as=0 ps=0 w=1u l=0.5u
X169 q2 q2 q2 VSS sg13_hv_nmos ad=0.34p pd=2.68u as=0 ps=0 w=1u l=0.5u
X170 GROUP9_0.nmosHV_priv4_0.S GROUP22_3.nmosHV_priv28_0.D GROUP21_3.nmosHV_priv25_0.S VDD sg13_hv_pmos ad=0.68p pd=4.68u as=0.68p ps=4.68u w=2u l=0.5u
X171 GROUP23_0.nmosHV$1_priv1_0.S VDD GROUP21_0.G VSS sg13_hv_nmos ad=0.38p pd=2.38u as=0.38p ps=2.38u w=2u l=0.5u
X172 q2 q2 q2 VDDL sg13_hv_pmos ad=1.36p pd=8.68u as=0 ps=0 w=4u l=0.5u
X173 VSS VSS VSS VSS sg13_hv_nmos ad=0.34p pd=2.68u as=0 ps=0 w=1u l=0.5u
X174 VDDL VDDL VDDL VDDL sg13_hv_pmos ad=1.36p pd=8.68u as=0 ps=0 w=4u l=0.5u
X175 VDDL VDDL VDDL VDDL sg13_lv_pmos ad=0.34p pd=2.68u as=0 ps=0 w=1u l=0.13u
X176 VSS VSS VSS VSS sg13_hv_nmos ad=0.34p pd=2.68u as=0 ps=0 w=1u l=0.5u
X177 GROUP7_0.pmosHV$1_priv1_0.S GROUP7_0.pmosHV$1_priv1_0.S GROUP7_0.pmosHV$1_priv1_0.S VDD sg13_hv_pmos ad=0.68p pd=4.68u as=0 ps=0 w=2u l=0.5u
X178 GROUP22_1.nmosHV_priv28_0.D GROUP22_1.nmosHV_priv28_0.D GROUP22_1.nmosHV_priv28_0.D VDD sg13_hv_pmos ad=0.68p pd=4.68u as=45.5261p ps=0.23483m w=2u l=0.5u
X179 GROUP21_2.G VSS GROUP23_0.nmosHV$1_priv1_0.S VDD sg13_hv_pmos ad=0.38p pd=2.38u as=0.38p ps=2.38u w=2u l=0.5u
X180 GROUP23_0.nmosHV$1_priv1_0.S VDD GROUP21_2.G VSS sg13_hv_nmos ad=0.38p pd=2.38u as=0.68p ps=4.68u w=2u l=0.5u
X181 VDD VDD VDD VDD sg13_hv_pmos ad=1.02p pd=6.68u as=0 ps=0 w=3u l=0.5u
X182 VSS VSS VSS VSS sg13_hv_nmos ad=0.34p pd=2.68u as=0 ps=0 w=1u l=0.5u
X183 GROUP5_1.pmosHV_priv15_0.S vin GROUP7_1.pmosHV$1_priv1_0.S VDD sg13_hv_pmos ad=1.7p pd=10.68u as=1.7p ps=10.68u w=5u l=0.5u
X184 GROUP9_2.nmosHV_priv4_0.S GROUP9_2.nmosHV_priv4_0.S GROUP9_2.nmosHV_priv4_0.S VDD sg13_hv_pmos ad=1.7p pd=10.68u as=13.2594p ps=51.74u w=5u l=0.5u
X185 GROUP9_0.nmosHV_priv4_0.S GROUP9_0.nmosHV_priv4_0.S GROUP9_0.nmosHV_priv4_0.S VDD sg13_hv_pmos ad=0.68p pd=4.68u as=0 ps=0 w=2u l=0.5u
X186 GROUP21_1.nmosHV_priv25_0.S GROUP22_1.nmosHV_priv28_0.D VSS VSS sg13_hv_nmos ad=0.34p pd=2.68u as=0.34p ps=2.68u w=1u l=0.5u
X187 VSS VSS VSS VSS sg13_hv_nmos ad=0.34p pd=2.68u as=0 ps=0 w=1u l=0.5u
X188 VDDL GROUP21_1.nmosHV_priv25_0.S GROUP15_3.pmosHV$2_priv7_0.D VDDL sg13_hv_pmos ad=1.36p pd=8.68u as=1.36p ps=8.68u w=4u l=0.5u
X189 GROUP16_1.pmosHV$2_priv10_0.D GROUP18_1.nmosHV_priv16_0.D q2 VDDL sg13_hv_pmos ad=1.36p pd=8.68u as=1.36p ps=8.68u w=4u l=0.5u
X190 GROUP18_2.nmosHV_priv16_0.D GROUP21_2.nmosHV_priv25_0.S VSS VSS sg13_hv_nmos ad=0.34p pd=2.68u as=0.34p ps=2.68u w=1u l=0.5u
X191 GROUP18_3.nmosHV_priv16_0.D GROUP18_3.nmosHV_priv16_0.D GROUP18_3.nmosHV_priv16_0.D VSS sg13_hv_nmos ad=0.34p pd=2.68u as=0 ps=0 w=1u l=0.5u
X192 GROUP22_3.nmosHV_priv28_0.D GROUP22_3.nmosHV_priv28_0.D GROUP22_3.nmosHV_priv28_0.D VDD sg13_hv_pmos ad=0.68p pd=4.68u as=0 ps=0 w=2u l=0.5u
X193 GROUP21_3.G VSS GROUP23_0.nmosHV$1_priv1_0.S VDD sg13_hv_pmos ad=0.38p pd=2.38u as=0.38p ps=2.38u w=2u l=0.5u
X194 GROUP21_3.G VDD GROUP23_0.nmosHV$1_priv1_0.S VSS sg13_hv_nmos ad=0.38p pd=2.38u as=0.38p ps=2.38u w=2u l=0.5u
X195 GROUP15_3.pmosHV$2_priv7_0.D GROUP15_3.pmosHV$2_priv7_0.D GROUP15_3.pmosHV$2_priv7_0.D VDDL sg13_hv_pmos ad=1.36p pd=8.68u as=12.0396p ps=45.16u w=4u l=0.5u
X196 GROUP23_0.nmosHV$1_priv1_0.S GROUP23_0.nmosHV$1_priv1_0.S GROUP23_0.nmosHV$1_priv1_0.S VSS sg13_hv_nmos ad=0.68p pd=4.68u as=0 ps=0 w=2u l=0.5u
X197 VSS VSS VSS VSS sg13_hv_nmos ad=0.34p pd=2.68u as=0 ps=0 w=1u l=0.5u
X198 q2 GROUP18_1.nmosHV_priv16_0.D VSS VSS sg13_hv_nmos ad=0.34p pd=2.68u as=0.34p ps=2.68u w=1u l=0.5u
X199 GROUP21_2.G VSS GROUP23_0.nmosHV$1_priv1_0.S VDD sg13_hv_pmos ad=0.68p pd=4.68u as=0.38p ps=2.38u w=2u l=0.5u
X200 VDDL VDDL VDDL VDDL sg13_hv_pmos ad=1.36p pd=8.68u as=0 ps=0 w=4u l=0.5u
X201 VDD vref_4 VSS rhigh l=42u w=2u
X202 VDD VDD VDD VDD sg13_hv_pmos ad=1.7p pd=10.68u as=0 ps=0 w=5u l=0.5u
X203 GROUP21_0.G GROUP21_0.G GROUP21_0.G VSS sg13_hv_nmos ad=0.68p pd=4.68u as=0 ps=0 w=2u l=0.5u
X204 q2 GROUP22_0.nmosHV_priv28_0.D VSS VSS sg13_hv_nmos ad=0.34p pd=2.68u as=0.34p ps=2.68u w=1u l=0.5u
X205 GROUP9_0.nmosHV_priv4_0.S GROUP9_0.nmosHV_priv4_0.S GROUP9_0.nmosHV_priv4_0.S VDD sg13_hv_pmos ad=1.7p pd=10.68u as=0 ps=0 w=5u l=0.5u
X206 GROUP21_3.nmosHV_priv25_0.S GROUP21_3.nmosHV_priv25_0.S GROUP21_3.nmosHV_priv25_0.S VDD sg13_hv_pmos ad=0.68p pd=4.68u as=0 ps=0 w=2u l=0.5u
X207 GROUP21_1.nmosHV_priv25_0.S GROUP21_1.nmosHV_priv25_0.S GROUP21_1.nmosHV_priv25_0.S VSS sg13_hv_nmos ad=0.34p pd=2.68u as=0 ps=0 w=1u l=0.5u
X208 GROUP21_0.G VSS GROUP23_0.nmosHV$1_priv1_0.S VDD sg13_hv_pmos ad=0.38p pd=2.38u as=0.38p ps=2.38u w=2u l=0.5u
X209 VDDL GROUP21_3.nmosHV_priv25_0.S GROUP15_0.pmosHV$2_priv7_0.D VDDL sg13_hv_pmos ad=1.36p pd=8.68u as=1.36p ps=8.68u w=4u l=0.5u
X210 GROUP4$1_0/pmos_priv5_0.D GROUP4$1_0/pmos_priv5_0.D GROUP4$1_0/pmos_priv5_0.D VSS sg13_lv_nmos ad=0.34p pd=2.68u as=0 ps=0 w=1u l=0.13u
X211 VSS VSS VSS VSS sg13_hv_nmos ad=0.34p pd=2.68u as=0 ps=0 w=1u l=0.5u
X212 GROUP5_2.pmosHV_priv15_0.S vref_2 GROUP9_2.nmosHV_priv4_0.S VDD sg13_hv_pmos ad=1.7p pd=10.68u as=1.7p ps=10.68u w=5u l=0.5u
X213 GROUP21_3.G VSS GROUP23_0.nmosHV$1_priv1_0.S VDD sg13_hv_pmos ad=0.68p pd=4.68u as=0.38p ps=2.38u w=2u l=0.5u
X214 VDDL VDDL VDDL VDDL sg13_lv_pmos ad=0.34p pd=2.68u as=0 ps=0 w=1u l=0.13u
X215 GROUP15_0.pmosHV$2_priv7_0.D GROUP15_0.pmosHV$2_priv7_0.D GROUP15_0.pmosHV$2_priv7_0.D VDDL sg13_hv_pmos ad=1.36p pd=8.68u as=12.0396p ps=45.16u w=4u l=0.5u
X216 GROUP18_2.nmosHV_priv16_0.D GROUP18_2.nmosHV_priv16_0.D GROUP18_2.nmosHV_priv16_0.D VSS sg13_hv_nmos ad=0.34p pd=2.68u as=0 ps=0 w=1u l=0.5u
X217 VSS VSS VSS VSS sg13_hv_nmos ad=0.34p pd=2.68u as=0 ps=0 w=1u l=0.5u
X218 GROUP23_0.nmosHV$1_priv1_0.S VSS GROUP21_1.G VDD sg13_hv_pmos ad=0.38p pd=2.38u as=0.38p ps=2.38u w=2u l=0.5u
X219 GROUP21_1.G VDD GROUP23_0.nmosHV$1_priv1_0.S VSS sg13_hv_nmos ad=0.38p pd=2.38u as=0.38p ps=2.38u w=2u l=0.5u
X220 GROUP23_0.nmosHV$1_priv1_0.S GROUP23_0.nmosHV$1_priv1_0.S GROUP23_0.nmosHV$1_priv1_0.S VDD sg13_hv_pmos ad=0.68p pd=4.68u as=0 ps=0 w=2u l=0.5u
X221 a_18054_n6587# clk VSS rppd l=10u w=2u
X222 GROUP5_0.pmosHV_priv15_0.S vref_4 GROUP9_0.nmosHV_priv4_0.S VDD sg13_hv_pmos ad=1.7p pd=10.68u as=1.7p ps=10.68u w=5u l=0.5u
X223 GROUP21_0.G VDD GROUP23_0.nmosHV$1_priv1_0.S VSS sg13_hv_nmos ad=0.38p pd=2.38u as=0.38p ps=2.38u w=2u l=0.5u
X224 GROUP16_2.pmosHV$2_priv10_0.D GROUP16_2.pmosHV$2_priv10_0.D GROUP16_2.pmosHV$2_priv10_0.D VDDL sg13_hv_pmos ad=1.36p pd=8.68u as=0 ps=0 w=4u l=0.5u
X225 GROUP18_3.nmosHV_priv16_0.D GROUP21_1.nmosHV_priv25_0.S VSS VSS sg13_hv_nmos ad=0.34p pd=2.68u as=0.34p ps=2.68u w=1u l=0.5u
X226 VSS VSS VSS VSS sg13_hv_nmos ad=0.34p pd=2.68u as=0 ps=0 w=1u l=0.5u
X227 GROUP21_0.nmosHV_priv25_0.S GROUP21_0.nmosHV_priv25_0.S GROUP21_0.nmosHV_priv25_0.S VSS sg13_hv_nmos ad=0.34p pd=2.68u as=0 ps=0 w=1u l=0.5u
X228 GROUP23_0.nmosHV$1_priv1_0.S VSS GROUP21_1.G VDD sg13_hv_pmos ad=0.38p pd=2.38u as=0.38p ps=2.38u w=2u l=0.5u
X229 VDDL GROUP22_1.nmosHV_priv28_0.D GROUP16_3.pmosHV$2_priv10_0.D VDDL sg13_hv_pmos ad=1.36p pd=8.68u as=1.36p ps=8.68u w=4u l=0.5u
X230 GROUP3_0/nmos_priv6_0.D a_18054_n6587# VDDL VDDL sg13_lv_pmos ad=0.34p pd=2.68u as=0.34p ps=2.68u w=1u l=0.13u
X231 VSS VSS VSS VSS sg13_hv_nmos ad=0.34p pd=2.68u as=0 ps=0 w=1u l=0.5u
X232 GROUP21_0.G VDD GROUP23_0.nmosHV$1_priv1_0.S VSS sg13_hv_nmos ad=0.68p pd=4.68u as=0.38p ps=2.38u w=2u l=0.5u
X233 GROUP23_0.nmosHV$1_priv1_0.S VDD GROUP21_3.G VSS sg13_hv_nmos ad=0.38p pd=2.38u as=0.38p ps=2.38u w=2u l=0.5u
X234 GROUP16_3.pmosHV$2_priv10_0.D GROUP16_3.pmosHV$2_priv10_0.D GROUP16_3.pmosHV$2_priv10_0.D VDDL sg13_hv_pmos ad=1.36p pd=8.68u as=0 ps=0 w=4u l=0.5u
X235 GROUP23_0.nmosHV$1_priv1_0.S VSS GROUP21_2.G VDD sg13_hv_pmos ad=0.38p pd=2.38u as=0.38p ps=2.38u w=2u l=0.5u
X236 GROUP9_2.nmosHV_priv4_0.S GROUP9_2.nmosHV_priv4_0.S GROUP9_2.nmosHV_priv4_0.S VSS sg13_hv_nmos ad=0.34p pd=2.68u as=0 ps=0 w=1u l=0.5u
X237 GROUP23_0.nmosHV$1_priv1_0.S VDD GROUP21_3.G VSS sg13_hv_nmos ad=0.38p pd=2.38u as=0.38p ps=2.38u w=2u l=0.5u
X238 VSS VSS VSS VSS sg13_hv_nmos ad=0.34p pd=2.68u as=0 ps=0 w=1u l=0.5u
X239 GROUP23_0.nmosHV$1_priv1_0.S VSS GROUP21_3.G VDD sg13_hv_pmos ad=0.38p pd=2.38u as=0.38p ps=2.38u w=2u l=0.5u
X240 GROUP9_2.nmosHV_priv4_0.S GROUP21_1.G VSS VSS sg13_hv_nmos ad=0.34p pd=2.68u as=0.34p ps=2.68u w=1u l=0.5u
X241 GROUP18_2.nmosHV_priv16_0.D q0 VSS VSS sg13_hv_nmos ad=0.34p pd=2.68u as=0.34p ps=2.68u w=1u l=0.5u
X242 GROUP23_0.nmosHV$1_priv1_0.S VSS GROUP21_0.G VDD sg13_hv_pmos ad=0.38p pd=2.38u as=0.38p ps=2.38u w=2u l=0.5u
X243 GROUP23_0.nmosHV$1_priv1_0.S VSS GROUP21_2.G VDD sg13_hv_pmos ad=0.38p pd=2.38u as=0.38p ps=2.38u w=2u l=0.5u
X244 GROUP23_0.nmosHV$1_priv1_0.S GROUP23_0.nmosHV$1_priv1_0.S GROUP23_0.nmosHV$1_priv1_0.S VDD sg13_hv_pmos ad=0.68p pd=4.68u as=0 ps=0 w=2u l=0.5u
X245 GROUP18_1.nmosHV_priv16_0.D GROUP18_1.nmosHV_priv16_0.D GROUP18_1.nmosHV_priv16_0.D VDDL sg13_hv_pmos ad=1.36p pd=8.68u as=0 ps=0 w=4u l=0.5u
X246 GROUP22_3.nmosHV_priv28_0.D GROUP21_3.G VSS VSS sg13_hv_nmos ad=0.34p pd=2.68u as=0.34p ps=2.68u w=1u l=0.5u
X247 GROUP18_3.nmosHV_priv16_0.D GROUP18_3.nmosHV_priv16_0.D GROUP18_3.nmosHV_priv16_0.D VSS sg13_hv_nmos ad=0.34p pd=2.68u as=0 ps=0 w=1u l=0.5u
X248 GROUP22_1.nmosHV_priv28_0.D GROUP22_1.nmosHV_priv28_0.D GROUP22_1.nmosHV_priv28_0.D VSS sg13_hv_nmos ad=0.34p pd=2.68u as=0 ps=0 w=1u l=0.5u
X249 GROUP23_0.nmosHV$1_priv1_0.S VDD GROUP21_1.G VSS sg13_hv_nmos ad=0.38p pd=2.38u as=0.38p ps=2.38u w=2u l=0.5u
X250 GROUP23_0.nmosHV$1_priv1_0.S VSS GROUP21_3.G VDD sg13_hv_pmos ad=0.38p pd=2.38u as=0.38p ps=2.38u w=2u l=0.5u
X251 GROUP21_2.G VDD GROUP23_0.nmosHV$1_priv1_0.S VSS sg13_hv_nmos ad=0.38p pd=2.38u as=0.38p ps=2.38u w=2u l=0.5u
X252 VSS a_18054_n6587# GROUP3_0/nmos_priv6_0.D VSS sg13_lv_nmos ad=0.34p pd=2.68u as=0.34p ps=2.68u w=1u l=0.13u
X253 vref_4 vref_3 VSS rppd l=2u w=2u
X254 GROUP23_0.nmosHV$1_priv1_0.S VSS GROUP21_0.G VDD sg13_hv_pmos ad=0.38p pd=2.38u as=0.38p ps=2.38u w=2u l=0.5u
X255 GROUP4$1_0/pmos_priv5_0.D GROUP3_0/nmos_priv6_0.D VDDL VDDL sg13_lv_pmos ad=0.34p pd=2.68u as=0.34p ps=2.68u w=1u l=0.13u
X256 GROUP23_0.nmosHV$1_priv1_0.S GROUP7$1_0/nmosHV$1_priv1$1_0.D VSS rppd l=10u w=2u
X257 GROUP23_0.nmosHV$1_priv1_0.S VDD GROUP21_1.G VSS sg13_hv_nmos ad=0.38p pd=2.38u as=0.38p ps=2.38u w=2u l=0.5u
X258 VSS VSS VSS VSS sg13_hv_nmos ad=0.34p pd=2.68u as=0 ps=0 w=1u l=0.5u
X259 GROUP18_0.nmosHV_priv16_0.D GROUP18_0.nmosHV_priv16_0.D GROUP18_0.nmosHV_priv16_0.D VSS sg13_hv_nmos ad=0.34p pd=2.68u as=0 ps=0 w=1u l=0.5u
X260 GROUP5_3.pmosHV_priv15_0.S GROUP5_3.pmosHV_priv15_0.S GROUP5_3.pmosHV_priv15_0.S VDD sg13_hv_pmos ad=1.7p pd=10.68u as=21.6594p ps=79.74u w=5u l=0.5u
X261 GROUP15_1.pmosHV$2_priv7_0.D q2 GROUP18_1.nmosHV_priv16_0.D VDDL sg13_hv_pmos ad=1.36p pd=8.68u as=1.36p ps=8.68u w=4u l=0.5u
X262 GROUP21_0.nmosHV_priv25_0.S GROUP22_0.nmosHV_priv28_0.D VSS VSS sg13_hv_nmos ad=0.34p pd=2.68u as=0.34p ps=2.68u w=1u l=0.5u
X263 GROUP23_0.nmosHV$1_priv1_0.S VDD GROUP21_0.G VSS sg13_hv_nmos ad=0.38p pd=2.38u as=0.38p ps=2.38u w=2u l=0.5u
X264 VSS VSS VSS VSS sg13_hv_nmos ad=0.34p pd=2.68u as=0 ps=0 w=1u l=0.5u
X265 VDD GROUP21_2.G GROUP5_3.pmosHV_priv15_0.S VDD sg13_hv_pmos ad=1.7p pd=10.68u as=1.7p ps=10.68u w=5u l=0.5u
X266 VSS VSS VSS VSS sg13_hv_nmos ad=0.34p pd=2.68u as=0 ps=0 w=1u l=0.5u
X267 VDDL VDDL VDDL VDDL sg13_hv_pmos ad=1.36p pd=8.68u as=0 ps=0 w=4u l=0.5u
X268 pmosHV_priv1_0.D GROUP3_0/nmos_priv6_0.D VSS VSS sg13_hv_nmos ad=3.4p pd=20.68u as=3.4p ps=20.68u w=10u l=0.5u
X269 VSS VSS VSS VSS sg13_hv_nmos ad=0.34p pd=2.68u as=0 ps=0 w=1u l=0.5u
X270 GROUP18_3.nmosHV_priv16_0.D q1 VSS VSS sg13_hv_nmos ad=0.34p pd=2.68u as=0.34p ps=2.68u w=1u l=0.5u
X271 GROUP21_1.G VSS GROUP23_0.nmosHV$1_priv1_0.S VDD sg13_hv_pmos ad=0.38p pd=2.38u as=0.38p ps=2.38u w=2u l=0.5u
X272 GROUP16_0.pmosHV$2_priv10_0.D GROUP16_0.pmosHV$2_priv10_0.D GROUP16_0.pmosHV$2_priv10_0.D VDDL sg13_hv_pmos ad=1.36p pd=8.68u as=0 ps=0 w=4u l=0.5u
X273 VSS VSS VSS VSS sg13_hv_nmos ad=0.34p pd=2.68u as=0 ps=0 w=1u l=0.5u
X274 GROUP5_3.pmosHV_priv15_0.S GROUP5_3.pmosHV_priv15_0.S GROUP5_3.pmosHV_priv15_0.S VDD sg13_hv_pmos ad=1.7p pd=10.68u as=0 ps=0 w=5u l=0.5u
X275 GROUP23_0.nmosHV$1_priv1_0.S VDD GROUP21_0.G VSS sg13_hv_nmos ad=0.38p pd=2.38u as=0.38p ps=2.38u w=2u l=0.5u
X276 GROUP21_0.nmosHV_priv25_0.S GROUP21_0.nmosHV_priv25_0.S GROUP21_0.nmosHV_priv25_0.S VSS sg13_hv_nmos ad=0.34p pd=2.68u as=0 ps=0 w=1u l=0.5u
X277 q3 q3 q3 VSS sg13_hv_nmos ad=0.34p pd=2.68u as=0 ps=0 w=1u l=0.5u
X278 GROUP21_1.G VSS GROUP23_0.nmosHV$1_priv1_0.S VDD sg13_hv_pmos ad=0.38p pd=2.38u as=0.38p ps=2.38u w=2u l=0.5u
X279 GROUP21_3.G VDD GROUP23_0.nmosHV$1_priv1_0.S VSS sg13_hv_nmos ad=0.38p pd=2.38u as=0.38p ps=2.38u w=2u l=0.5u
X280 GROUP7_2.pmosHV$1_priv1_0.S GROUP7_2.pmosHV$1_priv1_0.S GROUP7_2.pmosHV$1_priv1_0.S VSS sg13_hv_nmos ad=0.34p pd=2.68u as=0 ps=0 w=1u l=0.5u
X281 GROUP18_0.nmosHV_priv16_0.D q3 VSS VSS sg13_hv_nmos ad=0.34p pd=2.68u as=0.34p ps=2.68u w=1u l=0.5u
X282 GROUP5_2.pmosHV_priv15_0.S GROUP5_2.pmosHV_priv15_0.S GROUP5_2.pmosHV_priv15_0.S VDD sg13_hv_pmos ad=1.7p pd=10.68u as=0 ps=0 w=5u l=0.5u
X283 GROUP7_2.pmosHV$1_priv1_0.S GROUP21_1.G VSS VSS sg13_hv_nmos ad=0.34p pd=2.68u as=0.34p ps=2.68u w=1u l=0.5u
X284 GROUP21_2.G GROUP21_2.G GROUP21_2.G VDD sg13_hv_pmos ad=0.68p pd=4.68u as=71.9421p ps=0.3071m w=2u l=0.5u
X285 GROUP21_2.G VSS GROUP23_0.nmosHV$1_priv1_0.S VDD sg13_hv_pmos ad=0.38p pd=2.38u as=0.38p ps=2.38u w=2u l=0.5u
X286 GROUP5_1.pmosHV_priv15_0.S GROUP5_1.pmosHV_priv15_0.S GROUP5_1.pmosHV_priv15_0.S VDD sg13_hv_pmos ad=1.7p pd=10.68u as=0 ps=0 w=5u l=0.5u
X287 VSS VSS VSS VSS sg13_hv_nmos ad=0.34p pd=2.68u as=0 ps=0 w=1u l=0.5u
X288 GROUP21_3.G VDD GROUP23_0.nmosHV$1_priv1_0.S VSS sg13_hv_nmos ad=0.38p pd=2.38u as=0.38p ps=2.38u w=2u l=0.5u
X289 GROUP9_2.nmosHV_priv4_0.S GROUP22_1.nmosHV_priv28_0.D GROUP21_1.nmosHV_priv25_0.S VDD sg13_hv_pmos ad=0.68p pd=4.68u as=0.68p ps=4.68u w=2u l=0.5u
X290 GROUP21_3.G GROUP21_3.G GROUP21_3.G VDD sg13_hv_pmos ad=0.68p pd=4.68u as=0 ps=0 w=2u l=0.5u
X291 GROUP21_3.G VSS GROUP23_0.nmosHV$1_priv1_0.S VDD sg13_hv_pmos ad=0.38p pd=2.38u as=0.38p ps=2.38u w=2u l=0.5u
X292 VDDL GROUP22_0.nmosHV_priv28_0.D GROUP16_1.pmosHV$2_priv10_0.D VDDL sg13_hv_pmos ad=1.36p pd=8.68u as=1.36p ps=8.68u w=4u l=0.5u
X293 GROUP23_0.nmosHV$1_priv1_0.S VDD GROUP21_2.G VSS sg13_hv_nmos ad=0.38p pd=2.38u as=0.38p ps=2.38u w=2u l=0.5u
X294 VSS VSS VSS VSS sg13_lv_nmos ad=0.34p pd=2.68u as=0 ps=0 w=1u l=0.13u
X295 GROUP21_0.G VSS GROUP23_0.nmosHV$1_priv1_0.S VDD sg13_hv_pmos ad=0.38p pd=2.38u as=0.38p ps=2.38u w=2u l=0.5u
X296 GROUP5_0.pmosHV_priv15_0.S GROUP5_0.pmosHV_priv15_0.S GROUP5_0.pmosHV_priv15_0.S VDD sg13_hv_pmos ad=1.7p pd=10.68u as=0 ps=0 w=5u l=0.5u
X297 GROUP21_1.G VDD GROUP23_0.nmosHV$1_priv1_0.S VSS sg13_hv_nmos ad=0.38p pd=2.38u as=0.38p ps=2.38u w=2u l=0.5u
X298 GROUP16_1.pmosHV$2_priv10_0.D GROUP16_1.pmosHV$2_priv10_0.D GROUP16_1.pmosHV$2_priv10_0.D VDDL sg13_hv_pmos ad=1.36p pd=8.68u as=0 ps=0 w=4u l=0.5u
X299 q3 GROUP22_3.nmosHV_priv28_0.D VSS VSS sg13_hv_nmos ad=0.34p pd=2.68u as=0.34p ps=2.68u w=1u l=0.5u
X300 GROUP5_3.pmosHV_priv15_0.S GROUP5_3.pmosHV_priv15_0.S GROUP5_3.pmosHV_priv15_0.S VDD sg13_hv_pmos ad=1.7p pd=10.68u as=0 ps=0 w=5u l=0.5u
X301 GROUP9_1.nmosHV_priv4_0.S GROUP9_1.nmosHV_priv4_0.S GROUP9_1.nmosHV_priv4_0.S VSS sg13_hv_nmos ad=0.34p pd=2.68u as=0 ps=0 w=1u l=0.5u
X302 GROUP22_2.nmosHV_priv28_0.D GROUP21_2.nmosHV_priv25_0.S VSS VSS sg13_hv_nmos ad=0.34p pd=2.68u as=0.34p ps=2.68u w=1u l=0.5u
X303 GROUP21_0.G VSS GROUP23_0.nmosHV$1_priv1_0.S VDD sg13_hv_pmos ad=0.38p pd=2.38u as=0.38p ps=2.38u w=2u l=0.5u
X304 GROUP9_2.nmosHV_priv4_0.S GROUP9_2.nmosHV_priv4_0.S GROUP9_2.nmosHV_priv4_0.S VDD sg13_hv_pmos ad=0.68p pd=4.68u as=0 ps=0 w=2u l=0.5u
X305 VSS VSS VSS VSS sg13_hv_nmos ad=0.34p pd=2.68u as=0 ps=0 w=1u l=0.5u
X306 VDD pmosHV_priv1_0.D pmosHV_priv2_0.D VDD sg13_hv_pmos ad=0.34p pd=2.68u as=0.34p ps=2.68u w=1u l=0.5u
X307 GROUP9_1.nmosHV_priv4_0.S GROUP21_0.G VSS VSS sg13_hv_nmos ad=0.34p pd=2.68u as=0.34p ps=2.68u w=1u l=0.5u
X308 GROUP21_1.G VDD GROUP23_0.nmosHV$1_priv1_0.S VSS sg13_hv_nmos ad=0.38p pd=2.38u as=0.38p ps=2.38u w=2u l=0.5u
X309 GROUP23_0.nmosHV$1_priv1_0.S VSS GROUP21_1.G VDD sg13_hv_pmos ad=0.38p pd=2.38u as=0.38p ps=2.38u w=2u l=0.5u
X310 GROUP21_0.G VDD GROUP23_0.nmosHV$1_priv1_0.S VSS sg13_hv_nmos ad=0.38p pd=2.38u as=0.38p ps=2.38u w=2u l=0.5u
X311 q0 q0 q0 VSS sg13_hv_nmos ad=0.34p pd=2.68u as=24.1098p ps=0.13178m w=1u l=0.5u
X312 VDD VDD VDD VDD sg13_hv_pmos ad=1.7p pd=10.68u as=0 ps=0 w=5u l=0.5u
X313 VDD GROUP21_3.G GROUP5_0.pmosHV_priv15_0.S VDD sg13_hv_pmos ad=1.7p pd=10.68u as=1.7p ps=10.68u w=5u l=0.5u
X314 GROUP21_2.G GROUP21_2.G GROUP21_2.G VSS sg13_hv_nmos ad=0.68p pd=4.68u as=0 ps=0 w=2u l=0.5u
X315 GROUP7_1.pmosHV$1_priv1_0.S GROUP21_0.nmosHV_priv25_0.S GROUP22_0.nmosHV_priv28_0.D VDD sg13_hv_pmos ad=0.68p pd=4.68u as=0.68p ps=4.68u w=2u l=0.5u
X316 GROUP21_1.nmosHV_priv25_0.S GROUP21_1.nmosHV_priv25_0.S GROUP21_1.nmosHV_priv25_0.S VDD sg13_hv_pmos ad=0.68p pd=4.68u as=0 ps=0 w=2u l=0.5u
X317 GROUP22_2.nmosHV_priv28_0.D GROUP22_2.nmosHV_priv28_0.D GROUP22_2.nmosHV_priv28_0.D VSS sg13_hv_nmos ad=0.34p pd=2.68u as=0 ps=0 w=1u l=0.5u
X318 GROUP23_0.nmosHV$1_priv1_0.S VSS GROUP21_1.G VDD sg13_hv_pmos ad=0.38p pd=2.38u as=0.68p ps=4.68u w=2u l=0.5u
X319 GROUP21_3.nmosHV_priv25_0.S GROUP21_3.nmosHV_priv25_0.S GROUP21_3.nmosHV_priv25_0.S VSS sg13_hv_nmos ad=0.34p pd=2.68u as=0 ps=0 w=1u l=0.5u
X320 q0 q0 q0 VSS sg13_hv_nmos ad=0.34p pd=2.68u as=0 ps=0 w=1u l=0.5u
X321 GROUP5_0.pmosHV_priv15_0.S GROUP5_0.pmosHV_priv15_0.S GROUP5_0.pmosHV_priv15_0.S VDD sg13_hv_pmos ad=1.7p pd=10.68u as=0 ps=0 w=5u l=0.5u
X322 q0 q0 q0 VDDL sg13_hv_pmos ad=1.36p pd=8.68u as=0 ps=0 w=4u l=0.5u
X323 GROUP15_2.pmosHV$2_priv7_0.D GROUP15_2.pmosHV$2_priv7_0.D GROUP15_2.pmosHV$2_priv7_0.D VDDL sg13_hv_pmos ad=1.36p pd=8.68u as=0 ps=0 w=4u l=0.5u
X324 VSS VSS VSS VSS sg13_hv_nmos ad=0.34p pd=2.68u as=0 ps=0 w=1u l=0.5u
X325 GROUP22_1.nmosHV_priv28_0.D GROUP21_1.nmosHV_priv25_0.S VSS VSS sg13_hv_nmos ad=0.34p pd=2.68u as=0.34p ps=2.68u w=1u l=0.5u
X326 GROUP21_2.G VDD GROUP23_0.nmosHV$1_priv1_0.S VSS sg13_hv_nmos ad=0.38p pd=2.38u as=0.38p ps=2.38u w=2u l=0.5u
X327 VDDL VDDL VDDL VDDL sg13_hv_pmos ad=1.36p pd=8.68u as=0 ps=0 w=4u l=0.5u
X328 GROUP22_1.nmosHV_priv28_0.D GROUP21_1.G VSS VSS sg13_hv_nmos ad=0.34p pd=2.68u as=0.34p ps=2.68u w=1u l=0.5u
X329 VSS VSS VSS VSS sg13_hv_nmos ad=0.34p pd=2.68u as=0 ps=0 w=1u l=0.5u
X330 GROUP7_1.pmosHV$1_priv1_0.S GROUP7_1.pmosHV$1_priv1_0.S GROUP7_1.pmosHV$1_priv1_0.S VDD sg13_hv_pmos ad=0.68p pd=4.68u as=0 ps=0 w=2u l=0.5u
X331 GROUP23_0.nmosHV$1_priv1_0.S VDD GROUP21_3.G VSS sg13_hv_nmos ad=0.38p pd=2.38u as=0.68p ps=4.68u w=2u l=0.5u
X332 VSS VSS VSS VSS sg13_hv_nmos ad=0.34p pd=2.68u as=0 ps=0 w=1u l=0.5u
X333 VSS VSS VSS VSS sg13_hv_nmos ad=0.34p pd=2.68u as=0 ps=0 w=1u l=0.5u
X334 GROUP16_2.pmosHV$2_priv10_0.D GROUP18_2.nmosHV_priv16_0.D q0 VDDL sg13_hv_pmos ad=1.36p pd=8.68u as=1.36p ps=8.68u w=4u l=0.5u
X335 GROUP23_0.nmosHV$1_priv1_0.S VSS GROUP21_0.G VDD sg13_hv_pmos ad=0.38p pd=2.38u as=0.38p ps=2.38u w=2u l=0.5u
X336 GROUP23_0.nmosHV$1_priv1_0.S GROUP23_0.nmosHV$1_priv1_0.S GROUP23_0.nmosHV$1_priv1_0.S VSS sg13_hv_nmos ad=0.68p pd=4.68u as=0 ps=0 w=2u l=0.5u
X337 q0 GROUP18_2.nmosHV_priv16_0.D VSS VSS sg13_hv_nmos ad=0.34p pd=2.68u as=0.34p ps=2.68u w=1u l=0.5u
X338 vref_1 VSS VSS rhigh l=3.49u w=2u
X339 GROUP21_2.G VDD GROUP23_0.nmosHV$1_priv1_0.S VSS sg13_hv_nmos ad=0.68p pd=4.68u as=0.38p ps=2.38u w=2u l=0.5u
X340 GROUP22_0.nmosHV_priv28_0.D GROUP22_0.nmosHV_priv28_0.D GROUP22_0.nmosHV_priv28_0.D VDD sg13_hv_pmos ad=0.68p pd=4.68u as=0 ps=0 w=2u l=0.5u
X341 GROUP23_0.nmosHV$1_priv1_0.S VDD GROUP21_0.G VSS sg13_hv_nmos ad=0.38p pd=2.38u as=0.38p ps=2.38u w=2u l=0.5u
X342 GROUP22_1.nmosHV_priv28_0.D GROUP22_1.nmosHV_priv28_0.D GROUP22_1.nmosHV_priv28_0.D VSS sg13_hv_nmos ad=0.34p pd=2.68u as=0 ps=0 w=1u l=0.5u
X343 GROUP22_3.nmosHV_priv28_0.D GROUP21_3.nmosHV_priv25_0.S VSS VSS sg13_hv_nmos ad=0.34p pd=2.68u as=0.34p ps=2.68u w=1u l=0.5u
X344 GROUP21_0.nmosHV_priv25_0.S GROUP21_0.G VSS VSS sg13_hv_nmos ad=0.34p pd=2.68u as=0.34p ps=2.68u w=1u l=0.5u
X345 q0 GROUP22_2.nmosHV_priv28_0.D VSS VSS sg13_hv_nmos ad=0.34p pd=2.68u as=0.34p ps=2.68u w=1u l=0.5u
X346 GROUP7_1.pmosHV$1_priv1_0.S GROUP7_1.pmosHV$1_priv1_0.S GROUP7_1.pmosHV$1_priv1_0.S VSS sg13_hv_nmos ad=0.34p pd=2.68u as=0 ps=0 w=1u l=0.5u
X347 GROUP23_0.nmosHV$1_priv1_0.S VSS GROUP21_0.G VDD sg13_hv_pmos ad=0.38p pd=2.38u as=0.68p ps=4.68u w=2u l=0.5u
X348 VSS VSS VSS VSS sg13_hv_nmos ad=0.34p pd=2.68u as=0 ps=0 w=1u l=0.5u
X349 GROUP21_1.G VSS GROUP23_0.nmosHV$1_priv1_0.S VDD sg13_hv_pmos ad=0.38p pd=2.38u as=0.38p ps=2.38u w=2u l=0.5u
X350 GROUP23_0.nmosHV$1_priv1_0.S VDD GROUP21_1.G VSS sg13_hv_nmos ad=0.38p pd=2.38u as=0.68p ps=4.68u w=2u l=0.5u
X351 GROUP15_3.pmosHV$2_priv7_0.D GROUP15_3.pmosHV$2_priv7_0.D GROUP15_3.pmosHV$2_priv7_0.D VDDL sg13_hv_pmos ad=1.36p pd=8.68u as=0 ps=0 w=4u l=0.5u
X352 VDD pmosHV_priv2_0.D pmosHV_priv1_0.D VDD sg13_hv_pmos ad=0.34p pd=2.68u as=0.34p ps=2.68u w=1u l=0.5u
X353 GROUP7_1.pmosHV$1_priv1_0.S GROUP21_0.G VSS VSS sg13_hv_nmos ad=0.34p pd=2.68u as=0.34p ps=2.68u w=1u l=0.5u
X354 GROUP23_0.nmosHV$1_priv1_0.S VDD GROUP21_0.G VSS sg13_hv_nmos ad=0.38p pd=2.38u as=0.38p ps=2.38u w=2u l=0.5u
X355 VDDL GROUP21_0.nmosHV_priv25_0.S GROUP15_1.pmosHV$2_priv7_0.D VDDL sg13_hv_pmos ad=1.36p pd=8.68u as=1.36p ps=8.68u w=4u l=0.5u
X356 VSS VSS VSS VSS sg13_hv_nmos ad=0.34p pd=2.68u as=0 ps=0 w=1u l=0.5u
X357 GROUP18_1.nmosHV_priv16_0.D GROUP18_1.nmosHV_priv16_0.D GROUP18_1.nmosHV_priv16_0.D VSS sg13_hv_nmos ad=0.34p pd=2.68u as=0 ps=0 w=1u l=0.5u
X358 GROUP7_3.pmosHV$1_priv1_0.S GROUP7_3.pmosHV$1_priv1_0.S GROUP7_3.pmosHV$1_priv1_0.S VDD sg13_hv_pmos ad=1.7p pd=10.68u as=0 ps=0 w=5u l=0.5u
X359 GROUP22_3.nmosHV_priv28_0.D GROUP22_3.nmosHV_priv28_0.D GROUP22_3.nmosHV_priv28_0.D VSS sg13_hv_nmos ad=0.34p pd=2.68u as=0 ps=0 w=1u l=0.5u
X360 GROUP15_1.pmosHV$2_priv7_0.D GROUP15_1.pmosHV$2_priv7_0.D GROUP15_1.pmosHV$2_priv7_0.D VDDL sg13_hv_pmos ad=1.36p pd=8.68u as=0 ps=0 w=4u l=0.5u
X361 GROUP23_0.nmosHV$1_priv1_0.S GROUP23_0.nmosHV$1_priv1_0.S GROUP23_0.nmosHV$1_priv1_0.S VSS sg13_hv_nmos ad=0.68p pd=4.68u as=0 ps=0 w=2u l=0.5u
X362 VSS VSS VSS VSS sg13_hv_nmos ad=0.34p pd=2.68u as=0 ps=0 w=1u l=0.5u
X363 GROUP9_1.nmosHV_priv4_0.S GROUP22_0.nmosHV_priv28_0.D GROUP21_0.nmosHV_priv25_0.S VDD sg13_hv_pmos ad=0.68p pd=4.68u as=0.68p ps=4.68u w=2u l=0.5u
X364 GROUP21_1.G VSS GROUP23_0.nmosHV$1_priv1_0.S VDD sg13_hv_pmos ad=0.68p pd=4.68u as=0.38p ps=2.38u w=2u l=0.5u
X365 q3 q3 q3 VSS sg13_hv_nmos ad=0.34p pd=2.68u as=0 ps=0 w=1u l=0.5u
X366 GROUP15_0.pmosHV$2_priv7_0.D GROUP15_0.pmosHV$2_priv7_0.D GROUP15_0.pmosHV$2_priv7_0.D VDDL sg13_hv_pmos ad=1.36p pd=8.68u as=0 ps=0 w=4u l=0.5u
X367 vref_2 vref_1 VSS rppd l=3.6u w=2u
X368 VSS VSS VSS VSS sg13_hv_nmos ad=0.34p pd=2.68u as=0 ps=0 w=1u l=0.5u
C0 clk VSS 1.77354f
C1 vref_1 VSS 0.93567f
C2 vref_2 VSS 0.47509f
C3 vref_3 VSS 0.43286f
C4 vref_4 VSS 0.26394f
C5 m1_27282_11002# VSS 0.36656f ; **FLOATING
C6 a_19086_n6423# VSS 0.14818f ; **FLOATING
C7 a_18869_n6423# VSS 0.14818f ; **FLOATING
C8 a_18180_n6423# VSS 0.14818f ; **FLOATING
C9 a_17963_n6423# VSS 0.14818f ; **FLOATING
C10 a_19086_n5699# VSS 0.14818f ; **FLOATING
C11 a_18869_n5699# VSS 0.14818f ; **FLOATING
C12 a_18181_n5699# VSS 0.14818f ; **FLOATING
C13 a_17964_n5699# VSS 0.14818f ; **FLOATING
C14 GROUP4$1_0/pmos_priv5_0.D VSS 1.12224f
C15 pmosHV_priv1_0.D VSS 0.65573f
C16 a_18670_n3807# VSS 0.22513f ; **FLOATING
C17 a_18305_n3807# VSS 0.22513f ; **FLOATING
C18 a_17303_n3807# VSS 0.49071f ; **FLOATING
C19 a_16938_n3807# VSS 0.49071f ; **FLOATING
C20 GROUP7$1_0/nmosHV$1_priv1$1_0.D VSS 1.3197f
C21 a_34428_615# VSS 0.22513f ; **FLOATING
C22 a_29132_610# VSS 0.22513f ; **FLOATING
C23 a_25478_615# VSS 0.22513f ; **FLOATING
C24 a_20182_610# VSS 0.22513f ; **FLOATING
C25 a_16528_615# VSS 0.22513f ; **FLOATING
C26 a_11232_610# VSS 0.22513f ; **FLOATING
C27 a_7578_615# VSS 0.22513f ; **FLOATING
C28 a_2282_610# VSS 0.22513f ; **FLOATING
C29 a_34428_980# VSS 0.22513f ; **FLOATING
C30 a_29132_975# VSS 0.22513f ; **FLOATING
C31 a_25478_980# VSS 0.22513f ; **FLOATING
C32 a_20182_975# VSS 0.22513f ; **FLOATING
C33 a_16528_980# VSS 0.22513f ; **FLOATING
C34 a_11232_975# VSS 0.22513f ; **FLOATING
C35 a_7578_980# VSS 0.22513f ; **FLOATING
C36 a_2282_975# VSS 0.22513f ; **FLOATING
C37 a_34428_1820# VSS 0.22513f ; **FLOATING
C38 a_33704_1821# VSS 0.22513f ; **FLOATING
C39 a_29854_1821# VSS 0.22513f ; **FLOATING
C40 a_29132_1819# VSS 0.22513f ; **FLOATING
C41 a_25478_1820# VSS 0.22513f ; **FLOATING
C42 a_24754_1821# VSS 0.22513f ; **FLOATING
C43 a_20904_1821# VSS 0.22513f ; **FLOATING
C44 a_20182_1819# VSS 0.22513f ; **FLOATING
C45 a_16528_1820# VSS 0.22513f ; **FLOATING
C46 a_15804_1821# VSS 0.22513f ; **FLOATING
C47 a_11954_1821# VSS 0.22513f ; **FLOATING
C48 a_11232_1819# VSS 0.22513f ; **FLOATING
C49 a_7578_1820# VSS 0.22513f ; **FLOATING
C50 a_6854_1821# VSS 0.22513f ; **FLOATING
C51 a_3004_1821# VSS 0.22513f ; **FLOATING
C52 a_2282_1819# VSS 0.22513f ; **FLOATING
C53 a_34428_2185# VSS 0.22513f ; **FLOATING
C54 a_33704_2186# VSS 0.22513f ; **FLOATING
C55 a_29854_2186# VSS 0.22513f ; **FLOATING
C56 a_29132_2184# VSS 0.22513f ; **FLOATING
C57 a_25478_2185# VSS 0.22513f ; **FLOATING
C58 a_24754_2186# VSS 0.22513f ; **FLOATING
C59 a_20904_2186# VSS 0.22513f ; **FLOATING
C60 a_20182_2184# VSS 0.22513f ; **FLOATING
C61 a_16528_2185# VSS 0.22513f ; **FLOATING
C62 a_15804_2186# VSS 0.22513f ; **FLOATING
C63 a_11954_2186# VSS 0.22513f ; **FLOATING
C64 a_11232_2184# VSS 0.22513f ; **FLOATING
C65 a_7578_2185# VSS 0.22513f ; **FLOATING
C66 a_6854_2186# VSS 0.22513f ; **FLOATING
C67 a_3004_2186# VSS 0.22513f ; **FLOATING
C68 a_2282_2184# VSS 0.22513f ; **FLOATING
C69 a_33104_3081# VSS 0.6235f ; **FLOATING
C70 a_29854_3081# VSS 0.6235f ; **FLOATING
C71 a_24154_3081# VSS 0.6235f ; **FLOATING
C72 a_20904_3081# VSS 0.6235f ; **FLOATING
C73 a_15204_3081# VSS 0.6235f ; **FLOATING
C74 a_11954_3081# VSS 0.6235f ; **FLOATING
C75 a_6254_3081# VSS 0.6235f ; **FLOATING
C76 a_3004_3081# VSS 0.6235f ; **FLOATING
C77 GROUP18_3.nmosHV_priv16_0.D VSS 0.96877f
C78 a_33104_3446# VSS 0.6235f ; **FLOATING
C79 a_29854_3446# VSS 0.6235f ; **FLOATING
C80 a_24154_3446# VSS 0.6235f ; **FLOATING
C81 a_20904_3446# VSS 0.6235f ; **FLOATING
C82 a_15204_3446# VSS 0.6235f ; **FLOATING
C83 a_11954_3446# VSS 0.6235f ; **FLOATING
C84 a_6254_3446# VSS 0.6235f ; **FLOATING
C85 a_3004_3446# VSS 0.6235f ; **FLOATING
C86 a_28494_3990# VSS 0.35792f ; **FLOATING
C87 a_27508_3986# VSS 0.35792f ; **FLOATING
C88 a_19544_3990# VSS 0.35792f ; **FLOATING
C89 a_18558_3986# VSS 0.35792f ; **FLOATING
C90 a_10594_3990# VSS 0.35792f ; **FLOATING
C91 a_9608_3986# VSS 0.35792f ; **FLOATING
C92 a_1644_3990# VSS 0.35792f ; **FLOATING
C93 a_658_3986# VSS 0.35792f ; **FLOATING
C94 a_33104_4341# VSS 0.6235f ; **FLOATING
C95 a_29854_4340# VSS 0.6235f ; **FLOATING
C96 a_24154_4341# VSS 0.6235f ; **FLOATING
C97 a_20904_4340# VSS 0.6235f ; **FLOATING
C98 a_15204_4341# VSS 0.6235f ; **FLOATING
C99 a_11954_4340# VSS 0.6235f ; **FLOATING
C100 a_6254_4341# VSS 0.6235f ; **FLOATING
C101 a_3004_4340# VSS 0.6235f ; **FLOATING
C102 a_33104_4706# VSS 0.6235f ; **FLOATING
C103 a_29854_4705# VSS 0.6235f ; **FLOATING
C104 a_24154_4706# VSS 0.6235f ; **FLOATING
C105 a_20904_4705# VSS 0.6235f ; **FLOATING
C106 a_15204_4706# VSS 0.6235f ; **FLOATING
C107 a_11954_4705# VSS 0.6235f ; **FLOATING
C108 a_6254_4706# VSS 0.6235f ; **FLOATING
C109 a_3004_4705# VSS 0.6235f ; **FLOATING
C110 a_33704_5554# VSS 0.22513f ; **FLOATING
C111 a_29854_5554# VSS 0.22513f ; **FLOATING
C112 a_24754_5554# VSS 0.22513f ; **FLOATING
C113 a_20904_5554# VSS 0.22513f ; **FLOATING
C114 a_15804_5554# VSS 0.22513f ; **FLOATING
C115 a_11954_5554# VSS 0.22513f ; **FLOATING
C116 a_6854_5554# VSS 0.22513f ; **FLOATING
C117 a_3004_5554# VSS 0.22513f ; **FLOATING
C118 a_33704_5919# VSS 0.22513f ; **FLOATING
C119 a_29854_5919# VSS 0.22513f ; **FLOATING
C120 a_24754_5919# VSS 0.22513f ; **FLOATING
C121 a_20904_5919# VSS 0.22513f ; **FLOATING
C122 a_15804_5919# VSS 0.22513f ; **FLOATING
C123 a_11954_5919# VSS 0.22513f ; **FLOATING
C124 a_6854_5919# VSS 0.22513f ; **FLOATING
C125 a_3004_5919# VSS 0.22513f ; **FLOATING
C126 a_28494_6291# VSS 0.35792f ; **FLOATING
C127 a_27508_6287# VSS 0.35792f ; **FLOATING
C128 a_19544_6291# VSS 0.35792f ; **FLOATING
C129 a_18558_6287# VSS 0.35792f ; **FLOATING
C130 a_10594_6291# VSS 0.35792f ; **FLOATING
C131 a_9608_6287# VSS 0.35792f ; **FLOATING
C132 a_1644_6291# VSS 0.35792f ; **FLOATING
C133 a_658_6287# VSS 0.35792f ; **FLOATING
C134 a_33502_6814# VSS 0.35792f ; **FLOATING
C135 a_32180_6866# VSS 0.22513f ; **FLOATING
C136 a_31378_6866# VSS 0.22513f ; **FLOATING
C137 a_29854_6814# VSS 0.35792f ; **FLOATING
C138 a_24552_6814# VSS 0.35792f ; **FLOATING
C139 a_23230_6866# VSS 0.22513f ; **FLOATING
C140 a_22428_6866# VSS 0.22513f ; **FLOATING
C141 a_20904_6814# VSS 0.35792f ; **FLOATING
C142 a_15602_6814# VSS 0.35792f ; **FLOATING
C143 a_33502_7179# VSS 0.35792f ; **FLOATING
C144 a_14280_6866# VSS 0.22513f ; **FLOATING
C145 a_13478_6866# VSS 0.22513f ; **FLOATING
C146 a_11954_6814# VSS 0.35792f ; **FLOATING
C147 a_6652_6814# VSS 0.35792f ; **FLOATING
C148 a_32180_7231# VSS 0.22513f ; **FLOATING
C149 a_31378_7231# VSS 0.22513f ; **FLOATING
C150 a_29854_7179# VSS 0.35792f ; **FLOATING
C151 a_24552_7179# VSS 0.35792f ; **FLOATING
C152 a_5330_6866# VSS 0.22513f ; **FLOATING
C153 a_4528_6866# VSS 0.22513f ; **FLOATING
C154 a_3004_6814# VSS 0.35792f ; **FLOATING
C155 a_23230_7231# VSS 0.22513f ; **FLOATING
C156 a_22428_7231# VSS 0.22513f ; **FLOATING
C157 a_20904_7179# VSS 0.35792f ; **FLOATING
C158 a_15602_7179# VSS 0.35792f ; **FLOATING
C159 a_14280_7231# VSS 0.22513f ; **FLOATING
C160 a_13478_7231# VSS 0.22513f ; **FLOATING
C161 a_11954_7179# VSS 0.35792f ; **FLOATING
C162 a_6652_7179# VSS 0.35792f ; **FLOATING
C163 a_5330_7231# VSS 0.22513f ; **FLOATING
C164 a_4528_7231# VSS 0.22513f ; **FLOATING
C165 a_3004_7179# VSS 0.35792f ; **FLOATING
C166 a_32902_8080# VSS 0.75629f ; **FLOATING
C167 a_29854_8080# VSS 0.75629f ; **FLOATING
C168 a_23952_8080# VSS 0.75629f ; **FLOATING
C169 a_20904_8080# VSS 0.75629f ; **FLOATING
C170 a_15002_8080# VSS 0.75629f ; **FLOATING
C171 GROUP7_2.pmosHV$1_priv1_0.S VSS 0.24219f
C172 a_11954_8080# VSS 0.75629f ; **FLOATING
C173 a_6052_8080# VSS 0.75629f ; **FLOATING
C174 GROUP7_1.pmosHV$1_priv1_0.S VSS 0.11514f
C175 a_3004_8080# VSS 0.75629f ; **FLOATING
C176 GROUP9_0.nmosHV_priv4_0.S VSS 5.51992f
C177 a_32902_8445# VSS 0.75629f ; **FLOATING
C178 a_29854_8445# VSS 0.75629f ; **FLOATING
C179 a_23952_8445# VSS 0.75629f ; **FLOATING
C180 a_20904_8445# VSS 0.75629f ; **FLOATING
C181 a_15002_8445# VSS 0.75629f ; **FLOATING
C182 a_11954_8445# VSS 0.75629f ; **FLOATING
C183 a_6052_8445# VSS 0.75629f ; **FLOATING
C184 a_3004_8445# VSS 0.75629f ; **FLOATING
C185 a_31378_9279# VSS 0.75629f ; **FLOATING
C186 a_22428_9279# VSS 0.75629f ; **FLOATING
C187 a_13478_9279# VSS 0.75629f ; **FLOATING
C188 a_4528_9279# VSS 0.75629f ; **FLOATING
C189 GROUP21_0.G VSS 0.32787f
C190 a_31378_9644# VSS 0.75629f ; **FLOATING
C191 a_22428_9644# VSS 0.75629f ; **FLOATING
C192 a_13478_9644# VSS 0.75629f ; **FLOATING
C193 a_4528_9644# VSS 0.75629f ; **FLOATING
.ends
