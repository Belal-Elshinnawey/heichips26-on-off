* PEX produced on Fri Sep 11 01:05:41 CEST 2026 using scripts/sak-pex.sh with m=3 and s=1 (extresist threshold=10000 mOhm, minres=1000 mOhm, mindelay=1 ps)
* NGSPICE file created from lna_pex.ext - technology: ihp-sg13cmos5l

.subckt lna_pex VDD vout vin VSS
X0 M24_0/pmosHV$1_priv4_0.D VSS.t33 VSS.t32 rhigh l=15.02u w=2u
X1 M24_0/pmosHV$1_priv4_0.D M24_0/pmosHV$1_priv4_0.D VDD VDD sg13_hv_pmos ad=0.38p pd=2.38u as=0.38p ps=2.38u w=2u l=0.5u
X2 VSS.t45 VSS.t43 VSS.t44 VSS.t1 sg13_hv_nmos ad=0.68p pd=4.68u as=0 ps=0 w=2u l=0.5u
X3 M15_0/nmosHV$1_priv1_0.D vin VSS.t72 VSS.t24 sg13_hv_nmos ad=0.19p pd=1.38u as=0.19p ps=1.38u w=1u l=0.5u
X4 VSS.t60 vin M15_0/nmosHV$1_priv1_0.D VSS.t24 sg13_hv_nmos ad=0.19p pd=1.38u as=0.19p ps=1.38u w=1u l=0.5u
X5 VDD M22_0/pmosHV$1_priv2_0.D M23_0/pmosHV$1_priv3_0.D VDD sg13_hv_pmos ad=0.38p pd=2.38u as=0.38p ps=2.38u w=2u l=0.5u
X6 vout vout vout VDD sg13_hv_pmos ad=0.68p pd=4.68u as=16.0372p ps=91.63999u w=2u l=0.5u
X7 VSS.t62 vin M15_0/nmosHV$1_priv1_0.D VSS.t24 sg13_hv_nmos ad=0.19p pd=1.38u as=0.19p ps=1.38u w=1u l=0.5u
X8 M21_0/nmosHV$5_priv1_0.D M20_0/nmosHV$5_priv2_0.D VSS.t16 VSS.t1 sg13_hv_nmos ad=0.68p pd=4.68u as=0.38p ps=2.38u w=2u l=0.5u
X9 VSS.t38 VSS.t38 VSS.t38 VSS.t39 sg13_hv_nmos ad=0.17p pd=1.68u as=0 ps=0 w=0.5u l=0.5u
X10 VDD M24_0/pmosHV$1_priv4_0.D M24_0/pmosHV$1_priv4_0.D VDD sg13_hv_pmos ad=0.38p pd=2.38u as=0.68p ps=4.68u w=2u l=0.5u
X11 M24_0/pmosHV$1_priv4_0.D M24_0/pmosHV$1_priv4_0.D M24_0/pmosHV$1_priv4_0.D VDD sg13_hv_pmos ad=0.68p pd=4.68u as=34.3557p ps=0.14088m w=2u l=0.5u
X12 M15_0/nmosHV$1_priv1_0.D vin VSS.t66 VSS.t24 sg13_hv_nmos ad=0.19p pd=1.38u as=0.19p ps=1.38u w=1u l=0.5u
X13 M15_0/nmosHV$1_priv1_0.D M15_0/nmosHV$1_priv1_0.D M15_0/nmosHV$1_priv1_0.D VSS.t24 sg13_hv_nmos ad=0.34p pd=2.68u as=6.9973p ps=50.28u w=1u l=0.5u
X14 M15_0/nmosHV$1_priv1_0.D vin VSS.t56 VSS.t24 sg13_hv_nmos ad=0.34p pd=2.68u as=0.19p ps=1.38u w=1u l=0.5u
X15 vout M24_0/pmosHV$1_priv4_0.D VDD VDD sg13_hv_pmos ad=0.38p pd=2.38u as=0.38p ps=2.38u w=2u l=0.5u
X16 M23_0/pmosHV$1_priv3_0.D M22_0/pmosHV$1_priv2_0.D VDD VDD sg13_hv_pmos ad=0.38p pd=2.38u as=0.68p ps=4.68u w=2u l=0.5u
X17 M15_0/nmosHV$1_priv1_0.D vin VSS.t68 VSS.t24 sg13_hv_nmos ad=0.19p pd=1.38u as=0.19p ps=1.38u w=1u l=0.5u
X18 M23_0/pmosHV$1_priv3_0.D M22_0/pmosHV$1_priv2_0.D VDD VDD sg13_hv_pmos ad=0.38p pd=2.38u as=0.38p ps=2.38u w=2u l=0.5u
X19 M23_0/pmosHV$1_priv3_0.D M23_0/pmosHV$1_priv3_0.D M23_0/pmosHV$1_priv3_0.D VSS.t22 sg13_hv_nmos ad=0.17p pd=1.68u as=11.7335p ps=72.64u w=0.5u l=0.5u
X20 VSS.t11 M20_0/nmosHV$5_priv2_0.D M20_0/nmosHV$5_priv2_0.D VSS.t10 sg13_hv_nmos ad=0.38p pd=2.38u as=0.38p ps=2.38u w=2u l=0.5u
X21 M16_0/nmosHV$2_priv1_0.D M16_0/nmosHV$2_priv1_0.D M16_0/nmosHV$2_priv1_0.D VSS.t28 sg13_hv_nmos ad=0.34p pd=2.68u as=34.1645p ps=81.03u w=1u l=0.5u
X22 vout vout vout VSS.t23 sg13_hv_nmos ad=0.34p pd=2.68u as=0 ps=0 w=1u l=0.5u
X23 M23_0/pmosHV$1_priv3_0.D M23_0/pmosHV$1_priv3_0.D M23_0/pmosHV$1_priv3_0.D VDD sg13_hv_pmos ad=0.68p pd=4.68u as=0 ps=0 w=2u l=0.5u
X24 VSS.t37 VSS.t34 VSS.t36 VSS.t35 sg13_hv_nmos ad=0.68p pd=4.68u as=0 ps=0 w=2u l=0.5u
X25 VSS.t58 vin M15_0/nmosHV$1_priv1_0.D VSS.t24 sg13_hv_nmos ad=0.19p pd=1.38u as=0.19p ps=1.38u w=1u l=0.5u
X26 M2_0/nmosHV$3_priv4_0.D M2_0/nmosHV$3_priv4_0.D VSS.t19 VSS.t18 sg13_hv_nmos ad=0.17p pd=1.68u as=0.17p ps=1.68u w=0.5u l=0.5u
X27 VDD M24_0/pmosHV$1_priv4_0.D vout VDD sg13_hv_pmos ad=0.38p pd=2.38u as=0.68p ps=4.68u w=2u l=0.5u
X28 VDD M24_0/pmosHV$1_priv4_0.D vout VDD sg13_hv_pmos ad=0.38p pd=2.38u as=0.38p ps=2.38u w=2u l=0.5u
X29 M20_0/nmosHV$5_priv2_0.D M20_0/nmosHV$5_priv2_0.D VSS.t11 VSS.t12 sg13_hv_nmos ad=0.68p pd=4.68u as=0.38p ps=2.38u w=2u l=0.5u
X30 M21_0/nmosHV$5_priv1_0.D M23_0/pmosHV$1_priv3_0.D VDD VSS.t22 sg13_hv_nmos ad=0.51p pd=3.68u as=0.51p ps=3.68u w=1.5u l=0.5u
X31 M22_0/pmosHV$1_priv2_0.D M22_0/pmosHV$1_priv2_0.D VDD VDD sg13_hv_pmos ad=0.38p pd=2.38u as=0.38p ps=2.38u w=2u l=0.5u
X32 M22_0/pmosHV$1_priv2_0.D M22_0/pmosHV$1_priv2_0.D VDD VDD sg13_hv_pmos ad=0.68p pd=4.68u as=0.38p ps=2.38u w=2u l=0.5u
X33 VDD M24_0/pmosHV$1_priv4_0.D M24_0/pmosHV$1_priv4_0.D VDD sg13_hv_pmos ad=0.38p pd=2.38u as=0.38p ps=2.38u w=2u l=0.5u
X34 VSS.t70 vin M15_0/nmosHV$1_priv1_0.D VSS.t24 sg13_hv_nmos ad=0.19p pd=1.38u as=0.19p ps=1.38u w=1u l=0.5u
X35 M21_0/nmosHV$5_priv1_0.D M21_0/nmosHV$5_priv1_0.D M21_0/nmosHV$5_priv1_0.D VSS.t1 sg13_hv_nmos ad=0.68p pd=4.68u as=16.6844p ps=93.14999u w=2u l=0.5u
X36 VSS.t72 vin M15_0/nmosHV$1_priv1_0.D VSS.t24 sg13_hv_nmos ad=0.19p pd=1.38u as=0.34p ps=2.68u w=1u l=0.5u
X37 VDD M24_0/pmosHV$1_priv4_0.D M24_0/pmosHV$1_priv4_0.D VDD sg13_hv_pmos ad=0.38p pd=2.38u as=0.38p ps=2.38u w=2u l=0.5u
X38 M16_0/nmosHV$2_priv1_0.D VDD VSS.t31 rhigh l=0.20002m w=2u
X39 VSS.t2 M21_0/nmosHV$5_priv1_0.D vout VDD sg13_hv_pmos ad=0.238p pd=2.08u as=0.238p ps=2.08u w=0.7u l=0.5u
X40 M15_0/nmosHV$1_priv1_0.D vin VSS.t64 VSS.t24 sg13_hv_nmos ad=0.19p pd=1.38u as=0.19p ps=1.38u w=1u l=0.5u
X41 vin M16_0/nmosHV$2_priv1_0.D VSS.t27 rhigh l=40u w=2u
X42 M20_0/nmosHV$5_priv2_0.D VDD VSS.t21 rhigh l=0.20002m w=2u
X43 VSS.t55 VSS.t53 VSS.t54 VSS.t24 sg13_hv_nmos ad=0.34p pd=2.68u as=0 ps=0 w=1u l=0.5u
X44 VDD M22_0/pmosHV$1_priv2_0.D M22_0/pmosHV$1_priv2_0.D VDD sg13_hv_pmos ad=0.38p pd=2.38u as=0.38p ps=2.38u w=2u l=0.5u
X45 VDD M22_0/pmosHV$1_priv2_0.D M22_0/pmosHV$1_priv2_0.D VDD sg13_hv_pmos ad=0.38p pd=2.38u as=0.38p ps=2.38u w=2u l=0.5u
X46 M2_0/nmosHV$3_priv4_0.D M2_0/nmosHV$3_priv4_0.D M2_0/nmosHV$3_priv4_0.D VSS.t18 sg13_hv_nmos ad=0.17p pd=1.68u as=14.44555p ps=50.73u w=0.5u l=0.5u
X47 vout VDD M15_0/nmosHV$1_priv1_0.D VSS.t23 sg13_hv_nmos ad=0.34p pd=2.68u as=0.19p ps=1.38u w=1u l=0.5u
X48 VDD M24_0/pmosHV$1_priv4_0.D vout VDD sg13_hv_pmos ad=0.38p pd=2.38u as=0.38p ps=2.38u w=2u l=0.5u
X49 VSS.t68 vin M15_0/nmosHV$1_priv1_0.D VSS.t24 sg13_hv_nmos ad=0.19p pd=1.38u as=0.19p ps=1.38u w=1u l=0.5u
X50 VDD VDD VDD VDD sg13_hv_pmos ad=0.68p pd=4.68u as=0.29501n ps=0.5219m w=2u l=0.5u
X51 VDD VDD VDD VDD sg13_hv_pmos ad=0.68p pd=4.68u as=0 ps=0 w=2u l=0.5u
X52 VDD M24_0/pmosHV$1_priv4_0.D vout VDD sg13_hv_pmos ad=0.68p pd=4.68u as=0.38p ps=2.38u w=2u l=0.5u
X53 M21_0/nmosHV$5_priv1_0.D M20_0/nmosHV$5_priv2_0.D VSS.t4 VSS.t1 sg13_hv_nmos ad=0.38p pd=2.38u as=0.68p ps=4.68u w=2u l=0.5u
X54 VSS.t19 VSS.t19 VSS.t19 VSS.t18 sg13_hv_nmos ad=0.17p pd=1.68u as=0 ps=0 w=0.5u l=0.5u
X55 M21_0/nmosHV$5_priv1_0.D M20_0/nmosHV$5_priv2_0.D VSS.t14 VSS.t1 sg13_hv_nmos ad=0.38p pd=2.38u as=0.38p ps=2.38u w=2u l=0.5u
X56 M21_0/nmosHV$5_priv1_0.D M21_0/nmosHV$5_priv1_0.D M21_0/nmosHV$5_priv1_0.D VSS.t0 sg13_hv_nmos ad=0.51p pd=3.68u as=0 ps=0 w=1.5u l=0.5u
X57 VSS.t56 vin M15_0/nmosHV$1_priv1_0.D VSS.t24 sg13_hv_nmos ad=0.19p pd=1.38u as=0.19p ps=1.38u w=1u l=0.5u
X58 VDD M24_0/pmosHV$1_priv4_0.D M24_0/pmosHV$1_priv4_0.D VDD sg13_hv_pmos ad=0.68p pd=4.68u as=0.38p ps=2.38u w=2u l=0.5u
X59 M20_0/nmosHV$5_priv2_0.D M20_0/nmosHV$5_priv2_0.D M20_0/nmosHV$5_priv2_0.D VSS.t13 sg13_hv_nmos ad=0.68p pd=4.68u as=37.62435p ps=0.10861m w=2u l=0.5u
X60 VSS.t19 M2_0/nmosHV$3_priv4_0.D vout VSS.t18 sg13_hv_nmos ad=0.17p pd=1.68u as=0.17p ps=1.68u w=0.5u l=0.5u
X61 VDD M22_0/pmosHV$1_priv2_0.D M22_0/pmosHV$1_priv2_0.D VDD sg13_hv_pmos ad=0.38p pd=2.38u as=0.38p ps=2.38u w=2u l=0.5u
X62 M15_0/nmosHV$1_priv1_0.D VDD vout VSS.t23 sg13_hv_nmos ad=0.19p pd=1.38u as=0.34p ps=2.68u w=1u l=0.5u
X63 VDD VDD VDD VDD sg13_hv_pmos ad=0.68p pd=4.68u as=0 ps=0 w=2u l=0.5u
X64 M22_0/pmosHV$1_priv2_0.D VSS.t26 VSS.t25 rhigh l=15.02u w=2u
X65 VSS.t42 VSS.t40 VSS.t41 VDD sg13_hv_pmos ad=0.238p pd=2.08u as=0 ps=0 w=0.7u l=0.5u
X66 VDD M2_0/nmosHV$3_priv4_0.D VSS.t3 rhigh l=0.24997m w=2u
X67 VDD VDD VDD VSS.t22 sg13_hv_nmos ad=0.51p pd=3.68u as=0 ps=0 w=1.5u l=0.5u
X68 vout M24_0/pmosHV$1_priv4_0.D VDD VDD sg13_hv_pmos ad=0.38p pd=2.38u as=0.38p ps=2.38u w=2u l=0.5u
X69 M15_0/nmosHV$1_priv1_0.D vin VSS.t62 VSS.t24 sg13_hv_nmos ad=0.19p pd=1.38u as=0.19p ps=1.38u w=1u l=0.5u
X70 VSS.t14 M20_0/nmosHV$5_priv2_0.D M21_0/nmosHV$5_priv1_0.D VSS.t1 sg13_hv_nmos ad=0.38p pd=2.38u as=0.38p ps=2.38u w=2u l=0.5u
X71 M24_0/pmosHV$1_priv4_0.D M24_0/pmosHV$1_priv4_0.D VDD VDD sg13_hv_pmos ad=0.38p pd=2.38u as=0.38p ps=2.38u w=2u l=0.5u
X72 vout vout vout VDD sg13_hv_pmos ad=0.238p pd=2.08u as=0 ps=0 w=0.7u l=0.5u
X73 M24_0/pmosHV$1_priv4_0.D M24_0/pmosHV$1_priv4_0.D VDD VDD sg13_hv_pmos ad=0.38p pd=2.38u as=0.38p ps=2.38u w=2u l=0.5u
X74 M22_0/pmosHV$1_priv2_0.D M22_0/pmosHV$1_priv2_0.D VDD VDD sg13_hv_pmos ad=0.38p pd=2.38u as=0.68p ps=4.68u w=2u l=0.5u
X75 M22_0/pmosHV$1_priv2_0.D M22_0/pmosHV$1_priv2_0.D VDD VDD sg13_hv_pmos ad=0.38p pd=2.38u as=0.38p ps=2.38u w=2u l=0.5u
X76 M23_0/pmosHV$1_priv3_0.D M22_0/pmosHV$1_priv2_0.D VDD VDD sg13_hv_pmos ad=0.38p pd=2.38u as=0.38p ps=2.38u w=2u l=0.5u
X77 VSS.t64 vin M15_0/nmosHV$1_priv1_0.D VSS.t24 sg13_hv_nmos ad=0.19p pd=1.38u as=0.19p ps=1.38u w=1u l=0.5u
X78 M23_0/pmosHV$1_priv3_0.D M22_0/pmosHV$1_priv2_0.D VDD VDD sg13_hv_pmos ad=0.68p pd=4.68u as=0.38p ps=2.38u w=2u l=0.5u
X79 M20_0/nmosHV$5_priv2_0.D M20_0/nmosHV$5_priv2_0.D VSS.t6 VSS.t5 sg13_hv_nmos ad=0.38p pd=2.38u as=0.68p ps=4.68u w=2u l=0.5u
X80 M16_0/nmosHV$2_priv1_0.D M16_0/nmosHV$2_priv1_0.D VSS.t29 VSS.t28 sg13_hv_nmos ad=0.34p pd=2.68u as=0.19p ps=1.38u w=1u l=0.5u
X81 M20_0/nmosHV$5_priv2_0.D M20_0/nmosHV$5_priv2_0.D VSS.t8 VSS.t9 sg13_hv_nmos ad=0.38p pd=2.38u as=0.38p ps=2.38u w=2u l=0.5u
X82 VSS.t66 vin M15_0/nmosHV$1_priv1_0.D VSS.t24 sg13_hv_nmos ad=0.19p pd=1.38u as=0.19p ps=1.38u w=1u l=0.5u
X83 M22_0/pmosHV$1_priv2_0.D M22_0/pmosHV$1_priv2_0.D M22_0/pmosHV$1_priv2_0.D VDD sg13_hv_pmos ad=0.68p pd=4.68u as=35.2356p ps=0.14882m w=2u l=0.5u
X84 VSS.t19 VSS.t19 VSS.t19 VSS.t18 sg13_hv_nmos ad=0.17p pd=1.68u as=0 ps=0 w=0.5u l=0.5u
X85 VSS.t38 vout M23_0/pmosHV$1_priv3_0.D VSS.t22 sg13_hv_nmos ad=0.17p pd=1.68u as=0.17p ps=1.68u w=0.5u l=0.5u
X86 VDD M22_0/pmosHV$1_priv2_0.D M23_0/pmosHV$1_priv3_0.D VDD sg13_hv_pmos ad=0.38p pd=2.38u as=0.38p ps=2.38u w=2u l=0.5u
X87 VSS.t29 M16_0/nmosHV$2_priv1_0.D M16_0/nmosHV$2_priv1_0.D VSS.t28 sg13_hv_nmos ad=0.19p pd=1.38u as=0.34p ps=2.68u w=1u l=0.5u
X88 VSS.t52 VSS.t50 VSS.t51 VSS.t28 sg13_hv_nmos ad=0.34p pd=2.68u as=0 ps=0 w=1u l=0.5u
X89 M15_0/nmosHV$1_priv1_0.D vin VSS.t60 VSS.t24 sg13_hv_nmos ad=0.19p pd=1.38u as=0.19p ps=1.38u w=1u l=0.5u
X90 VDD M22_0/pmosHV$1_priv2_0.D M23_0/pmosHV$1_priv3_0.D VDD sg13_hv_pmos ad=0.38p pd=2.38u as=0.38p ps=2.38u w=2u l=0.5u
X91 M15_0/nmosHV$1_priv1_0.D M15_0/nmosHV$1_priv1_0.D M15_0/nmosHV$1_priv1_0.D VSS.t23 sg13_hv_nmos ad=0.34p pd=2.68u as=0 ps=0 w=1u l=0.5u
X92 vout vout vout VSS.t18 sg13_hv_nmos ad=0.17p pd=1.68u as=0 ps=0 w=0.5u l=0.5u
X93 VSS.t8 M20_0/nmosHV$5_priv2_0.D M20_0/nmosHV$5_priv2_0.D VSS.t7 sg13_hv_nmos ad=0.38p pd=2.38u as=0.38p ps=2.38u w=2u l=0.5u
X94 M15_0/nmosHV$1_priv1_0.D vin VSS.t58 VSS.t24 sg13_hv_nmos ad=0.19p pd=1.38u as=0.19p ps=1.38u w=1u l=0.5u
X95 vout M24_0/pmosHV$1_priv4_0.D VDD VDD sg13_hv_pmos ad=0.38p pd=2.38u as=0.38p ps=2.38u w=2u l=0.5u
X96 M15_0/nmosHV$1_priv1_0.D vin VSS.t70 VSS.t24 sg13_hv_nmos ad=0.19p pd=1.38u as=0.19p ps=1.38u w=1u l=0.5u
X97 VDD VDD VDD VDD sg13_hv_pmos ad=0.68p pd=4.68u as=0 ps=0 w=2u l=0.5u
X98 VSS.t16 M20_0/nmosHV$5_priv2_0.D M21_0/nmosHV$5_priv1_0.D VSS.t1 sg13_hv_nmos ad=0.38p pd=2.38u as=0.38p ps=2.38u w=2u l=0.5u
R0 VSS.n82 VSS.t32 22867.4
R1 VSS.n83 VSS.t39 2499.34
R2 VSS.n82 VSS.t18 1700.39
R3 VSS.n76 VSS.t31 1385.32
R4 VSS.t1 VSS.n45 1370.49
R5 VSS.t3 VSS.t13 1021.88
R6 VSS.t0 VSS.t3 740.625
R7 VSS.t31 VSS.t25 630.749
R8 VSS.t24 VSS.n81 520.222
R9 VSS.t25 VSS.t1 411.865
R10 VSS.t23 VSS.t24 277.147
R11 VSS.n80 VSS.t28 229.363
R12 VSS.t39 VSS.t22 221.25
R13 VSS.t28 VSS.n79 196.123
R14 VSS.n73 VSS.n45 190.47
R15 VSS.t5 VSS.t35 171.095
R16 VSS.t13 VSS.t12 171.095
R17 VSS.t35 VSS.n73 132.656
R18 VSS.t22 VSS.t0 118.126
R19 VSS.t7 VSS.t5 82.5005
R20 VSS.t9 VSS.t7 82.5005
R21 VSS.t10 VSS.t9 82.5005
R22 VSS.t12 VSS.t10 82.5005
R23 VSS.t32 VSS.t23 46.9534
R24 VSS.n17 VSS.t29 28.0665
R25 VSS.n73 VSS.t21 21.4821
R26 VSS.n77 VSS.n76 19.1141
R27 VSS.n79 VSS.n74 19.1141
R28 VSS.n81 VSS.t27 18.283
R29 VSS.n72 VSS.t2 18.0005
R30 VSS.n3 VSS.t54 5.63547
R31 VSS.n9 VSS.n8 0.0433338
R32 VSS.t21 VSS.t26 15.3262
R33 VSS.n26 VSS.t41 0.0484151
R34 VSS.n2 VSS.t53 7.48191
R35 VSS.n26 VSS.t40 7.49
R36 VSS.n7 VSS.t34 7.50949
R37 VSS.n4 VSS.n5 0.063656
R38 VSS.n9 VSS.t50 7.50308
R39 VSS.t26 VSS.n45 14.9488
R40 VSS.n12 VSS.n29 13.5683
R41 VSS.t27 VSS.n80 9.9728
R42 VSS.t38 VSS.n70 9.5943
R43 VSS.n72 VSS.n70 9.3655
R44 VSS.t11 VSS.n39 9.177
R45 VSS.t16 VSS.n35 9.177
R46 VSS.n77 VSS.n74 9.14177
R47 VSS.n135 VSS.n133 9.0005
R48 VSS.n137 VSS.n136 9.0005
R49 VSS.n132 VSS.n131 9.0005
R50 VSS.n139 VSS.n138 9.0005
R51 VSS.n140 VSS.n129 9.0005
R52 VSS.n142 VSS.n141 9.0005
R53 VSS.n142 VSS.n130 9.0005
R54 VSS.t70 VSS.n129 9.0005
R55 VSS.n138 VSS.t68 9.0005
R56 VSS.t66 VSS.n132 9.0005
R57 VSS.t64 VSS.n137 9.0005
R58 VSS.n133 VSS.t62 9.0005
R59 VSS.n134 VSS.t60 9.0005
R60 VSS.t58 VSS.n14 0.0645828
R61 VSS.n130 VSS.t72 9.0005
R62 VSS.n43 VSS.n42 9.0005
R63 VSS.n41 VSS.n34 9.0005
R64 VSS.n41 VSS.n40 9.0005
R65 VSS.t8 VSS.n38 9.0005
R66 VSS.t14 VSS.n36 9.0005
R67 VSS.n42 VSS.n37 9.0005
R68 VSS.n37 VSS.t4 9.0005
R69 VSS.n40 VSS.t6 9.0005
R70 VSS.t19 VSS.n84 8.7643
R71 VSS.n75 VSS.n74 8.5005
R72 VSS.n76 VSS.n75 8.5005
R73 VSS.n79 VSS.n78 8.5005
R74 VSS.n78 VSS.n77 8.5005
R75 VSS.n81 VSS.n29 8.5005
R76 VSS.n80 VSS.n29 8.5005
R77 VSS.n84 VSS.n83 8.5005
R78 VSS.n7 VSS.n6 0.063656
R79 VSS.n7 VSS.t37 2.84339
R80 VSS.n6 VSS.t36 2.81267
R81 VSS.n5 VSS.t45 2.84339
R82 VSS.n4 VSS.t44 2.81267
R83 VSS.n2 VSS.n3 0.0434444
R84 VSS.t52 VSS.n8 5.65115
R85 VSS.n9 VSS.t51 5.67867
R86 VSS.t42 VSS.t41 8.4902
R87 VSS.n83 VSS.n82 7.64381
R88 VSS.n126 VSS.n30 5.05801
R89 VSS.n43 VSS.n35 4.853
R90 VSS.n39 VSS.n34 4.853
R91 VSS.n15 VSS.n14 4.55016
R92 VSS.n78 VSS.n30 4.50285
R93 VSS.n75 VSS.n30 4.24341
R94 VSS.n128 VSS.n11 3.0638
R95 VSS.n18 VSS.n20 0.0936048
R96 VSS.n10 VSS.n28 3.0005
R97 VSS.n127 VSS.n12 3.0005
R98 VSS.n124 VSS.n123 3.0005
R99 VSS.n125 VSS.n16 3.0005
R100 VSS.n119 VSS.n32 3.0005
R101 VSS.n121 VSS.n120 3.0005
R102 VSS.n122 VSS.n31 3.0005
R103 VSS.n116 VSS.n33 3.0005
R104 VSS.n118 VSS.n117 3.0005
R105 VSS.n1 VSS.t26 0.44998
R106 VSS.n115 VSS.n114 3.0005
R107 VSS.n110 VSS.n109 3.0005
R108 VSS.n111 VSS.n47 3.0005
R109 VSS.n113 VSS.n112 3.0005
R110 VSS.n0 VSS.n46 3.0005
R111 VSS.n93 VSS.n53 3.0005
R112 VSS.n102 VSS.n50 3.0005
R113 VSS.n108 VSS.n48 3.0005
R114 VSS.n107 VSS.n106 3.0005
R115 VSS.n105 VSS.n49 3.0005
R116 VSS.n104 VSS.n103 3.0005
R117 VSS.n101 VSS.n100 3.0005
R118 VSS.n99 VSS.n51 3.0005
R119 VSS.n98 VSS.n97 3.0005
R120 VSS.n96 VSS.n52 3.0005
R121 VSS.n95 VSS.n94 3.0005
R122 VSS.n86 VSS.n85 3.0005
R123 VSS.n87 VSS.n55 3.0005
R124 VSS.n89 VSS.n88 3.0005
R125 VSS.n90 VSS.n54 3.0005
R126 VSS.n92 VSS.n91 3.0005
R127 VSS.n23 VSS.n25 3.0005
R128 VSS.n24 VSS.n21 3.0005
R129 VSS.n61 VSS.n58 3.0005
R130 VSS.n63 VSS.n62 3.0005
R131 VSS.n64 VSS.n57 3.0005
R132 VSS.n66 VSS.n65 3.0005
R133 VSS.n67 VSS.n56 3.0005
R134 VSS.n69 VSS.n68 3.0005
R135 VSS.n60 VSS.n59 3.0005
R136 VSS.n20 VSS.n27 3.0005
R137 VSS.n17 VSS.n126 2.2505
R138 VSS.n22 VSS.t19 2.2505
R139 VSS.t26 VSS.n44 2.0165
R140 VSS.n18 VSS.n13 1.03187
R141 VSS.t72 VSS.n2 1.2585
R142 VSS.t29 VSS.n8 1.2585
R143 VSS.n42 VSS.n41 1.0935
R144 VSS.n40 VSS.n37 1.0935
R145 VSS.n44 VSS.n34 0.9645
R146 VSS.n84 VSS.t18 0.736079
R147 VSS.t6 VSS.n6 0.653499
R148 VSS.t4 VSS.n4 0.653499
R149 VSS.n22 VSS.n70 0.628233
R150 VSS.t19 VSS.n71 0.628233
R151 VSS.n71 VSS.t38 0.5943
R152 VSS.n68 VSS.n67 0.527465
R153 VSS.n69 VSS.n56 0.527465
R154 VSS.n127 VSS.n28 0.461724
R155 VSS.n66 VSS.n57 0.446194
R156 VSS.n65 VSS.n64 0.446194
R157 VSS.n109 VSS.n108 0.406853
R158 VSS.n110 VSS.n48 0.406853
R159 VSS.n60 VSS.n13 0.3943
R160 VSS.n59 VSS.n20 0.3943
R161 VSS.n12 VSS.n10 0.389771
R162 VSS.n71 VSS.n72 0.3655
R163 VSS.n41 VSS.n38 0.3525
R164 VSS.n42 VSS.n36 0.3525
R165 VSS.n37 VSS.t14 0.3525
R166 VSS.t14 VSS.t16 0.3525
R167 VSS.n40 VSS.t8 0.3525
R168 VSS.t8 VSS.t11 0.3525
R169 VSS.n89 VSS.n55 0.350947
R170 VSS.n88 VSS.n87 0.350947
R171 VSS.n126 VSS.n28 0.350947
R172 VSS.n123 VSS.n16 0.349394
R173 VSS.n125 VSS.n124 0.349394
R174 VSS.n109 VSS.n47 0.345771
R175 VSS.n111 VSS.n110 0.345771
R176 VSS.n97 VSS.n51 0.338006
R177 VSS.n99 VSS.n98 0.338006
R178 VSS.n121 VSS.n32 0.328171
R179 VSS.n120 VSS.n119 0.328171
R180 VSS.n113 VSS.n47 0.326618
R181 VSS.n112 VSS.n111 0.326618
R182 VSS.n101 VSS.n51 0.315229
R183 VSS.n85 VSS.n55 0.315229
R184 VSS.n87 VSS.n86 0.315229
R185 VSS.n100 VSS.n99 0.315229
R186 VSS.n17 VSS.n16 0.312124
R187 VSS.n126 VSS.n125 0.312124
R188 VSS.n122 VSS.n121 0.309535
R189 VSS.n120 VSS.n31 0.309535
R190 VSS.n67 VSS.n66 0.307465
R191 VSS.n65 VSS.n56 0.307465
R192 VSS.n68 VSS.n21 0.300735
R193 VSS.n24 VSS.n69 0.300735
R194 VSS.n115 VSS.t26 0.296076
R195 VSS.n117 VSS.n32 0.294524
R196 VSS.n119 VSS.n118 0.294524
R197 VSS.n62 VSS.n61 0.292453
R198 VSS.n63 VSS.n58 0.292453
R199 VSS.n128 VSS.n127 0.289069
R200 VSS.n117 VSS.n116 0.287794
R201 VSS.n118 VSS.n33 0.287794
R202 VSS.n62 VSS.n57 0.286241
R203 VSS.n64 VSS.n63 0.286241
R204 VSS.n108 VSS.n107 0.281582
R205 VSS.n106 VSS.n48 0.281582
R206 VSS.n96 VSS.n95 0.275371
R207 VSS.n94 VSS.n52 0.275371
R208 VSS.n97 VSS.n96 0.273818
R209 VSS.n98 VSS.n52 0.273818
R210 VSS.n90 VSS.n89 0.270712
R211 VSS.n88 VSS.n54 0.270712
R212 VSS.n123 VSS.n122 0.267606
R213 VSS.n124 VSS.n31 0.267606
R214 VSS.n116 VSS.n115 0.256735
R215 VSS.n114 VSS.n33 0.256735
R216 VSS.n61 VSS.n60 0.240688
R217 VSS.n59 VSS.n58 0.240688
R218 VSS.n130 VSS.n27 0.233481
R219 VSS.n0 VSS.n113 0.230853
R220 VSS.n1 VSS.n46 0.648281
R221 VSS.n112 VSS.n46 0.230853
R222 VSS.n91 VSS.n53 0.218429
R223 VSS.n93 VSS.n92 0.218429
R224 VSS.n23 VSS.n21 0.217394
R225 VSS.n25 VSS.n24 0.217394
R226 VSS.n102 VSS.n101 0.212735
R227 VSS.n100 VSS.n50 0.212735
R228 VSS.n103 VSS.n102 0.210147
R229 VSS.n104 VSS.n50 0.210147
R230 VSS.n103 VSS.n49 0.2029
R231 VSS.n105 VSS.n104 0.2029
R232 VSS.n91 VSS.n90 0.201347
R233 VSS.n92 VSS.n54 0.201347
R234 VSS.n114 VSS.n1 0.667124
R235 VSS.n27 VSS.t33 0.187888
R236 VSS.n36 VSS.n35 0.170376
R237 VSS.n39 VSS.n38 0.170376
R238 VSS.n107 VSS.n49 0.166147
R239 VSS.n106 VSS.n105 0.166147
R240 VSS.n95 VSS.n53 0.157347
R241 VSS.n94 VSS.n93 0.157347
R242 VSS.n19 VSS.n142 0.156987
R243 VSS.t33 VSS.n18 1.55187
R244 VSS.n19 VSS.n128 0.144149
R245 VSS.n85 VSS.n23 0.143888
R246 VSS.n86 VSS.n25 0.143888
R247 VSS.n141 VSS 0.143836
R248 VSS.n44 VSS.n43 0.1295
R249 VSS.n142 VSS.n129 0.129031
R250 VSS.n138 VSS.n129 0.129031
R251 VSS.n138 VSS.n132 0.129031
R252 VSS.n137 VSS.n132 0.129031
R253 VSS.n137 VSS.n133 0.129031
R254 VSS.n134 VSS.n133 0.129031
R255 VSS.t70 VSS.n130 0.129031
R256 VSS.t68 VSS.t70 0.129031
R257 VSS.t68 VSS.t66 0.129031
R258 VSS.t66 VSS.t64 0.129031
R259 VSS.t64 VSS.t62 0.129031
R260 VSS.t60 VSS.t62 0.129031
R261 VSS.t60 VSS.t58 0.129031
R262 VSS.n14 VSS.t56 0.0650403
R263 VSS.n141 VSS.n140 0.129031
R264 VSS.n140 VSS.n139 0.129031
R265 VSS.n139 VSS.n131 0.129031
R266 VSS.n136 VSS.n131 0.129031
R267 VSS.n136 VSS.n135 0.129031
R268 VSS.n135 VSS.n15 3.14379
R269 VSS.n26 VSS.t2 0.701254
R270 VSS.t19 VSS.n25 0.104892
R271 VSS.n23 VSS.n22 0.104892
R272 VSS.t43 VSS.n5 7.50949
R273 VSS.n12 VSS.n11 0.361022
R274 VSS.n10 VSS.n17 0.350947
R275 VSS.n134 VSS.n15 0.126278
R276 VSS VSS.n11 0.158265
R277 VSS.n20 VSS.n19 0.14286
R278 VSS VSS.n13 0.142335
R279 VSS.n3 VSS.t55 5.73663
R280 VSS.t26 VSS.n0 1.16766
C0 M20_0/nmosHV$5_priv2_0.D M21_0/nmosHV$5_priv1_0.D 2.22862f
C1 a_8207_7790# a_7583_7790# 0.01052f
C2 a_6759_7424# M23_0/pmosHV$1_priv3_0.D 0.0394f
C3 VDD vout 8.08359f
C4 M23_0/pmosHV$1_priv3_0.D M21_0/nmosHV$5_priv1_0.D 2.07569f
C5 M24_0/pmosHV$1_priv4_0.D a_7460_4316# 0.02126f
C6 M15_0/nmosHV$1_priv1_0.D a_8820_3670# 0.12199f
C7 M15_0/nmosHV$1_priv1_0.D a_9487_4524# 0.09472f
C8 a_9487_5065# a_7460_4316# 0.01408f
C9 a_4947_8472# VDD 0.14771f
C10 vin a_7460_4316# 0.0897f
C11 VDD M2_0/nmosHV$3_priv4_0.D 0.61332f
C12 vin a_2964_1402# 0.04877f
C13 a_6759_7424# VDD 0.1371f
C14 a_4947_8472# vout 0.02426f
C15 VDD M21_0/nmosHV$5_priv1_0.D 0.91005f
C16 M2_0/nmosHV$3_priv4_0.D vout 1.32757f
C17 a_1883_8256# a_443_8992# 0.01464f
C18 a_2953_8256# a_443_8992# 0.01464f
C19 M24_0/pmosHV$1_priv4_0.D a_10328_7221# 0.03987f
C20 a_10328_5800# VDD 0.23422f
C21 a_4947_8472# M2_0/nmosHV$3_priv4_0.D 0.16185f
C22 a_2954_7333# M21_0/nmosHV$5_priv1_0.D 0.15975f
C23 vout M21_0/nmosHV$5_priv1_0.D 2.07206f
C24 a_4380_6488# VDD 0.3942f
C25 M16_0/nmosHV$2_priv1_0.D a_6948_322# 0.14061f
C26 a_8872_7423# a_9395_7424# 0.01289f
C27 a_10328_5800# vout 0.15099f
C28 vin M16_0/nmosHV$2_priv1_0.D 0.49192f
C29 a_4947_8472# M21_0/nmosHV$5_priv1_0.D 0.43619f
C30 M24_0/pmosHV$1_priv4_0.D VDD 11.7361f
C31 M2_0/nmosHV$3_priv4_0.D M21_0/nmosHV$5_priv1_0.D 0.51067f
C32 vin a_8820_313# 0.03816f
C33 VDD a_9487_5065# 0.05468f
C34 vin VDD 0.02653f
C35 vin m2_5626_n720# 0.01496f
C36 a_7583_7790# a_6759_7790# 0.01052f
C37 M24_0/pmosHV$1_priv4_0.D vout 2.39539f
C38 M20_0/nmosHV$5_priv2_0.D a_1883_8256# 0.04424f
C39 M20_0/nmosHV$5_priv2_0.D a_2953_8256# 0.19696f
C40 a_9487_5065# vout 0.10887f
C41 VDD a_10328_4960# 0.38019f
C42 M15_0/nmosHV$1_priv1_0.D a_7460_4316# 0.13771f
C43 a_9487_4524# a_7460_4316# 0.01408f
C44 M24_0/pmosHV$1_priv4_0.D M2_0/nmosHV$3_priv4_0.D 0.04733f
C45 M22_0/pmosHV$1_priv2_0.D a_4380_7312# 0.04427f
C46 a_2964_1402# M15_0/nmosHV$1_priv1_0.D 0.03799f
C47 M2_0/nmosHV$3_priv4_0.D a_9395_7790# 0.03745f
C48 a_5801_7312# M22_0/pmosHV$1_priv2_0.D 0.21591f
C49 a_8207_7790# VDD 0.10331f
C50 M24_0/pmosHV$1_priv4_0.D a_10328_5800# 0.04009f
C51 a_8207_7424# a_8872_7423# 0.0104f
C52 M16_0/nmosHV$2_priv1_0.D M15_0/nmosHV$1_priv1_0.D 0.14762f
C53 a_1884_7333# a_1883_8256# 0.01044f
C54 a_8820_313# M15_0/nmosHV$1_priv1_0.D 0.03229f
C55 a_2954_7333# a_2953_8256# 0.01044f
C56 M15_0/nmosHV$1_priv1_0.D VDD 2.65165f
C57 a_2964_1402# M22_0/pmosHV$1_priv2_0.D 0.04136f
C58 M20_0/nmosHV$5_priv2_0.D a_443_8992# 0.64018f
C59 a_9487_4524# VDD 0.04104f
C60 vin M24_0/pmosHV$1_priv4_0.D 0.0979f
C61 M20_0/nmosHV$5_priv2_0.D M22_0/pmosHV$1_priv2_0.D 0.26211f
C62 a_8872_7789# M2_0/nmosHV$3_priv4_0.D 0.11653f
C63 M24_0/pmosHV$1_priv4_0.D a_10328_4960# 0.04219f
C64 M15_0/nmosHV$1_priv1_0.D vout 0.78168f
C65 VDD a_10328_3538# 0.21093f
C66 a_8207_7790# M21_0/nmosHV$5_priv1_0.D 0.03711f
C67 a_9487_4524# vout 0.02732f
C68 M23_0/pmosHV$1_priv3_0.D M22_0/pmosHV$1_priv2_0.D 2.49299f
C69 a_9395_7424# VDD 0.01071f
C70 vout a_7583_7790# 0.03634f
C71 M23_0/pmosHV$1_priv3_0.D a_6759_7790# 0.03902f
C72 a_7583_7424# a_8207_7424# 0.01052f
C73 a_2964_1402# a_7460_4316# 0.24633f
C74 a_9395_7424# vout 0.08848f
C75 M22_0/pmosHV$1_priv2_0.D a_1114_5562# 0.07479f
C76 VDD a_4380_7312# 0.37348f
C77 a_5802_6488# M22_0/pmosHV$1_priv2_0.D 0.0413f
C78 VDD a_443_8992# 1.65111f
C79 M22_0/pmosHV$1_priv2_0.D VDD 11.9588f
C80 a_7583_7424# M23_0/pmosHV$1_priv3_0.D 0.0883f
C81 a_8872_7423# M2_0/nmosHV$3_priv4_0.D 0.03988f
C82 a_5802_6488# a_5801_7312# 0.01286f
C83 M23_0/pmosHV$1_priv3_0.D a_7460_4316# 0.01212f
C84 a_6948_863# M16_0/nmosHV$2_priv1_0.D 0.0665f
C85 a_9395_7424# M2_0/nmosHV$3_priv4_0.D 0.03745f
C86 a_5801_7312# VDD 0.21572f
C87 M16_0/nmosHV$2_priv1_0.D a_7460_4316# 0.07775f
C88 a_4947_8472# a_443_8992# 0.87347f
C89 a_8872_7789# a_9395_7790# 0.01289f
C90 a_4947_8472# M22_0/pmosHV$1_priv2_0.D 0.16376f
C91 M16_0/nmosHV$2_priv1_0.D a_2964_1402# 0.33406f
C92 M24_0/pmosHV$1_priv4_0.D M15_0/nmosHV$1_priv1_0.D 0.11544f
C93 VDD a_7460_4316# 0.68572f
C94 a_9536_1001# M24_0/pmosHV$1_priv4_0.D 0.07959f
C95 vin M15_0/nmosHV$1_priv1_0.D 3.30877f
C96 vin a_8820_3670# 0.038f
C97 M20_0/nmosHV$5_priv2_0.D a_1114_5562# 0.03962f
C98 a_8207_7424# VDD 0.10511f
C99 a_2964_1402# VDD 1.26848f
C100 M21_0/nmosHV$5_priv1_0.D a_443_8992# 0.04177f
C101 vin a_9536_1001# 0.14651f
C102 M24_0/pmosHV$1_priv4_0.D a_10328_3538# 0.18809f
C103 M22_0/pmosHV$1_priv2_0.D M21_0/nmosHV$5_priv1_0.D 0.52109f
C104 M20_0/nmosHV$5_priv2_0.D VDD 0.14122f
C105 a_7583_7424# vout 0.03834f
C106 a_7460_4316# vout 0.48847f
C107 a_6759_7790# M21_0/nmosHV$5_priv1_0.D 0.13104f
C108 a_5802_6488# M23_0/pmosHV$1_priv3_0.D 0.15966f
C109 a_8207_7424# vout 0.09625f
C110 a_4380_6488# a_4380_7312# 0.01299f
C111 M20_0/nmosHV$5_priv2_0.D a_1884_7333# 0.04173f
C112 M20_0/nmosHV$5_priv2_0.D a_2954_7333# 0.04231f
C113 M23_0/pmosHV$1_priv3_0.D VDD 4.68445f
C114 a_4380_6488# M22_0/pmosHV$1_priv2_0.D 0.04083f
C115 a_8207_7790# a_8872_7789# 0.0104f
C116 VDD a_10328_7221# 0.36196f
C117 a_7583_7424# a_6759_7424# 0.01052f
C118 a_4947_8472# M20_0/nmosHV$5_priv2_0.D 0.05279f
C119 M23_0/pmosHV$1_priv3_0.D vout 1.71633f
C120 VDD a_1114_5562# 0.24165f
C121 a_10328_7221# vout 0.06029f
C122 a_5802_6488# VDD 0.22578f
C123 a_4947_8472# M23_0/pmosHV$1_priv3_0.D 0.02527f
C124 a_8207_7424# M21_0/nmosHV$5_priv1_0.D 0.03711f
C125 m2_5626_n720# VSS 0.74652f ; **FLOATING
C126 a_8820_313# VSS 0.24595f ; **FLOATING
C127 a_6948_322# VSS 0.16311f ; **FLOATING
C128 a_6948_863# VSS 0.23118f ; **FLOATING
C129 a_10328_3538# VSS 0.03087f ; **FLOATING
C130 a_8820_3670# VSS 0.15113f ; **FLOATING
C131 a_9487_4524# VSS 0.14504f ; **FLOATING
C132 a_10328_4960# VSS 0.02884f ; **FLOATING
C133 a_9487_5065# VSS 0.14509f ; **FLOATING
C134 a_10328_5800# VSS 0.0293f ; **FLOATING
C135 a_5802_6488# VSS 0.01148f ; **FLOATING
C136 a_4380_6488# VSS 0.01147f ; **FLOATING
C137 a_10328_7221# VSS 0.01894f ; **FLOATING
C138 a_9395_7424# VSS 0.1086f ; **FLOATING
C139 a_8872_7423# VSS 0.18276f ; **FLOATING
C140 a_8207_7424# VSS 0.0235f ; **FLOATING
C141 a_7583_7424# VSS 0.10819f ; **FLOATING
C142 a_6759_7424# VSS 0.18495f ; **FLOATING
C143 a_5801_7312# VSS 0.01107f ; **FLOATING
C144 a_9395_7790# VSS 0.19122f ; **FLOATING
C145 a_8872_7789# VSS 0.11484f ; **FLOATING
C146 a_8207_7790# VSS 0.11539f ; **FLOATING
C147 a_7583_7790# VSS 0.19118f ; **FLOATING
C148 a_6759_7790# VSS 0.19177f ; **FLOATING
C149 a_4380_7312# VSS 0.01152f ; **FLOATING
C150 a_2954_7333# VSS 0.23557f ; **FLOATING
C151 a_1884_7333# VSS 0.4136f ; **FLOATING
C152 M2_0/nmosHV$3_priv4_0.D VSS 26.0867f
C153 a_2953_8256# VSS 0.22376f ; **FLOATING
C154 a_1883_8256# VSS 0.39753f ; **FLOATING
C155 VSS.t26 VSS 1.92303f
C156 VSS.t33 VSS 2.04658f
C157 VSS.t29 VSS 12.58314f
C158 VSS.t16 VSS 5.7782f
C159 VSS.t4 VSS 10.36828f
C160 VSS.t72 VSS 6.23675f
C161 VSS.t68 VSS 2.17439f
.ends
