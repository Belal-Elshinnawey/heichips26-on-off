* PEX produced on Wed Sep  9 13:49:11 CEST 2026 using scripts/sak-pex.sh with m=3 and s=1 (extresist threshold=10000 mOhm, minres=1000 mOhm, mindelay=1 ps)
* NGSPICE file created from charge_pump_pex.ext - technology: ihp-sg13cmos5l

.subckt charge_pump_pex cp_cap_p cp_cap_m VSS VDD UP vout DN
X0 VDD VDD VDD VDD sg13_lv_pmos ad=0.68p pd=4.68u as=21.1572p ps=82.46u w=2u l=0.5u
X1 VDD VDD VDD VDD sg13_lv_pmos ad=0.68p pd=4.68u as=0 ps=0 w=2u l=0.5u
X2 GROUP2_0.nmos_priv2_0.D DN cp_cap_p VSS.t3 sg13_lv_nmos ad=0.11875p pd=1.005u as=0.2125p ps=1.93u w=0.625u l=0.5u
X3 VDD GROUP5_0.G GROUP5_0.G VDD sg13_lv_pmos ad=0.38p pd=2.38u as=0.38p ps=2.38u w=2u l=0.5u
X4 VDD GROUP5_0.G GROUP4_0.pmos$1_priv1_0.S VDD sg13_lv_pmos ad=0.38p pd=2.38u as=0.38p ps=2.38u w=2u l=0.5u
X5 VSS.t12 GROUP1_0.G GROUP2_0.nmos_priv2_0.D VSS.t6 sg13_lv_nmos ad=0.38p pd=2.38u as=0.38p ps=2.38u w=2u l=0.5u
X6 GROUP2_0.nmos_priv2_0.D GROUP1_0.G VSS.t12 VSS.t7 sg13_lv_nmos ad=0.68p pd=4.68u as=0.38p ps=2.38u w=2u l=0.5u
X7 cp_cap_p DN GROUP2_0.nmos_priv2_0.D VSS.t4 sg13_lv_nmos ad=0.11875p pd=1.005u as=0.11875p ps=1.005u w=0.625u l=0.5u
X8 GROUP2_0.nmos_priv2_0.D GROUP1_0.G VSS.t10 VSS.t4 sg13_lv_nmos ad=0.38p pd=2.38u as=0.38p ps=2.38u w=2u l=0.5u
X9 GROUP5_0.G GROUP5_0.G VDD VDD sg13_lv_pmos ad=0.38p pd=2.38u as=0.38p ps=2.38u w=2u l=0.5u
X10 GROUP4_0.pmos$1_priv1_0.S GROUP5_0.G VDD VDD sg13_lv_pmos ad=0.38p pd=2.38u as=0.38p ps=2.38u w=2u l=0.5u
X11 GROUP4_0.pmos$1_priv1_0.S GROUP5_0.G VDD VDD sg13_lv_pmos ad=0.38p pd=2.38u as=0.38p ps=2.38u w=2u l=0.5u
X12 cp_cap_p cp_cap_p cp_cap_p VDD sg13_lv_pmos ad=0.2142p pd=1.94u as=1.03461n ps=0.01256 w=0.63u l=0.5u
X13 GROUP5_0.G GROUP5_0.G VDD VDD sg13_lv_pmos ad=0.38p pd=2.38u as=0.38p ps=2.38u w=2u l=0.5u
X14 GROUP1_0.G GROUP1_0.G VSS.t5 VSS.t6 sg13_lv_nmos ad=0.38p pd=2.38u as=0.38p ps=2.38u w=2u l=0.5u
X15 VSS.t26 VSS.t24 VSS.t25 VSS.t0 sg13_lv_nmos ad=0.68p pd=4.68u as=0 ps=0 w=2u l=0.5u
X16 GROUP4_0.pmos$1_priv1_0.S UP cp_cap_p VDD sg13_lv_pmos ad=0.11875p pd=1.005u as=0.11875p ps=1.005u w=0.625u l=0.5u
X17 GROUP4_0.pmos$1_priv1_0.S GROUP4_0.pmos$1_priv1_0.S GROUP4_0.pmos$1_priv1_0.S VDD sg13_lv_pmos ad=0.2142p pd=1.94u as=7.052p ps=42.84u w=0.63u l=0.5u
X18 GROUP1_0.G GROUP1_0.G GROUP1_0.G VSS.t0 sg13_lv_nmos ad=0.68p pd=4.68u as=0.1098n ps=0.25428m w=2u l=0.5u
X19 VSS.t8 GROUP1_0.G GROUP1_0.G VSS.t7 sg13_lv_nmos ad=0.68p pd=4.68u as=0.38p ps=2.38u w=2u l=0.5u
X20 cp_cap_p UP GROUP4_0.pmos$1_priv1_0.S VDD sg13_lv_pmos ad=0.2125p pd=1.93u as=0.11875p ps=1.005u w=0.625u l=0.5u
X21 GROUP4_0.pmos$1_priv1_0.S GROUP4_0.pmos$1_priv1_0.S GROUP4_0.pmos$1_priv1_0.S VDD sg13_lv_pmos ad=0.68p pd=4.68u as=0 ps=0 w=2u l=0.5u
X22 GROUP5_0.G GROUP5_0.G GROUP5_0.G VDD sg13_lv_pmos ad=0.68p pd=4.68u as=37.5438p ps=0.11538m w=2u l=0.5u
X23 GROUP5_0.G VSS VSS.t17 rhigh l=0.27592m w=2u
X24 GROUP2_0.nmos_priv2_0.D DN cp_cap_p VSS.t6 sg13_lv_nmos ad=0.11875p pd=1.005u as=0.11875p ps=1.005u w=0.625u l=0.5u
X25 VSS.t23 VSS.t21 VSS.t22 VSS.t16 sg13_lv_nmos ad=0.68p pd=4.68u as=0 ps=0 w=2u l=0.5u
X26 VDD GROUP1_0.G VSS.t18 rhigh l=0.27592m w=2u
X27 VDD GROUP5_0.G GROUP4_0.pmos$1_priv1_0.S VDD sg13_lv_pmos ad=0.38p pd=2.38u as=0.38p ps=2.38u w=2u l=0.5u
X28 GROUP1_0.G GROUP1_0.G VSS.t2 VSS.t3 sg13_lv_nmos ad=0.38p pd=2.38u as=0.38p ps=2.38u w=2u l=0.5u
X29 cp_cap_p vout VSS.t14 rhigh l=28.76u w=2u
X30 VDD GROUP5_0.G GROUP5_0.G VDD sg13_lv_pmos ad=0.38p pd=2.38u as=0.38p ps=2.38u w=2u l=0.5u
X31 GROUP4_0.pmos$1_priv1_0.S UP cp_cap_p VDD sg13_lv_pmos ad=0.11875p pd=1.005u as=0.2125p ps=1.93u w=0.625u l=0.5u
X32 cp_cap_p DN GROUP2_0.nmos_priv2_0.D VSS.t7 sg13_lv_nmos ad=0.2125p pd=1.93u as=0.11875p ps=1.005u w=0.625u l=0.5u
X33 GROUP2_0.nmos_priv2_0.D GROUP1_0.G VSS.t9 VSS.t1 sg13_lv_nmos ad=0.38p pd=2.38u as=0.68p ps=4.68u w=2u l=0.5u
X34 GROUP2_0.nmos_priv2_0.D GROUP2_0.nmos_priv2_0.D GROUP2_0.nmos_priv2_0.D VSS.t16 sg13_lv_nmos ad=0.68p pd=4.68u as=6.6679p ps=37.8u w=2u l=0.5u
X35 VDD GROUP5_0.G GROUP4_0.pmos$1_priv1_0.S VDD sg13_lv_pmos ad=0.38p pd=2.38u as=0.68p ps=4.68u w=2u l=0.5u
X36 GROUP4_0.pmos$1_priv1_0.S GROUP5_0.G VDD VDD sg13_lv_pmos ad=0.68p pd=4.68u as=0.38p ps=2.38u w=2u l=0.5u
X37 GROUP2_0.nmos_priv2_0.D GROUP2_0.nmos_priv2_0.D GROUP2_0.nmos_priv2_0.D VSS.t15 sg13_lv_nmos ad=0.2142p pd=1.94u as=0 ps=0 w=0.63u l=0.5u
X38 VSS.t2 GROUP1_0.G GROUP1_0.G VSS.t1 sg13_lv_nmos ad=0.38p pd=2.38u as=0.68p ps=4.68u w=2u l=0.5u
X39 VDD GROUP5_0.G GROUP5_0.G VDD sg13_lv_pmos ad=0.38p pd=2.38u as=0.68p ps=4.68u w=2u l=0.5u
X40 GROUP5_0.G GROUP5_0.G VDD VDD sg13_lv_pmos ad=0.68p pd=4.68u as=0.38p ps=2.38u w=2u l=0.5u
X41 VSS.t5 GROUP1_0.G GROUP1_0.G VSS.t4 sg13_lv_nmos ad=0.38p pd=2.38u as=0.38p ps=2.38u w=2u l=0.5u
X42 cp_cap_m VSS.t20 VSS.t19 rhigh l=1.40168m w=1u
X43 cp_cap_p UP GROUP4_0.pmos$1_priv1_0.S VDD sg13_lv_pmos ad=0.11875p pd=1.005u as=0.11875p ps=1.005u w=0.625u l=0.5u
X44 cp_cap_p cp_cap_p cp_cap_p VSS.t16 sg13_lv_nmos ad=0.2142p pd=1.94u as=0 ps=0 w=0.63u l=0.5u
X45 VSS.t10 GROUP1_0.G GROUP2_0.nmos_priv2_0.D VSS.t3 sg13_lv_nmos ad=0.38p pd=2.38u as=0.38p ps=2.38u w=2u l=0.5u
R0 VSS.n11 VSS.t19 32579.2
R1 VSS.t19 VSS.t18 6355.98
R2 VSS.n11 VSS.t14 2224.66
R3 VSS.n10 VSS.t14 2134.01
R4 VSS.t18 VSS.t17 1190.63
R5 VSS.n14 VSS.t0 515.924
R6 VSS.t7 VSS.t16 317.024
R7 VSS.t17 VSS.n10 302.392
R8 VSS.t15 VSS.t1 164.159
R9 VSS.t16 VSS.n11 156.34
R10 VSS.t1 VSS.t3 152.867
R11 VSS.t3 VSS.t4 152.867
R12 VSS.t4 VSS.t6 152.867
R13 VSS.t6 VSS.t7 152.867
R14 VSS.n12 VSS.t0 93.4578
R15 VSS.n10 VSS.n9 19.1088
R16 VSS.t21 VSS.n4 15.0513
R17 VSS.n18 VSS.t21 15.0005
R18 VSS.n0 VSS.n1 0.063656
R19 VSS.n6 VSS.n5 14.5076
R20 VSS.n35 VSS.t20 13.7571
R21 VSS.n34 VSS.n33 13.7571
R22 VSS.n12 VSS.t15 13.5498
R23 VSS.n13 VSS.n12 11.0661
R24 VSS.n29 VSS.t20 10.8868
R25 VSS.n8 VSS.n6 10.8868
R26 VSS.n33 VSS.n32 10.8868
R27 VSS.n36 VSS.n35 9.6739
R28 VSS.n20 VSS.n19 9.26803
R29 VSS.t12 VSS.n21 9.26803
R30 VSS.n27 VSS.n26 9.0005
R31 VSS.t2 VSS.n27 9.0005
R32 VSS.n17 VSS.t5 9.0005
R33 VSS.n19 VSS.t8 9.0005
R34 VSS.n24 VSS.n23 9.0005
R35 VSS.n22 VSS.t10 9.0005
R36 VSS.n23 VSS.n16 9.0005
R37 VSS.n16 VSS.t9 9.0005
R38 VSS.n15 VSS.n14 8.5005
R39 VSS.n15 VSS.n9 8.5005
R40 VSS.t23 VSS.n4 8.49202
R41 VSS.n2 VSS.n3 0.0756194
R42 VSS.t23 VSS.n3 4.22359
R43 VSS.n2 VSS.n4 0.066135
R44 VSS.t22 VSS.n2 2.81267
R45 VSS.n1 VSS.t26 2.84339
R46 VSS.n0 VSS.t25 2.81267
R47 VSS.n14 VSS.n13 6.60123
R48 VSS.n13 VSS.n9 6.60123
R49 VSS.n30 VSS.n15 6.59353
R50 VSS.n36 VSS.n5 6.3377
R51 VSS.n26 VSS.n20 5.03507
R52 VSS.n24 VSS.n21 5.03507
R53 VSS.n26 VSS.n25 2.80284
R54 VSS.n27 VSS.n7 2.80284
R55 VSS.n28 VSS.t2 2.80284
R56 VSS.n31 VSS.n8 2.55557
R57 VSS.n31 VSS.n30 2.2505
R58 VSS VSS.n36 1.517
R59 VSS.n35 VSS.n34 1.5005
R60 VSS.n33 VSS.t20 1.5005
R61 VSS.n33 VSS.n6 1.5005
R62 VSS.n25 VSS.n24 0.891988
R63 VSS.n23 VSS.n7 0.891988
R64 VSS.n28 VSS.n16 0.891988
R65 VSS.t8 VSS.n18 0.653499
R66 VSS.t9 VSS.n0 0.653499
R67 VSS.n34 VSS.n5 0.650314
R68 VSS.n27 VSS.n17 0.534569
R69 VSS.t2 VSS.t5 0.534569
R70 VSS.n19 VSS.t5 0.534569
R71 VSS.n23 VSS.n22 0.534569
R72 VSS.t10 VSS.n16 0.534569
R73 VSS.t10 VSS.t12 0.534569
R74 VSS.n30 VSS.n29 0.305567
R75 VSS.n32 VSS.n31 0.305567
R76 VSS.n20 VSS.n17 0.253076
R77 VSS.n22 VSS.n21 0.253076
R78 VSS.n29 VSS.n28 0.133967
R79 VSS.n32 VSS.n7 0.133967
R80 VSS.n25 VSS.n8 0.133967
R81 VSS.n3 VSS.n18 0.0981094
R82 VSS.t24 VSS.n1 7.50949
C0 a_28379_1100# GROUP2_0.nmos_priv2_0.D 0.03911f
C1 a_28380_2024# a_28379_1100# 0.01042f
C2 a_25080_5274# GROUP5_0.G 0.27366f
C3 cp_cap_p GROUP5_0.G 0.26577f
C4 UP a_28379_2675# 0.03693f
C5 a_28379_4248# VDD 0.36848f
C6 a_28379_3324# GROUP5_0.G 0.0419f
C7 VDD a_20300_5350# 0.14796f
C8 a_27134_3324# GROUP5_0.G 0.0423f
C9 VDD a_28379_2675# 0.10109f
C10 a_28380_176# GROUP1_0.G 0.04174f
C11 a_20300_5350# GROUP1_0.G 0.07762f
C12 a_27134_4248# GROUP5_0.G 0.19774f
C13 a_28380_176# a_28379_1100# 0.01042f
C14 GROUP4_0.pmos$1_priv1_0.S cp_cap_p 1.57282f
C15 GROUP4_0.pmos$1_priv1_0.S a_28379_3324# 0.06154f
C16 GROUP4_0.pmos$1_priv1_0.S a_27134_3324# 0.14834f
C17 cp_cap_m cp_cap_p 10.3846p
C18 vout VDD 0.07129f
C19 a_27311_176# a_27310_1100# 0.01042f
C20 vout DN 0.01808f
C21 a_28379_4248# GROUP5_0.G 0.09007f
C22 cp_cap_m GROUP2_0.nmos_priv2_0.D 0.112f
C23 cp_cap_p a_27487_2024# 0.0205f
C24 vout GROUP1_0.G 0.0615f
C25 a_27311_176# GROUP1_0.G 0.04284f
C26 UP VDD 1.0632f
C27 a_27487_2024# GROUP2_0.nmos_priv2_0.D 0.06496f
C28 cp_cap_p GROUP2_0.nmos_priv2_0.D 2.18998f
C29 UP a_27486_2675# 0.03683f
C30 UP DN 0.9094f
C31 vout a_30158_4920# 0.91014f
C32 cp_cap_p a_28380_2024# 0.09241f
C33 VDD a_27486_2675# 0.09812f
C34 a_28380_2024# GROUP2_0.nmos_priv2_0.D 0.01082f
C35 a_27134_3324# a_27134_4248# 0.01052f
C36 a_27310_1100# GROUP1_0.G 0.19612f
C37 DN GROUP1_0.G 0.91463f
C38 GROUP4_0.pmos$1_priv1_0.S a_28379_2675# 0.07104f
C39 UP GROUP5_0.G 0.93313f
C40 a_28379_4248# a_28379_3324# 0.01052f
C41 a_25080_5274# a_20300_5350# 0.56918f
C42 a_28379_1100# GROUP1_0.G 0.04426f
C43 a_28380_176# GROUP2_0.nmos_priv2_0.D 0.16831f
C44 cp_cap_p a_28379_2675# 0.02906f
C45 VDD GROUP5_0.G 14.1328f
C46 a_28379_3324# a_28379_2675# 0.01052f
C47 a_27486_2675# GROUP5_0.G 0.01547f
C48 a_28380_2024# a_28379_2675# 0.01038f
C49 GROUP4_0.pmos$1_priv1_0.S UP 1.6022f
C50 vout cp_cap_p 0.65335f
C51 GROUP4_0.pmos$1_priv1_0.S VDD 2.63683f
C52 vout GROUP2_0.nmos_priv2_0.D 0.15222f
C53 cp_cap_p UP 1.63937f
C54 cp_cap_m a_15302_n17730# 2.58151f
C55 VDD a_25080_5274# 0.29863f
C56 cp_cap_p VDD 0.33861f
C57 cp_cap_m GROUP1_0.G 1.45265f
C58 a_27487_2024# a_27486_2675# 0.01038f
C59 a_27487_2024# DN 0.03693f
C60 VDD a_28379_3324# 0.34657f
C61 cp_cap_p a_27486_2675# 0.08272f
C62 cp_cap_p DN 1.51838f
C63 a_27310_1100# GROUP2_0.nmos_priv2_0.D 0.01086f
C64 VDD a_27134_3324# 0.24614f
C65 DN GROUP2_0.nmos_priv2_0.D 1.56481f
C66 cp_cap_p a_15302_n17730# 0.08181f
C67 a_27487_2024# GROUP1_0.G 0.01453f
C68 cp_cap_p GROUP1_0.G 0.05821f
C69 VDD a_27134_4248# 0.20872f
C70 GROUP4_0.pmos$1_priv1_0.S GROUP5_0.G 2.09382f
C71 a_28380_2024# DN 0.03683f
C72 GROUP2_0.nmos_priv2_0.D GROUP1_0.G 2.6701f
C73 cp_cap_p a_30158_4920# 0.11531f
C74 cp_cap_m VSS 0.20207p
C75 vout VSS 1.08412p
C76 VDD VSS 45.22589f
C77 a_28380_176# VSS 0.23324f ; **FLOATING
C78 a_27311_176# VSS 0.41698f ; **FLOATING
C79 a_28379_1100# VSS 0.37469f ; **FLOATING
C80 a_27310_1100# VSS 0.2243f ; **FLOATING
C81 a_28380_2024# VSS 0.11547f ; **FLOATING
C82 a_27487_2024# VSS 0.1193f ; **FLOATING
C83 a_28379_2675# VSS 0.0155f ; **FLOATING
C84 a_27486_2675# VSS 0.01764f ; **FLOATING
C85 GROUP4_0.pmos$1_priv1_0.S VSS 15.16503f
C86 a_28379_4248# VSS 0.0164f ; **FLOATING
C87 a_27134_4248# VSS 0.01667f ; **FLOATING
C88 VSS.t20 VSS 80.759f
C89 VSS.t12 VSS 11.1396f
C90 VSS.t2 VSS 14.48795f
.ends
