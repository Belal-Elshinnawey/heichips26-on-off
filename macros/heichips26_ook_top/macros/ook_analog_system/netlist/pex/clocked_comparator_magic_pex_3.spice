* PEX produced on Sun Sep 13 13:06:31 CEST 2026 using scripts/sak-pex.sh with m=3 and s=1 (extresist threshold=10000 mOhm, minres=1000 mOhm, mindelay=1 ps)
* NGSPICE file created from clocked_comparator_pex.ext - technology: ihp-sg13cmos5l

.subckt clocked_comparator_pex clk vref VDDL VDD vin vout VSS
X0 clk VDD GROUP21_0.G.t14 VSS.t57 sg13_hv_nmos ad=0.38p pd=2.38u as=0.38p ps=2.38u w=2u l=0.5u
X1 GROUP21_0.G.t9 VSS.t74 clk VDD sg13_hv_pmos ad=0.38p pd=2.38u as=0.38p ps=2.38u w=2u l=0.5u
X2 GROUP15_0.pmosHV$2_priv7_0.S GROUP15_0.pmosHV$2_priv7_0.S GROUP15_0.pmosHV$2_priv7_0.S VDDL sg13_hv_pmos ad=1.36p pd=8.68u as=24.5292p ps=0.13411m w=4u l=0.5u
X3 GROUP18_0.G GROUP21_0.G.t21 VSS.t12 VSS.t10 sg13_hv_nmos ad=0.34p pd=2.68u as=0.34p ps=2.68u w=1u l=0.5u
X4 GROUP9_0.nmosHV_priv4_0.S GROUP21_0.G.t22 VSS.t14 VSS.t13 sg13_hv_nmos ad=0.34p pd=2.68u as=0.34p ps=2.68u w=1u l=0.5u
X5 clk VDD GROUP21_0.G.t16 VSS.t61 sg13_hv_nmos ad=0.38p pd=2.38u as=0.38p ps=2.38u w=2u l=0.5u
X6 GROUP15_0.pmosHV$2_priv7_0.D GROUP15_0.pmosHV$2_priv7_0.D GROUP15_0.pmosHV$2_priv7_0.D VDDL sg13_hv_pmos ad=1.36p pd=8.68u as=12.0396p ps=45.16u w=4u l=0.5u
X7 clk VSS.t69 GROUP21_0.G.t12 VDD sg13_hv_pmos ad=0.38p pd=2.38u as=0.68p ps=4.68u w=2u l=0.5u
X8 GROUP16_0.pmosHV$2_priv10_0.D GROUP16_0.pmosHV$2_priv10_0.D GROUP16_0.pmosHV$2_priv10_0.D VDDL sg13_hv_pmos ad=1.36p pd=8.68u as=12.0396p ps=45.16u w=4u l=0.5u
X9 GROUP15_0.pmosHV$2_priv7_0.D vout GROUP15_0.pmosHV$2_priv7_0.S VDDL sg13_hv_pmos ad=1.36p pd=8.68u as=1.36p ps=8.68u w=4u l=0.5u
X10 VSS.t45 VSS.t43 VSS.t44 VSS.t40 sg13_hv_nmos ad=0.34p pd=2.68u as=0 ps=0 w=1u l=0.5u
X11 GROUP21_0.G.t5 GROUP21_0.G.t3 GROUP21_0.G.t4 VDD sg13_hv_pmos ad=0.68p pd=4.68u as=0 ps=0 w=2u l=0.5u
X12 clk VDD GROUP21_0.G.t15 VSS.t59 sg13_hv_nmos ad=0.38p pd=2.38u as=0.38p ps=2.38u w=2u l=0.5u
X13 GROUP21_0.G.t10 VSS.t72 clk VDD sg13_hv_pmos ad=0.38p pd=2.38u as=0.38p ps=2.38u w=2u l=0.5u
X14 GROUP21_0.G.t11 VSS.t70 clk VDD sg13_hv_pmos ad=0.38p pd=2.38u as=0.38p ps=2.38u w=2u l=0.5u
X15 GROUP20_0.G GROUP20_0.G GROUP20_0.G VDD sg13_hv_pmos ad=0.68p pd=4.68u as=45.5261p ps=0.23483m w=2u l=0.5u
X16 clk VDD GROUP21_0.G.t17 VSS.t63 sg13_hv_nmos ad=0.38p pd=2.38u as=0.38p ps=2.38u w=2u l=0.5u
X17 clk VDD GROUP21_0.G.t18 VSS.t65 sg13_hv_nmos ad=0.38p pd=2.38u as=0.38p ps=2.38u w=2u l=0.5u
X18 VSS.t42 VSS.t39 VSS.t41 VSS.t40 sg13_hv_nmos ad=0.34p pd=2.68u as=0 ps=0 w=1u l=0.5u
X19 GROUP5_0.pmosHV_priv15_0.D GROUP5_0.pmosHV_priv15_0.D GROUP5_0.pmosHV_priv15_0.D VDD sg13_hv_pmos ad=0.68p pd=4.68u as=13.2594p ps=51.74u w=2u l=0.5u
X20 GROUP5_0.pmosHV_priv15_0.D GROUP18_0.G GROUP20_0.G VDD sg13_hv_pmos ad=0.68p pd=4.68u as=0.68p ps=4.68u w=2u l=0.5u
X21 VSS.t27 VSS.t25 VSS.t26 VSS.t13 sg13_hv_nmos ad=0.34p pd=2.68u as=0 ps=0 w=1u l=0.5u
X22 GROUP20_0.G GROUP21_0.G.t20 VSS.t16 VSS.t15 sg13_hv_nmos ad=0.34p pd=2.68u as=0.34p ps=2.68u w=1u l=0.5u
X23 VSS.t55 VSS.t52 VSS.t54 VSS.t53 sg13_hv_nmos ad=0.34p pd=2.68u as=0 ps=0 w=1u l=0.5u
X24 GROUP9_0.nmosHV_priv4_0.S GROUP9_0.nmosHV_priv4_0.S GROUP9_0.nmosHV_priv4_0.S VSS.t13 sg13_hv_nmos ad=0.34p pd=2.68u as=13.2594p ps=51.74u w=1u l=0.5u
X25 clk VSS.t75 GROUP21_0.G.t9 VDD sg13_hv_pmos ad=0.38p pd=2.38u as=0.38p ps=2.38u w=2u l=0.5u
X26 VSS.t38 VSS.t36 VSS.t37 VSS.t10 sg13_hv_nmos ad=0.34p pd=2.68u as=0 ps=0 w=1u l=0.5u
X27 GROUP20_0.G GROUP20_0.G GROUP20_0.G VSS.t5 sg13_hv_nmos ad=0.34p pd=2.68u as=0 ps=0 w=1u l=0.5u
X28 GROUP21_0.G.t16 VDD clk VSS.t62 sg13_hv_nmos ad=0.38p pd=2.38u as=0.38p ps=2.38u w=2u l=0.5u
X29 VDDL VDDL VDDL VDDL sg13_hv_pmos ad=1.36p pd=8.68u as=14.5746p ps=54.94u w=4u l=0.5u
X30 VDDL GROUP20_0.G GROUP16_0.pmosHV$2_priv10_0.D VDDL sg13_hv_pmos ad=1.36p pd=8.68u as=1.36p ps=8.68u w=4u l=0.5u
X31 GROUP18_0.G GROUP20_0.G VSS.t2 VSS.t1 sg13_hv_nmos ad=0.34p pd=2.68u as=0.34p ps=2.68u w=1u l=0.5u
X32 GROUP21_0.G.t8 VSS.t76 clk VDD sg13_hv_pmos ad=0.38p pd=2.38u as=0.38p ps=2.38u w=2u l=0.5u
X33 vout vout vout VSS.t18 sg13_hv_nmos ad=0.34p pd=2.68u as=24.1098p ps=0.13178m w=1u l=0.5u
X34 vout GROUP15_0.pmosHV$2_priv7_0.S VSS.t20 VSS.t3 sg13_hv_nmos ad=0.34p pd=2.68u as=0.34p ps=2.68u w=1u l=0.5u
X35 GROUP20_0.G GROUP18_0.G VSS.t9 VSS.t8 sg13_hv_nmos ad=0.34p pd=2.68u as=0.34p ps=2.68u w=1u l=0.5u
X36 clk VDD GROUP21_0.G.t19 VSS.t67 sg13_hv_nmos ad=0.38p pd=2.38u as=0.68p ps=4.68u w=2u l=0.5u
X37 GROUP15_0.pmosHV$2_priv7_0.D GROUP15_0.pmosHV$2_priv7_0.D GROUP15_0.pmosHV$2_priv7_0.D VDDL sg13_hv_pmos ad=1.36p pd=8.68u as=0 ps=0 w=4u l=0.5u
X38 clk clk clk VSS.t21 sg13_hv_nmos ad=0.68p pd=4.68u as=11.3622p ps=83.08u w=2u l=0.5u
X39 GROUP15_0.pmosHV$2_priv7_0.S GROUP15_0.pmosHV$2_priv7_0.S GROUP15_0.pmosHV$2_priv7_0.S VSS.t18 sg13_hv_nmos ad=0.34p pd=2.68u as=0 ps=0 w=1u l=0.5u
X40 clk VSS.t79 GROUP21_0.G.t7 VDD sg13_hv_pmos ad=0.38p pd=2.38u as=0.38p ps=2.38u w=2u l=0.5u
X41 clk VSS.t73 GROUP21_0.G.t10 VDD sg13_hv_pmos ad=0.38p pd=2.38u as=0.38p ps=2.38u w=2u l=0.5u
X42 GROUP15_0.pmosHV$2_priv7_0.S vout VSS.t19 VSS.t3 sg13_hv_nmos ad=0.34p pd=2.68u as=0.34p ps=2.68u w=1u l=0.5u
X43 VDD GROUP21_0.G.t24 GROUP5_0.pmosHV_priv15_0.S VDD sg13_hv_pmos ad=1.7p pd=10.68u as=1.7p ps=10.68u w=5u l=0.5u
X44 GROUP5_0.pmosHV_priv15_0.S GROUP5_0.pmosHV_priv15_0.S GROUP5_0.pmosHV_priv15_0.S VDD sg13_hv_pmos ad=1.7p pd=10.68u as=21.6594p ps=79.74u w=5u l=0.5u
X45 GROUP21_0.G.t2 GROUP21_0.G.t0 GROUP21_0.G.t1 VSS.t17 sg13_hv_nmos ad=0.68p pd=4.68u as=0 ps=0 w=2u l=0.5u
X46 GROUP21_0.G.t14 VDD clk VSS.t58 sg13_hv_nmos ad=0.38p pd=2.38u as=0.38p ps=2.38u w=2u l=0.5u
X47 GROUP21_0.G.t17 VDD clk VSS.t64 sg13_hv_nmos ad=0.38p pd=2.38u as=0.38p ps=2.38u w=2u l=0.5u
X48 vout vout vout VDDL sg13_hv_pmos ad=1.36p pd=8.68u as=0 ps=0 w=4u l=0.5u
X49 GROUP15_0.pmosHV$2_priv7_0.S GROUP15_0.pmosHV$2_priv7_0.S GROUP15_0.pmosHV$2_priv7_0.S VSS.t10 sg13_hv_nmos ad=0.34p pd=2.68u as=0 ps=0 w=1u l=0.5u
X50 VSS.t48 VSS.t46 VSS.t47 VSS.t40 sg13_hv_nmos ad=0.34p pd=2.68u as=0 ps=0 w=1u l=0.5u
X51 VDD VDD VDD VDD sg13_hv_pmos ad=1.7p pd=10.68u as=58.386p ps=0.18327m w=5u l=0.5u
X52 GROUP21_0.G.t13 VDD clk VSS.t56 sg13_hv_nmos ad=0.68p pd=4.68u as=0.38p ps=2.38u w=2u l=0.5u
X53 VSS.t35 VSS.t32 VSS.t34 VSS.t33 sg13_hv_nmos ad=0.34p pd=2.68u as=0 ps=0 w=1u l=0.5u
X54 GROUP16_0.pmosHV$2_priv10_0.D GROUP16_0.pmosHV$2_priv10_0.D GROUP16_0.pmosHV$2_priv10_0.D VDDL sg13_hv_pmos ad=1.36p pd=8.68u as=0 ps=0 w=4u l=0.5u
X55 GROUP15_0.pmosHV$2_priv7_0.S GROUP18_0.G VSS.t11 VSS.t10 sg13_hv_nmos ad=0.34p pd=2.68u as=0.34p ps=2.68u w=1u l=0.5u
X56 GROUP5_0.pmosHV_priv15_0.D GROUP5_0.pmosHV_priv15_0.D GROUP5_0.pmosHV_priv15_0.D VDD sg13_hv_pmos ad=1.7p pd=10.68u as=0 ps=0 w=5u l=0.5u
X57 GROUP5_0.pmosHV_priv15_0.S GROUP5_0.pmosHV_priv15_0.S GROUP5_0.pmosHV_priv15_0.S VDD sg13_hv_pmos ad=1.7p pd=10.68u as=0 ps=0 w=5u l=0.5u
X58 GROUP5_0.pmosHV_priv15_0.D GROUP21_0.G.t23 VSS.t68 VSS.t6 sg13_hv_nmos ad=0.34p pd=2.68u as=0.34p ps=2.68u w=1u l=0.5u
X59 GROUP9_0.nmosHV_priv4_0.S GROUP20_0.G GROUP18_0.G VDD sg13_hv_pmos ad=0.68p pd=4.68u as=0.68p ps=4.68u w=2u l=0.5u
X60 GROUP18_0.G GROUP18_0.G GROUP18_0.G VDD sg13_hv_pmos ad=0.68p pd=4.68u as=45.658p ps=0.23585m w=2u l=0.5u
X61 GROUP16_0.pmosHV$2_priv10_0.D GROUP15_0.pmosHV$2_priv7_0.S vout VDDL sg13_hv_pmos ad=1.36p pd=8.68u as=1.36p ps=8.68u w=4u l=0.5u
X62 VSS.t51 VSS.t49 VSS.t50 VSS.t10 sg13_hv_nmos ad=0.34p pd=2.68u as=0 ps=0 w=1u l=0.5u
X63 GROUP5_0.pmosHV_priv15_0.S vin GROUP5_0.pmosHV_priv15_0.D VDD sg13_hv_pmos ad=1.7p pd=10.68u as=1.7p ps=10.68u w=5u l=0.5u
X64 GROUP9_0.nmosHV_priv4_0.S GROUP9_0.nmosHV_priv4_0.S GROUP9_0.nmosHV_priv4_0.S VDD sg13_hv_pmos ad=0.68p pd=4.68u as=0 ps=0 w=2u l=0.5u
X65 GROUP18_0.G GROUP18_0.G GROUP18_0.G VSS.t7 sg13_hv_nmos ad=0.34p pd=2.68u as=0 ps=0 w=1u l=0.5u
X66 VSS.t31 VSS.t28 VSS.t30 VSS.t29 sg13_hv_nmos ad=0.34p pd=2.68u as=0 ps=0 w=1u l=0.5u
X67 GROUP9_0.nmosHV_priv4_0.S GROUP9_0.nmosHV_priv4_0.S GROUP9_0.nmosHV_priv4_0.S VDD sg13_hv_pmos ad=1.7p pd=10.68u as=0 ps=0 w=5u l=0.5u
X68 clk VSS.t77 GROUP21_0.G.t8 VDD sg13_hv_pmos ad=0.38p pd=2.38u as=0.38p ps=2.38u w=2u l=0.5u
X69 VDDL VDDL VDDL VDDL sg13_hv_pmos ad=1.36p pd=8.68u as=0 ps=0 w=4u l=0.5u
X70 VDDL GROUP18_0.G GROUP15_0.pmosHV$2_priv7_0.D VDDL sg13_hv_pmos ad=1.36p pd=8.68u as=1.36p ps=8.68u w=4u l=0.5u
X71 clk clk clk VDD sg13_hv_pmos ad=0.68p pd=4.68u as=0 ps=0 w=2u l=0.5u
X72 GROUP18_0.G GROUP18_0.G GROUP18_0.G VSS.t10 sg13_hv_nmos ad=0.34p pd=2.68u as=0 ps=0 w=1u l=0.5u
X73 GROUP5_0.pmosHV_priv15_0.S GROUP5_0.pmosHV_priv15_0.S GROUP5_0.pmosHV_priv15_0.S VDD sg13_hv_pmos ad=1.7p pd=10.68u as=0 ps=0 w=5u l=0.5u
X74 GROUP20_0.G GROUP20_0.G GROUP20_0.G VSS.t0 sg13_hv_nmos ad=0.34p pd=2.68u as=0 ps=0 w=1u l=0.5u
X75 GROUP21_0.G.t15 VDD clk VSS.t60 sg13_hv_nmos ad=0.38p pd=2.38u as=0.38p ps=2.38u w=2u l=0.5u
X76 GROUP5_0.pmosHV_priv15_0.S vref GROUP9_0.nmosHV_priv4_0.S VDD sg13_hv_pmos ad=1.7p pd=10.68u as=1.7p ps=10.68u w=5u l=0.5u
X77 clk VSS.t71 GROUP21_0.G.t11 VDD sg13_hv_pmos ad=0.38p pd=2.38u as=0.38p ps=2.38u w=2u l=0.5u
X78 GROUP21_0.G.t18 VDD clk VSS.t66 sg13_hv_nmos ad=0.38p pd=2.38u as=0.38p ps=2.38u w=2u l=0.5u
X79 vout vout vout VSS.t18 sg13_hv_nmos ad=0.34p pd=2.68u as=0 ps=0 w=1u l=0.5u
X80 VSS.t24 VSS.t22 VSS.t23 VSS.t6 sg13_hv_nmos ad=0.34p pd=2.68u as=0 ps=0 w=1u l=0.5u
X81 GROUP21_0.G.t6 VSS.t80 clk VDD sg13_hv_pmos ad=0.68p pd=4.68u as=0.38p ps=2.38u w=2u l=0.5u
X82 GROUP21_0.G.t7 VSS.t78 clk VDD sg13_hv_pmos ad=0.38p pd=2.38u as=0.38p ps=2.38u w=2u l=0.5u
X83 vout GROUP20_0.G VSS.t4 VSS.t3 sg13_hv_nmos ad=0.34p pd=2.68u as=0.34p ps=2.68u w=1u l=0.5u
X84 GROUP5_0.pmosHV_priv15_0.D GROUP5_0.pmosHV_priv15_0.D GROUP5_0.pmosHV_priv15_0.D VSS.t6 sg13_hv_nmos ad=0.34p pd=2.68u as=0 ps=0 w=1u l=0.5u
R0 VSS.t17 VSS.n60 19700.9
R1 VSS.t29 VSS.n57 7127.92
R2 VSS.n59 VSS.t18 5507.24
R3 VSS.t1 VSS.t33 1684.62
R4 VSS.n59 VSS.t7 1578.46
R5 VSS.t6 VSS.n58 1239.7
R6 VSS.n59 VSS.t13 1237.32
R7 VSS.n65 VSS.t21 1131.69
R8 VSS.t13 VSS.t6 952.495
R9 VSS.t8 VSS.t29 805.148
R10 VSS.n58 VSS.t0 754.413
R11 VSS.t21 VSS.n64 566.42
R12 VSS.n60 VSS.n59 508.579
R13 VSS.t10 VSS.n26 439.728
R14 VSS.t66 VSS.t67 338.029
R15 VSS.t65 VSS.t66 338.029
R16 VSS.t64 VSS.t65 338.029
R17 VSS.t63 VSS.t64 338.029
R18 VSS.t62 VSS.t63 338.029
R19 VSS.t61 VSS.t62 338.029
R20 VSS.t60 VSS.t61 338.029
R21 VSS.t59 VSS.t60 338.029
R22 VSS.t58 VSS.t59 338.029
R23 VSS.t57 VSS.t58 338.029
R24 VSS.t56 VSS.t57 338.029
R25 VSS.n61 VSS.t56 314.82
R26 VSS.n57 VSS.n56 295.437
R27 VSS.n61 VSS.t17 270.647
R28 VSS.t40 VSS.t3 181.472
R29 VSS.n54 VSS.t53 169.042
R30 VSS.n56 VSS.t40 166.556
R31 VSS.n65 VSS.n26 162.445
R32 VSS.t5 VSS.n55 160.094
R33 VSS.n57 VSS.t10 117.843
R34 VSS.n59 VSS.t1 106.154
R35 VSS.t3 VSS.n24 74.604
R36 VSS.n56 VSS.t5 70.1033
R37 VSS.t18 VSS.n24 56.1749
R38 VSS.n58 VSS.t8 50.7358
R39 VSS.n55 VSS.t15 21.3794
R40 VSS.n64 VSS.t67 19.0464
R41 VSS.n1 VSS.t23 5.63547
R42 VSS.n3 VSS.t30 5.63547
R43 VSS.n5 VSS.t34 5.63547
R44 VSS.n7 VSS.t44 5.63547
R45 VSS.n9 VSS.t47 5.63547
R46 VSS.n11 VSS.t54 5.63547
R47 VSS.n13 VSS.t50 5.63547
R48 VSS.n15 VSS.t37 5.63547
R49 VSS.n17 VSS.t41 5.63547
R50 VSS.n19 VSS.t26 5.63547
R51 VSS.n0 VSS.t22 7.48191
R52 VSS.n2 VSS.t28 7.48191
R53 VSS.n4 VSS.t32 7.48191
R54 VSS.n6 VSS.t43 7.48191
R55 VSS.n8 VSS.t46 7.48191
R56 VSS.n10 VSS.t52 7.48191
R57 VSS.n12 VSS.t49 7.48191
R58 VSS.n14 VSS.t36 7.48191
R59 VSS.n16 VSS.t39 7.48191
R60 VSS.t80 VSS.n33 15.0005
R61 VSS.t79 VSS.n32 15.0005
R62 VSS.n37 VSS.t78 15.0005
R63 VSS.n38 VSS.t77 15.0005
R64 VSS.t76 VSS.n39 15.0005
R65 VSS.t75 VSS.n30 15.0005
R66 VSS.n43 VSS.t74 15.0005
R67 VSS.n44 VSS.t73 15.0005
R68 VSS.t72 VSS.n45 15.0005
R69 VSS.t71 VSS.n28 15.0005
R70 VSS.n49 VSS.t70 15.0005
R71 VSS.n22 VSS.t69 15.0005
R72 VSS.n34 VSS.t80 15.0005
R73 VSS.n35 VSS.t79 15.0005
R74 VSS.t78 VSS.n36 15.0005
R75 VSS.t77 VSS.n31 15.0005
R76 VSS.n40 VSS.t76 15.0005
R77 VSS.n41 VSS.t75 15.0005
R78 VSS.t74 VSS.n42 15.0005
R79 VSS.t73 VSS.n29 15.0005
R80 VSS.n46 VSS.t72 15.0005
R81 VSS.n47 VSS.t71 15.0005
R82 VSS.t70 VSS.n48 15.0005
R83 VSS.t69 VSS.n27 15.0005
R84 VSS.n18 VSS.t25 7.48191
R85 VSS.t15 VSS.n54 12.4301
R86 VSS VSS.n84 11.3606
R87 VSS.n70 VSS.n69 10.0724
R88 VSS.n78 VSS.n77 10.0528
R89 VSS VSS.n51 9.99417
R90 VSS VSS.n71 9.29628
R91 VSS.n70 VSS.n68 9.19239
R92 VSS.n78 VSS.n76 9.16794
R93 VSS.n52 VSS.n50 9.0005
R94 VSS.n83 VSS.n82 9.0005
R95 VSS.n80 VSS.n75 9.0005
R96 VSS.n62 VSS.n53 8.96438
R97 VSS.n53 VSS.n52 8.83694
R98 VSS.n54 VSS.n25 8.5005
R99 VSS.n55 VSS.n25 8.5005
R100 VSS.n0 VSS.n1 0.0434444
R101 VSS.n2 VSS.n3 0.0434444
R102 VSS.n4 VSS.n5 0.0434444
R103 VSS.n6 VSS.n7 0.0434444
R104 VSS.n8 VSS.n9 0.0434444
R105 VSS.n10 VSS.n11 0.0434444
R106 VSS.n12 VSS.n13 0.0434444
R107 VSS.n14 VSS.n15 0.0434444
R108 VSS.n16 VSS.n17 0.0434444
R109 VSS.n18 VSS.n19 0.0434444
R110 VSS.n83 VSS.n21 6.63939
R111 VSS.n51 VSS.t68 5.99337
R112 VSS.n84 VSS.t9 5.99293
R113 VSS.n82 VSS.t2 5.99293
R114 VSS.n76 VSS.t20 5.99293
R115 VSS.n77 VSS.t4 5.99293
R116 VSS.n75 VSS.t16 5.99293
R117 VSS.n71 VSS.t12 5.99293
R118 VSS.n69 VSS.t11 5.99293
R119 VSS.n68 VSS.t19 5.99293
R120 VSS.n50 VSS.t14 5.99293
R121 VSS.n81 VSS.n24 5.85246
R122 VSS.n20 VSS.n80 5.57361
R123 VSS.n60 VSS.n21 5.36421
R124 VSS.n79 VSS.n74 5.26194
R125 VSS.n73 VSS.n72 5.25706
R126 VSS.n67 VSS.n26 5.23566
R127 VSS.n66 VSS.n65 5.22651
R128 VSS.n62 VSS.n61 4.7321
R129 VSS.n64 VSS.n63 4.7321
R130 VSS.n20 VSS.n25 4.24186
R131 VSS VSS.n83 2.70528
R132 VSS.n23 VSS.n27 2.42524
R133 VSS.n72 VSS 2.0025
R134 VSS.n21 VSS.n81 1.99368
R135 VSS.n79 VSS 1.90472
R136 VSS.n34 VSS 1.82406
R137 VSS.n20 VSS.n74 1.7374
R138 VSS.n72 VSS 1.71039
R139 VSS.n33 VSS 1.67556
R140 VSS VSS.n79 1.60772
R141 VSS.n73 VSS.n67 1.38187
R142 VSS.n52 VSS 1.30461
R143 VSS.n67 VSS.n66 1.24003
R144 VSS.n63 VSS.n62 1.19567
R145 VSS.n63 VSS.n23 1.09718
R146 VSS.n74 VSS.n73 0.996
R147 VSS.n81 VSS.n20 0.89535
R148 VSS.n23 VSS.n22 0.84341
R149 VSS.n51 VSS.n0 0.653499
R150 VSS.n84 VSS.n2 0.653499
R151 VSS.n82 VSS.n4 0.653499
R152 VSS.n76 VSS.n6 0.653499
R153 VSS.n77 VSS.n8 0.653499
R154 VSS.n75 VSS.n10 0.653499
R155 VSS.n71 VSS.n12 0.653499
R156 VSS.n69 VSS.n14 0.653499
R157 VSS.n68 VSS.n16 0.653499
R158 VSS.n50 VSS.n18 0.653499
R159 VSS.n53 VSS.n21 0.6517
R160 VSS.n80 VSS 0.648278
R161 VSS VSS.n78 0.640944
R162 VSS.n66 VSS.n23 0.639052
R163 VSS VSS.n70 0.276722
R164 VSS.n22 VSS.n49 0.269389
R165 VSS.n49 VSS.n28 0.269389
R166 VSS.n45 VSS.n28 0.269389
R167 VSS.n45 VSS.n44 0.269389
R168 VSS.n44 VSS.n43 0.269389
R169 VSS.n43 VSS.n30 0.269389
R170 VSS.n39 VSS.n30 0.269389
R171 VSS.n39 VSS.n38 0.269389
R172 VSS.n38 VSS.n37 0.269389
R173 VSS.n37 VSS.n32 0.269389
R174 VSS.n33 VSS.n32 0.269389
R175 VSS.n48 VSS.n27 0.269389
R176 VSS.n48 VSS.n47 0.269389
R177 VSS.n47 VSS.n46 0.269389
R178 VSS.n46 VSS.n29 0.269389
R179 VSS.n42 VSS.n29 0.269389
R180 VSS.n42 VSS.n41 0.269389
R181 VSS.n41 VSS.n40 0.269389
R182 VSS.n40 VSS.n31 0.269389
R183 VSS.n36 VSS.n31 0.269389
R184 VSS.n36 VSS.n35 0.269389
R185 VSS.n35 VSS.n34 0.269389
R186 VSS.n19 VSS.t27 5.73663
R187 VSS.n17 VSS.t42 5.73663
R188 VSS.n15 VSS.t38 5.73663
R189 VSS.n13 VSS.t51 5.73663
R190 VSS.n11 VSS.t55 5.73663
R191 VSS.n9 VSS.t48 5.73663
R192 VSS.n7 VSS.t45 5.73663
R193 VSS.n5 VSS.t35 5.73663
R194 VSS.n3 VSS.t31 5.73663
R195 VSS.n1 VSS.t24 5.73663
R196 GROUP21_0.G.n14 GROUP21_0.G.n5 18.1034
R197 GROUP21_0.G.n14 GROUP21_0.G.n13 15.904
R198 GROUP21_0.G.n7 GROUP21_0.G.n2 18.4957
R199 GROUP21_0.G.n7 GROUP21_0.G.t21 7.1796
R200 GROUP21_0.G.n12 GROUP21_0.G.t0 7.50949
R201 GROUP21_0.G.n6 GROUP21_0.G.t23 7.42005
R202 GROUP21_0.G.n5 GROUP21_0.G.t22 7.69815
R203 GROUP21_0.G.n10 GROUP21_0.G.t3 7.53302
R204 GROUP21_0.G.n27 GROUP21_0.G.t12 12.3725
R205 GROUP21_0.G.n16 GROUP21_0.G.t19 12.3725
R206 GROUP21_0.G.n19 GROUP21_0.G.t18 12.3725
R207 GROUP21_0.G.n20 GROUP21_0.G.t17 12.3725
R208 GROUP21_0.G.n21 GROUP21_0.G.t16 12.3725
R209 GROUP21_0.G.n0 GROUP21_0.G.t15 12.3725
R210 GROUP21_0.G.n0 GROUP21_0.G.t14 12.3725
R211 GROUP21_0.G.n26 GROUP21_0.G.t11 12.3725
R212 GROUP21_0.G.n31 GROUP21_0.G.t10 12.3725
R213 GROUP21_0.G.n32 GROUP21_0.G.t9 12.3725
R214 GROUP21_0.G.n33 GROUP21_0.G.t8 12.3725
R215 GROUP21_0.G.n2 GROUP21_0.G.t7 12.3725
R216 GROUP21_0.G.n28 GROUP21_0.G.n27 9.0005
R217 GROUP21_0.G.n29 GROUP21_0.G.n26 9.0005
R218 GROUP21_0.G.n31 GROUP21_0.G.n30 9.0005
R219 GROUP21_0.G.n32 GROUP21_0.G.n25 9.0005
R220 GROUP21_0.G.n34 GROUP21_0.G.n33 9.0005
R221 GROUP21_0.G.n2 GROUP21_0.G.n23 9.0005
R222 GROUP21_0.G.n0 GROUP21_0.G.n22 9.0005
R223 GROUP21_0.G.n17 GROUP21_0.G.n16 9.0005
R224 GROUP21_0.G.n19 GROUP21_0.G.n18 9.0005
R225 GROUP21_0.G.n20 GROUP21_0.G.n15 9.0005
R226 GROUP21_0.G.n17 GROUP23_0.nmosHV$1_priv1_0.D 9.0005
R227 GROUP21_0.G.n18 GROUP23_0.nmosHV$1_priv1_0.D 9.0005
R228 GROUP21_0.G.n28 GROUP24_0.pmosHV$3_priv1_0.D 9.0005
R229 GROUP21_0.G.n25 GROUP21_0.G.n24 9.0005
R230 GROUP21_0.G.n30 GROUP21_0.G.n4 9.0005
R231 GROUP21_0.G.n29 GROUP24_0.pmosHV$3_priv1_0.D 9.0005
R232 GROUP21_0.G.t2 GROUP21_0.G.n11 2.81267
R233 GROUP21_0.G.t1 GROUP21_0.G.n12 2.84339
R234 GROUP21_0.G.n11 GROUP21_0.G.n12 0.063656
R235 GROUP21_0.G.t5 GROUP21_0.G.n9 2.81267
R236 GROUP21_0.G.t4 GROUP21_0.G.n10 2.80929
R237 GROUP21_0.G.n9 GROUP21_0.G.n10 0.0397382
R238 GROUP21_0.G.n35 GROUP21_0.G.t20 7.36589
R239 GROUP21_0.G.n13 GROUP21_0.G.t24 7.10395
R240 GROUP21_0.G.n1 GROUP21_0.G.n0 0.347998
R241 GROUP21_0.G.n2 GROUP21_0.G.n8 4.70638
R242 GROUP21_0.G.n22 GROUP21_0.G.t13 3.37253
R243 GROUP21_0.G.n23 GROUP21_0.G.t6 3.37253
R244 GROUP21_0.G.n5 GROUP21_0.G.n6 0.358942
R245 GROUP21_0.G.n2 GROUP21_0.G.n14 1.45739
R246 GROUP21_0.G.n13 GROUP4_0.G 1.38746
R247 GROUP21_0.G.n2 GROUP21_0.G.n0 1.06628
R248 GROUP21_0.G.n35 GROUP22_0.G 0.798426
R249 GROUP21_0.G.n34 GROUP21_0.G.n8 0.47868
R250 GROUP21_0.G.n6 GROUP8_0.G 0.612892
R251 GROUP21_0.G.n22 GROUP21_0.G.n11 0.653499
R252 GROUP21_0.G.n23 GROUP21_0.G.n9 0.653499
R253 GROUP21_0.G.n27 GROUP21_0.G.n26 0.534569
R254 GROUP21_0.G.n31 GROUP21_0.G.n26 0.534569
R255 GROUP21_0.G.n32 GROUP21_0.G.n31 0.534569
R256 GROUP21_0.G.n33 GROUP21_0.G.n32 0.534569
R257 GROUP21_0.G.n19 GROUP21_0.G.n16 0.534569
R258 GROUP21_0.G.n20 GROUP21_0.G.n19 0.534569
R259 GROUP21_0.G.n21 GROUP21_0.G.n20 0.534569
R260 GROUP21_0.G.n18 GROUP21_0.G.n17 0.534569
R261 GROUP21_0.G.n18 GROUP21_0.G.n15 0.534569
R262 GROUP21_0.G.n3 GROUP21_0.G.n1 2.33872
R263 GROUP21_0.G.n29 GROUP21_0.G.n28 0.534569
R264 GROUP21_0.G.n30 GROUP21_0.G.n29 0.534569
R265 GROUP21_0.G.n30 GROUP21_0.G.n25 0.534569
R266 GROUP21_0.G.n34 GROUP21_0.G.n25 0.534569
R267 GROUP21_0.G.n4 GROUP21_0.G.n24 0.534569
R268 GROUP21_0.G.n8 GROUP21_0.G.n24 3.59225
R269 GROUP21_0.G.n7 GROUP21_0.G.n35 3.29097
R270 GROUP21_0.G.n3 GROUP21_0.G.n15 0.827396
R271 GROUP23_0.nmosHV$1_priv1_0.D GROUP21_0.G.n3 3.06661
R272 GROUP21_0.G.n21 GROUP21_0.G.n1 0.995941
R273 GROUP21_0.G.n33 GROUP21_0.G.n2 1.48251
R274 GROUP24_0.pmosHV$3_priv1_0.D GROUP21_0.G.n4 1.06864
C0 GROUP18_0.G a_17642_n28087# 0.03987f
C1 GROUP9_0.nmosHV_priv4_0.S GROUP5_0.pmosHV_priv15_0.D 0.05104f
C2 GROUP18_0.G clk 0.06555f
C3 GROUP15_0.pmosHV$2_priv7_0.S GROUP15_0.pmosHV$2_priv7_0.D 0.38265f
C4 vref GROUP9_0.nmosHV_priv4_0.S 2.06887f
C5 VDDL clk 0.0449f
C6 GROUP15_0.pmosHV$2_priv7_0.S GROUP20_0.G 1.00529f
C7 GROUP16_0.pmosHV$2_priv10_0.D GROUP20_0.G 1.8762f
C8 a_17642_n33080# vout 0.038f
C9 GROUP18_0.G a_21290_n28452# 0.16968f
C10 VDDL a_17642_n32185# 0.37565f
C11 a_16920_n33082# a_17642_n33080# 0.01035f
C12 a_16282_n28975# VDD 0.20583f
C13 a_22216_n33446# GROUP20_0.G 0.03884f
C14 VDD a_20690_n27186# 0.52227f
C15 a_17642_n27186# GROUP5_0.pmosHV_priv15_0.S 0.01476f
C16 GROUP18_0.G a_17642_n29347# 0.03816f
C17 GROUP15_0.pmosHV$2_priv7_0.S a_20892_n31820# 0.04108f
C18 vin a_17642_n27186# 0.04142f
C19 a_20892_n31820# GROUP16_0.pmosHV$2_priv10_0.D 0.26836f
C20 VDDL a_20892_n32185# 0.37565f
C21 GROUP15_0.pmosHV$2_priv7_0.D vout 1.87806f
C22 vout GROUP20_0.G 1.281f
C23 a_17642_n28087# GROUP5_0.pmosHV_priv15_0.D 0.17614f
C24 VDDL GROUP18_0.G 3.1392f
C25 a_20690_n26821# VDD 0.51908f
C26 a_20892_n30925# GROUP20_0.G 0.04145f
C27 a_17642_n33445# vout 0.03816f
C28 GROUP18_0.G a_21492_n29347# 0.11078f
C29 VDD a_16282_n31276# 0.20583f
C30 VDD a_19166_n25622# 0.75802f
C31 VDD a_21290_n28087# 0.20554f
C32 vout a_20892_n31820# 0.01557f
C33 GROUP18_0.G a_17642_n30561# 0.04169f
C34 VDD GROUP5_0.pmosHV_priv15_0.S 3.05694f
C35 a_19166_n28035# GROUP5_0.pmosHV_priv15_0.D 0.10967f
C36 GROUP9_0.nmosHV_priv4_0.S a_20690_n27186# 0.29889f
C37 VDDL a_17642_n31820# 0.37565f
C38 VDDL a_17642_n30561# 0.65692f
C39 GROUP15_0.pmosHV$2_priv7_0.S a_17642_n32185# 0.26793f
C40 VDD GROUP20_0.G 0.81162f
C41 vin VDD 1.01961f
C42 a_21492_n33080# a_22216_n33081# 0.01042f
C43 a_20690_n26821# GROUP5_0.pmosHV_priv15_0.S 0.29522f
C44 a_17642_n28452# GROUP18_0.G 0.0397f
C45 GROUP9_0.nmosHV_priv4_0.S a_19968_n28035# 0.1195f
C46 GROUP18_0.G GROUP5_0.pmosHV_priv15_0.D 1.4116f
C47 GROUP9_0.nmosHV_priv4_0.S VDD 1.55016f
C48 a_21492_n29712# GROUP20_0.G 0.0382f
C49 GROUP20_0.G a_21290_n28087# 0.03991f
C50 a_16920_n33447# a_17642_n33445# 0.01035f
C51 GROUP15_0.pmosHV$2_priv7_0.S a_20892_n32185# 0.04177f
C52 VDDL a_20892_n30560# 0.63505f
C53 GROUP15_0.pmosHV$2_priv7_0.S GROUP18_0.G 1.30224f
C54 vout a_17642_n32185# 0.04124f
C55 vin GROUP5_0.pmosHV_priv15_0.S 2.07636f
C56 GROUP9_0.nmosHV_priv4_0.S a_21290_n28087# 0.16083f
C57 VDDL GROUP15_0.pmosHV$2_priv7_0.S 2.20382f
C58 VDDL GROUP16_0.pmosHV$2_priv10_0.D 1.47311f
C59 GROUP15_0.pmosHV$2_priv7_0.S a_21492_n33080# 0.038f
C60 GROUP9_0.nmosHV_priv4_0.S GROUP5_0.pmosHV_priv15_0.S 0.37529f
C61 VDD a_19166_n25987# 0.4513f
C62 GROUP9_0.nmosHV_priv4_0.S GROUP20_0.G 1.47006f
C63 a_17642_n28087# VDD 0.20539f
C64 VDD clk 3.32883f
C65 vout a_20892_n32185# 0.29089f
C66 VDD a_21290_n28452# 0.20554f
C67 GROUP18_0.G vout 1.18243f
C68 a_17642_n30926# GROUP15_0.pmosHV$2_priv7_0.D 0.26717f
C69 a_16920_n33082# GROUP18_0.G 0.03865f
C70 VDDL vout 2.17312f
C71 vout a_21492_n33080# 0.11851f
C72 a_16282_n31276# clk 0.13091f
C73 a_15296_n31280# VDD 0.04055f
C74 VDDL a_20892_n30925# 0.37987f
C75 GROUP15_0.pmosHV$2_priv7_0.S a_21492_n33445# 0.03816f
C76 a_22216_n34286# GROUP20_0.G 0.11639f
C77 a_19166_n25987# GROUP5_0.pmosHV_priv15_0.S 0.30958f
C78 a_21492_n33445# a_22216_n33446# 0.01042f
C79 a_17642_n29712# GROUP18_0.G 0.03845f
C80 a_17642_n31820# vout 0.04108f
C81 GROUP20_0.G clk 0.0208f
C82 a_17642_n27186# GROUP5_0.pmosHV_priv15_0.D 0.30815f
C83 GROUP18_0.G VDD 0.86188f
C84 GROUP15_0.pmosHV$2_priv7_0.S GROUP16_0.pmosHV$2_priv10_0.D 1.88074f
C85 VDD a_17642_n26821# 0.4548f
C86 vout a_22216_n33081# 0.11526f
C87 a_21290_n28452# GROUP20_0.G 0.03974f
C88 a_16920_n33447# GROUP18_0.G 0.04313f
C89 a_17642_n29347# GROUP20_0.G 0.11422f
C90 vref a_20690_n27186# 0.04142f
C91 a_17642_n26821# GROUP5_0.pmosHV_priv15_0.S 0.33002f
C92 GROUP15_0.pmosHV$2_priv7_0.D GROUP18_0.G 1.88235f
C93 GROUP15_0.pmosHV$2_priv7_0.S vout 6.6419f
C94 GROUP18_0.G GROUP20_0.G 5.67308f
C95 vout GROUP16_0.pmosHV$2_priv10_0.D 0.42301f
C96 VDDL GROUP15_0.pmosHV$2_priv7_0.D 1.55536f
C97 a_16920_n33082# GROUP15_0.pmosHV$2_priv7_0.S 0.11641f
C98 GROUP18_0.G vin 0.22824f
C99 a_17642_n28452# VDD 0.20577f
C100 VDDL GROUP20_0.G 2.90834f
C101 VDD GROUP5_0.pmosHV_priv15_0.D 1.06042f
C102 a_20892_n30925# GROUP16_0.pmosHV$2_priv10_0.D 0.26682f
C103 vin a_17642_n26821# 0.04159f
C104 a_21492_n29347# GROUP20_0.G 0.04107f
C105 vref VDD 1.35117f
C106 GROUP18_0.G GROUP9_0.nmosHV_priv4_0.S 0.17341f
C107 a_16920_n34291# GROUP18_0.G 0.10908f
C108 vref a_20690_n26821# 0.04159f
C109 a_17642_n31820# GROUP15_0.pmosHV$2_priv7_0.D 0.2681f
C110 VDDL a_20892_n31820# 0.37565f
C111 a_17642_n33080# GROUP15_0.pmosHV$2_priv7_0.S 0.11294f
C112 a_22216_n33081# GROUP20_0.G 0.0389f
C113 GROUP5_0.pmosHV_priv15_0.D GROUP5_0.pmosHV_priv15_0.S 0.48035f
C114 a_17642_n30926# GROUP18_0.G 0.04153f
C115 a_15296_n31280# clk 0.11303f
C116 a_17642_n28452# GROUP20_0.G 0.1654f
C117 GROUP20_0.G GROUP5_0.pmosHV_priv15_0.D 0.29318f
C118 vref GROUP5_0.pmosHV_priv15_0.S 2.03213f
C119 VDDL a_17642_n30926# 0.3891f
C120 a_15296_n28979# VDD 0.04038f
C121 vref GROUP20_0.G 0.22824f
C122 vin GROUP5_0.pmosHV_priv15_0.D 2.03701f
C123 VDD a_17642_n27186# 0.45527f
C124 a_20892_n30560# GROUP20_0.G 0.04129f
C125 a_22216_n34651# VSS 0.26503f ; **FLOATING
C126 a_16920_n34656# VSS 0.2554f ; **FLOATING
C127 a_22216_n34286# VSS 0.15979f ; **FLOATING
C128 a_16920_n34291# VSS 0.15567f ; **FLOATING
C129 a_22216_n33446# VSS 0.26924f ; **FLOATING
C130 a_21492_n33445# VSS 0.26584f ; **FLOATING
C131 a_17642_n33445# VSS 0.26859f ; **FLOATING
C132 a_16920_n33447# VSS 0.25822f ; **FLOATING
C133 a_22216_n33081# VSS 0.15444f ; **FLOATING
C134 a_21492_n33080# VSS 0.15472f ; **FLOATING
C135 a_17642_n33080# VSS 0.15456f ; **FLOATING
C136 a_16920_n33082# VSS 0.15174f ; **FLOATING
C137 a_20892_n32185# VSS 0.01403f ; **FLOATING
C138 a_17642_n32185# VSS 0.01455f ; **FLOATING
C139 a_20892_n31820# VSS 0.01403f ; **FLOATING
C140 a_17642_n31820# VSS 0.01442f ; **FLOATING
C141 a_16282_n31276# VSS 0.06183f ; **FLOATING
C142 a_15296_n31280# VSS 0.2287f ; **FLOATING
C143 a_20892_n30925# VSS 0.0166f ; **FLOATING
C144 a_17642_n30926# VSS 0.01862f ; **FLOATING
C145 a_20892_n30560# VSS 0.01974f ; **FLOATING
C146 a_17642_n30561# VSS 0.019f ; **FLOATING
C147 a_21492_n29712# VSS 0.26898f ; **FLOATING
C148 a_17642_n29712# VSS 0.26467f ; **FLOATING
C149 a_21492_n29347# VSS 0.16029f ; **FLOATING
C150 a_17642_n29347# VSS 0.15875f ; **FLOATING
C151 a_16282_n28975# VSS 0.06267f ; **FLOATING
C152 a_15296_n28979# VSS 0.2287f ; **FLOATING
C153 a_21290_n28452# VSS 0.03852f ; **FLOATING
C154 a_19968_n28400# VSS 0.26348f ; **FLOATING
C155 a_19166_n28400# VSS 0.25725f ; **FLOATING
C156 a_17642_n28452# VSS 0.02542f ; **FLOATING
C157 a_21290_n28087# VSS 0.05174f ; **FLOATING
C158 a_19968_n28035# VSS 0.14987f ; **FLOATING
C159 a_19166_n28035# VSS 0.15063f ; **FLOATING
C160 a_17642_n28087# VSS 0.02553f ; **FLOATING
C161 a_20690_n27186# VSS 0.01388f ; **FLOATING
C162 a_17642_n27186# VSS 0.01398f ; **FLOATING
C163 GROUP9_0.nmosHV_priv4_0.S VSS 0.38233f
C164 a_20690_n26821# VSS 0.01388f ; **FLOATING
C165 a_17642_n26821# VSS 0.01398f ; **FLOATING
C166 a_19166_n25987# VSS 0.02594f ; **FLOATING
C167 GROUP5_0.pmosHV_priv15_0.S VSS 0.38233f
C168 a_19166_n25622# VSS 0.02594f ; **FLOATING
C169 GROUP21_0.G.n0 VSS 0.41305f
C170 GROUP21_0.G.n1 VSS 0.04146f
C171 GROUP21_0.G.n2 VSS 2.22973f
C172 GROUP21_0.G.n3 VSS 0.42247f
C173 GROUP21_0.G.n4 VSS 0.08452f
C174 GROUP24_0.pmosHV$3_priv1_0.D VSS 0.13158f
C175 GROUP23_0.nmosHV$1_priv1_0.D VSS 0.32212f
C176 GROUP21_0.G.n5 VSS 2.41783f
C177 GROUP21_0.G.n6 VSS 0.11773f
C178 GROUP21_0.G.n7 VSS 3.51164f
C179 GROUP21_0.G.n8 VSS 0.16784f
C180 GROUP21_0.G.n9 VSS 0.33895f
C181 GROUP21_0.G.n10 VSS 0.17905f
C182 GROUP21_0.G.n11 VSS 0.30409f
C183 GROUP21_0.G.n12 VSS 0.21208f
C184 GROUP4_0.G VSS 0.46671f
C185 GROUP21_0.G.n13 VSS 0.89194f
C186 GROUP8_0.G VSS 0.30449f
C187 GROUP21_0.G.n14 VSS 2.20255f
C188 GROUP21_0.G.t14 VSS 8.19185f
C189 GROUP21_0.G.t15 VSS 0.17443f
C190 GROUP21_0.G.n15 VSS 0.08452f
C191 GROUP21_0.G.t16 VSS 0.17443f
C192 GROUP21_0.G.t17 VSS 0.17443f
C193 GROUP21_0.G.t18 VSS 0.17443f
C194 GROUP21_0.G.t19 VSS 0.16118f
C195 GROUP21_0.G.n16 VSS 0.06209f
C196 GROUP21_0.G.n17 VSS 0.04706f
C197 GROUP21_0.G.n18 VSS 0.08452f
C198 GROUP21_0.G.n19 VSS 0.09955f
C199 GROUP21_0.G.n20 VSS 0.09955f
C200 GROUP21_0.G.n21 VSS 0.09955f
C201 GROUP21_0.G.t13 VSS 0.12108f
C202 GROUP21_0.G.t1 VSS 0.23091f
C203 GROUP21_0.G.t2 VSS 0.22604f
C204 GROUP21_0.G.n22 VSS 0.06826f
C205 GROUP21_0.G.t6 VSS 0.12108f
C206 GROUP21_0.G.t4 VSS 0.22884f
C207 GROUP21_0.G.t5 VSS 0.22627f
C208 GROUP21_0.G.n23 VSS 0.06826f
C209 GROUP21_0.G.t7 VSS 0.17443f
C210 GROUP21_0.G.n24 VSS 0.2546f
C211 GROUP21_0.G.n25 VSS 0.08452f
C212 GROUP21_0.G.t8 VSS 0.17443f
C213 GROUP21_0.G.t9 VSS 0.17443f
C214 GROUP21_0.G.t10 VSS 0.17443f
C215 GROUP21_0.G.t11 VSS 0.17443f
C216 GROUP21_0.G.n26 VSS 0.09955f
C217 GROUP21_0.G.t12 VSS 0.16118f
C218 GROUP21_0.G.n27 VSS 0.06209f
C219 GROUP21_0.G.n28 VSS 0.04706f
C220 GROUP21_0.G.n29 VSS 0.08452f
C221 GROUP21_0.G.n30 VSS 0.08452f
C222 GROUP21_0.G.n31 VSS 0.09955f
C223 GROUP21_0.G.n32 VSS 0.09955f
C224 GROUP21_0.G.n33 VSS 0.09955f
C225 GROUP21_0.G.n34 VSS 0.08452f
C226 GROUP22_0.G VSS 0.31278f
C227 GROUP21_0.G.n35 VSS 2.97696f
C228 VSS.t14 VSS 0.12392f
C229 VSS.t68 VSS 0.11827f
C230 VSS.t19 VSS 0.58967f
C231 VSS.t12 VSS 0.11427f
C232 VSS.t16 VSS 0.11786f
C233 VSS.t20 VSS 1.17935f
.ends
