* PEX produced on Mon Sep 14 05:22:31 CEST 2026 using scripts/sak-pex.sh with m=3 and s=1 (extresist threshold=10000 mOhm, minres=1000 mOhm, mindelay=1 ps)
* NGSPICE file created from comparator_group_pex.ext - technology: ihp-sg13cmos5l

.subckt comparator_group_pex VDDL VDD vin q3 VSS q2 q1 q0 clk_h vref_1 vref_2
+ vref_3 vref_4
X0 VSS.t181 VSS.t179 VSS.t180 VSS.t176 sg13_hv_nmos ad=0.34p pd=2.68u as=0 ps=0 w=1u l=0.5u
X1 GROUP10_2.pmosHV$1_priv4_0.D GROUP10_2.pmosHV$1_priv4_0.D GROUP10_2.pmosHV$1_priv4_0.D VSS.t265 sg13_hv_nmos ad=0.34p pd=2.68u as=45.658p ps=0.23585m w=1u l=0.5u
X2 VDDL.t31 GROUP20_0.G GROUP16_0.pmosHV$2_priv10_0.D VDDL.t0 sg13_hv_pmos ad=1.36p pd=8.68u as=1.36p ps=8.68u w=4u l=0.5u
X3 GROUP22_0.G.t3 VDD.t50 clk_h.t69 VSS.t35 sg13_hv_nmos ad=0.38p pd=2.38u as=0.38p ps=2.38u w=2u l=0.5u
X4 GROUP22_3.G.t1 VDD.t42 clk_h.t37 VSS.t43 sg13_hv_nmos ad=0.38p pd=2.38u as=0.38p ps=2.38u w=2u l=0.5u
X5 clk_h.t26 VDD.t29 GROUP22_2.G.t1 VSS.t56 sg13_hv_nmos ad=0.38p pd=2.38u as=0.38p ps=2.38u w=2u l=0.5u
X6 GROUP22_0.G.t11 VSS.t340 clk_h.t31 VDD.t1 sg13_hv_pmos ad=0.38p pd=2.38u as=0.38p ps=2.38u w=2u l=0.5u
X7 GROUP20_0.G GROUP10_0.pmosHV$1_priv4_0.D VSS.t80 VSS.t79 sg13_hv_nmos ad=0.34p pd=2.68u as=0.34p ps=2.68u w=1u l=0.5u
X8 q0 q0 q0 VSS.t251 sg13_hv_nmos ad=0.34p pd=2.68u as=24.1098p ps=0.13178m w=1u l=0.5u
X9 clk_h.t39 VDD.t35 GROUP22_3.G.t4 VSS.t50 sg13_hv_nmos ad=0.38p pd=2.38u as=0.38p ps=2.38u w=2u l=0.5u
X10 GROUP22_2.G.t5 VDD.t22 clk_h.t68 VSS.t63 sg13_hv_nmos ad=0.38p pd=2.38u as=0.38p ps=2.38u w=2u l=0.5u
X11 VDDL.t32 GROUP12_3.nmosHV_priv10_0.S GROUP15_2.pmosHV$2_priv7_0.D VDDL.t10 sg13_hv_pmos ad=1.36p pd=8.68u as=1.36p ps=8.68u w=4u l=0.5u
X12 GROUP8_2.nmosHV_priv1_0.S GROUP8_2.nmosHV_priv1_0.S GROUP8_2.nmosHV_priv1_0.S VDD.t3 sg13_hv_pmos ad=1.7p pd=10.68u as=13.2594p ps=51.74u w=5u l=0.5u
X13 VDD.t18 GROUP22_2.G.t21 GROUP6_2.pmosHV_priv16_0.S VDD.t3 sg13_hv_pmos ad=1.7p pd=10.68u as=1.7p ps=10.68u w=5u l=0.5u
X14 GROUP13_1.pmosHV$2_priv1_0.D q1 GROUP19_0.G VDDL.t0 sg13_hv_pmos ad=1.36p pd=8.68u as=1.36p ps=8.68u w=4u l=0.5u
X15 clk_h.t56 VDD.t33 GROUP22_3.G.t5 VSS.t52 sg13_hv_nmos ad=0.38p pd=2.38u as=0.38p ps=2.38u w=2u l=0.5u
X16 GROUP22_2.G.t6 VDD.t20 clk_h.t57 VSS.t65 sg13_hv_nmos ad=0.68p pd=4.68u as=0.38p ps=2.38u w=2u l=0.5u
X17 GROUP8_1.nmosHV_priv1_0.S GROUP10_0.pmosHV$1_priv4_0.D GROUP20_0.G VDD.t1 sg13_hv_pmos ad=0.68p pd=4.68u as=0.68p ps=4.68u w=2u l=0.5u
X18 clk_h.t29 VSS.t323 GROUP22_2.G.t13 VDD.t3 sg13_hv_pmos ad=0.38p pd=2.38u as=0.68p ps=4.68u w=2u l=0.5u
X19 VDDL.t19 VDDL.t17 VDDL.t18 VDDL.t1 sg13_hv_pmos ad=1.36p pd=8.68u as=0 ps=0 w=4u l=0.5u
X20 GROUP10_1.pmosHV$1_priv4_0.S GROUP10_1.pmosHV$1_priv4_0.S GROUP10_1.pmosHV$1_priv4_0.S VSS.t261 sg13_hv_nmos ad=0.34p pd=2.68u as=13.2594p ps=51.74u w=1u l=0.5u
X21 GROUP10_2.pmosHV$1_priv4_0.S GROUP22_2.G.t22 VSS.t299 VSS.t298 sg13_hv_nmos ad=0.34p pd=2.68u as=0.34p ps=2.68u w=1u l=0.5u
X22 GROUP10_0.pmosHV$1_priv4_0.S GROUP10_0.pmosHV$1_priv4_0.S GROUP10_0.pmosHV$1_priv4_0.S VDD.t1 sg13_hv_pmos ad=1.7p pd=10.68u as=13.2594p ps=51.74u w=5u l=0.5u
X23 GROUP12_1.nmosHV_priv10_0.S GROUP12_1.nmosHV_priv10_0.S GROUP12_1.nmosHV_priv10_0.S VDD.t0 sg13_hv_pmos ad=0.68p pd=4.68u as=45.658p ps=0.23585m w=2u l=0.5u
X24 clk_h.t6 clk_h.t4 clk_h.t5 VSS.t7 sg13_hv_nmos ad=0.68p pd=4.68u as=0 ps=0 w=2u l=0.5u
X25 GROUP6_2.pmosHV_priv16_0.S GROUP6_2.pmosHV_priv16_0.S GROUP6_2.pmosHV_priv16_0.S VDD.t3 sg13_hv_pmos ad=1.7p pd=10.68u as=21.6594p ps=79.74u w=5u l=0.5u
X26 GROUP10_0.pmosHV$1_priv4_0.D GROUP20_0.G VSS.t93 VSS.t92 sg13_hv_nmos ad=0.34p pd=2.68u as=0.34p ps=2.68u w=1u l=0.5u
X27 GROUP22_1.G.t12 VDD.t56 clk_h.t61 VSS.t29 sg13_hv_nmos ad=0.68p pd=4.68u as=0.38p ps=2.38u w=2u l=0.5u
X28 q0 GROUP20_1.G VSS.t71 VSS.t70 sg13_hv_nmos ad=0.34p pd=2.68u as=0.34p ps=2.68u w=1u l=0.5u
X29 GROUP20_0.G GROUP20_0.G GROUP20_0.G VDD.t1 sg13_hv_pmos ad=0.68p pd=4.68u as=45.5261p ps=0.23483m w=2u l=0.5u
X30 VSS.t223 VSS.t220 VSS.t222 VSS.t221 sg13_hv_nmos ad=0.34p pd=2.68u as=0 ps=0 w=1u l=0.5u
X31 clk_h.t64 VSS.t359 GROUP22_1.G.t13 VDD.t0 sg13_hv_pmos ad=0.38p pd=2.38u as=0.68p ps=4.68u w=2u l=0.5u
X32 GROUP19_3.G GROUP19_3.G GROUP19_3.G VDDL.t10 sg13_hv_pmos ad=1.36p pd=8.68u as=24.5292p ps=0.13411m w=4u l=0.5u
X33 clk_h.t63 VSS.t357 GROUP22_1.G.t14 VDD.t0 sg13_hv_pmos ad=0.38p pd=2.38u as=0.38p ps=2.38u w=2u l=0.5u
X34 VSS.t120 VSS.t117 VSS.t119 VSS.t118 sg13_hv_nmos ad=0.34p pd=2.68u as=0 ps=0 w=1u l=0.5u
X35 GROUP19_0.G GROUP19_0.G GROUP19_0.G VSS.t1 sg13_hv_nmos ad=0.34p pd=2.68u as=24.5292p ps=0.13411m w=1u l=0.5u
X36 GROUP8_3.nmosHV_priv1_0.S GROUP8_3.nmosHV_priv1_0.S GROUP8_3.nmosHV_priv1_0.S VDD.t2 sg13_hv_pmos ad=0.68p pd=4.68u as=13.2594p ps=51.74u w=2u l=0.5u
X37 GROUP8_0.nmosHV_priv1_0.S GROUP22_1.G.t23 VSS.t306 VSS.t291 sg13_hv_nmos ad=0.34p pd=2.68u as=0.34p ps=2.68u w=1u l=0.5u
X38 VDD.t13 VDD.t11 VDD.t12 VDD.t2 sg13_hv_pmos ad=1.7p pd=10.68u as=0 ps=0 w=5u l=0.5u
X39 VSS.t185 VSS.t182 VSS.t184 VSS.t183 sg13_hv_nmos ad=0.34p pd=2.68u as=0 ps=0 w=1u l=0.5u
X40 GROUP22_1.G.t18 VSS.t350 clk_h.t50 VDD.t0 sg13_hv_pmos ad=0.38p pd=2.38u as=0.38p ps=2.38u w=2u l=0.5u
X41 GROUP22_0.G.t8 VSS.t346 clk_h.t66 VDD.t1 sg13_hv_pmos ad=0.38p pd=2.38u as=0.38p ps=2.38u w=2u l=0.5u
X42 GROUP22_0.G.t9 VSS.t344 clk_h.t33 VDD.t1 sg13_hv_pmos ad=0.38p pd=2.38u as=0.38p ps=2.38u w=2u l=0.5u
X43 GROUP8_0.nmosHV_priv1_0.S GROUP12_1.nmosHV_priv10_0.S GROUP20_1.G VDD.t0 sg13_hv_pmos ad=0.68p pd=4.68u as=0.68p ps=4.68u w=2u l=0.5u
X44 VDDL.t34 GROUP20_2.G GROUP14_2.pmosHV$2_priv4_0.S VDDL.t14 sg13_hv_pmos ad=1.36p pd=8.68u as=1.36p ps=8.68u w=4u l=0.5u
X45 clk_h.t25 VDD.t49 GROUP22_0.G.t3 VSS.t36 sg13_hv_nmos ad=0.38p pd=2.38u as=0.38p ps=2.38u w=2u l=0.5u
X46 clk_h.t0 VDD.t41 GROUP22_3.G.t1 VSS.t44 sg13_hv_nmos ad=0.38p pd=2.38u as=0.38p ps=2.38u w=2u l=0.5u
X47 GROUP22_2.G.t2 VDD.t28 clk_h.t26 VSS.t57 sg13_hv_nmos ad=0.38p pd=2.38u as=0.38p ps=2.38u w=2u l=0.5u
X48 clk_h.t68 VDD.t23 GROUP22_2.G.t4 VSS.t62 sg13_hv_nmos ad=0.38p pd=2.38u as=0.38p ps=2.38u w=2u l=0.5u
X49 GROUP22_2.G.t17 VSS.t316 clk_h.t45 VDD.t3 sg13_hv_pmos ad=0.38p pd=2.38u as=0.38p ps=2.38u w=2u l=0.5u
X50 GROUP10_1.pmosHV$1_priv4_0.S GROUP10_1.pmosHV$1_priv4_0.S GROUP10_1.pmosHV$1_priv4_0.S VDD.t0 sg13_hv_pmos ad=1.7p pd=10.68u as=0 ps=0 w=5u l=0.5u
X51 GROUP22_3.G.t5 VDD.t34 clk_h.t39 VSS.t51 sg13_hv_nmos ad=0.38p pd=2.38u as=0.38p ps=2.38u w=2u l=0.5u
X52 clk_h.t57 VDD.t21 GROUP22_2.G.t5 VSS.t64 sg13_hv_nmos ad=0.38p pd=2.38u as=0.38p ps=2.38u w=2u l=0.5u
X53 GROUP15_0.pmosHV$2_priv7_0.D GROUP15_0.pmosHV$2_priv7_0.D GROUP15_0.pmosHV$2_priv7_0.D VDDL.t1 sg13_hv_pmos ad=1.36p pd=8.68u as=12.0396p ps=45.16u w=4u l=0.5u
X54 GROUP13_3.pmosHV$2_priv1_0.D q3 GROUP19_2.G VDDL.t14 sg13_hv_pmos ad=1.36p pd=8.68u as=1.36p ps=8.68u w=4u l=0.5u
X55 VDD.t19 GROUP22_3.G.t21 GROUP6_3.pmosHV_priv16_0.S VDD.t2 sg13_hv_pmos ad=1.7p pd=10.68u as=1.7p ps=10.68u w=5u l=0.5u
X56 GROUP10_0.pmosHV$1_priv4_0.S GROUP20_0.G GROUP10_0.pmosHV$1_priv4_0.D VDD.t1 sg13_hv_pmos ad=0.68p pd=4.68u as=0.68p ps=4.68u w=2u l=0.5u
X57 GROUP22_3.G.t6 VDD.t32 clk_h.t56 VSS.t53 sg13_hv_nmos ad=0.68p pd=4.68u as=0.38p ps=2.38u w=2u l=0.5u
X58 q1 q1 q1 VSS.t74 sg13_hv_nmos ad=0.34p pd=2.68u as=24.1098p ps=0.13178m w=1u l=0.5u
X59 GROUP19_2.G GROUP10_2.pmosHV$1_priv4_0.D VSS.t267 VSS.t266 sg13_hv_nmos ad=0.34p pd=2.68u as=0.34p ps=2.68u w=1u l=0.5u
X60 clk_h.t71 VSS.t335 GROUP22_3.G.t7 VDD.t2 sg13_hv_pmos ad=0.38p pd=2.38u as=0.68p ps=4.68u w=2u l=0.5u
X61 GROUP6_0.pmosHV_priv16_0.S vin.t2 GROUP8_1.nmosHV_priv1_0.S VDD.t1 sg13_hv_pmos ad=1.7p pd=10.68u as=1.7p ps=10.68u w=5u l=0.5u
X62 GROUP8_3.nmosHV_priv1_0.S GROUP22_3.G.t23 VSS.t11 VSS.t10 sg13_hv_nmos ad=0.34p pd=2.68u as=0.34p ps=2.68u w=1u l=0.5u
X63 GROUP22_1.G.t9 VDD.t62 clk_h.t59 VSS.t23 sg13_hv_nmos ad=0.38p pd=2.38u as=0.38p ps=2.38u w=2u l=0.5u
X64 clk_h.t12 clk_h.t10 clk_h.t11 VSS.t9 sg13_hv_nmos ad=0.68p pd=4.68u as=0 ps=0 w=2u l=0.5u
X65 VSS.t108 VSS.t105 VSS.t107 VSS.t106 sg13_hv_nmos ad=0.34p pd=2.68u as=0 ps=0 w=1u l=0.5u
X66 GROUP13_1.pmosHV$2_priv1_0.D GROUP13_1.pmosHV$2_priv1_0.D GROUP13_1.pmosHV$2_priv1_0.D VDDL.t0 sg13_hv_pmos ad=1.36p pd=8.68u as=12.0396p ps=45.16u w=4u l=0.5u
X67 q2 GROUP22_3.nmosHV_priv28_0.D VSS.t311 VSS.t277 sg13_hv_nmos ad=0.34p pd=2.68u as=0.34p ps=2.68u w=1u l=0.5u
X68 VSS.t160 VSS.t157 VSS.t159 VSS.t158 sg13_hv_nmos ad=0.34p pd=2.68u as=0 ps=0 w=1u l=0.5u
X69 GROUP10_0.pmosHV$1_priv4_0.S GROUP10_0.pmosHV$1_priv4_0.S GROUP10_0.pmosHV$1_priv4_0.S VSS.t87 sg13_hv_nmos ad=0.34p pd=2.68u as=0 ps=0 w=1u l=0.5u
X70 GROUP6_0.pmosHV_priv16_0.S GROUP6_0.pmosHV_priv16_0.S GROUP6_0.pmosHV_priv16_0.S VDD.t1 sg13_hv_pmos ad=1.7p pd=10.68u as=21.6594p ps=79.74u w=5u l=0.5u
X71 GROUP22_2.G.t12 GROUP22_2.G.t10 GROUP22_2.G.t11 VDD.t3 sg13_hv_pmos ad=0.68p pd=4.68u as=0 ps=0 w=2u l=0.5u
X72 VSS.t132 VSS.t129 VSS.t131 VSS.t130 sg13_hv_nmos ad=0.34p pd=2.68u as=0 ps=0 w=1u l=0.5u
X73 GROUP15_0.pmosHV$2_priv7_0.D q0 GROUP16_1.G VDDL.t1 sg13_hv_pmos ad=1.36p pd=8.68u as=1.36p ps=8.68u w=4u l=0.5u
X74 VDDL.t12 VDDL.t9 VDDL.t11 VDDL.t10 sg13_hv_pmos ad=1.36p pd=8.68u as=0 ps=0 w=4u l=0.5u
X75 GROUP6_2.pmosHV_priv16_0.S vin.t0 GROUP8_2.nmosHV_priv1_0.S VDD.t3 sg13_hv_pmos ad=1.7p pd=10.68u as=1.7p ps=10.68u w=5u l=0.5u
X76 GROUP20_0.G GROUP22_0.G.t20 VSS.t254 VSS.t253 sg13_hv_nmos ad=0.34p pd=2.68u as=0.34p ps=2.68u w=1u l=0.5u
X77 GROUP10_0.pmosHV$1_priv4_0.D GROUP10_0.pmosHV$1_priv4_0.D GROUP10_0.pmosHV$1_priv4_0.D VDD.t1 sg13_hv_pmos ad=0.68p pd=4.68u as=45.658p ps=0.23585m w=2u l=0.5u
X78 GROUP16_1.G GROUP12_1.nmosHV_priv10_0.S VSS.t16 VSS.t15 sg13_hv_nmos ad=0.34p pd=2.68u as=0.34p ps=2.68u w=1u l=0.5u
X79 GROUP20_0.G GROUP20_0.G GROUP20_0.G VSS.t91 sg13_hv_nmos ad=0.34p pd=2.68u as=0 ps=0 w=1u l=0.5u
X80 q3 q3 q3 VDDL.t14 sg13_hv_pmos ad=1.36p pd=8.68u as=24.1098p ps=0.13178m w=4u l=0.5u
X81 GROUP10_3.pmosHV$1_priv4_0.S GROUP10_3.pmosHV$1_priv4_0.S GROUP10_3.pmosHV$1_priv4_0.S VDD.t2 sg13_hv_pmos ad=0.68p pd=4.68u as=13.2594p ps=51.74u w=2u l=0.5u
X82 VSS.t128 VSS.t125 VSS.t127 VSS.t126 sg13_hv_nmos ad=0.34p pd=2.68u as=0 ps=0 w=1u l=0.5u
X83 GROUP20_2.G GROUP20_2.G GROUP20_2.G VDD.t3 sg13_hv_pmos ad=0.68p pd=4.68u as=45.5261p ps=0.23483m w=2u l=0.5u
X84 GROUP10_2.pmosHV$1_priv4_0.S GROUP10_2.pmosHV$1_priv4_0.S GROUP10_2.pmosHV$1_priv4_0.S VSS.t88 sg13_hv_nmos ad=0.34p pd=2.68u as=13.2594p ps=51.74u w=1u l=0.5u
X85 VDD.t16 VDD.t14 VDD.t15 VDD.t3 sg13_hv_pmos ad=1.7p pd=10.68u as=0 ps=0 w=5u l=0.5u
X86 GROUP22_1.G.t15 VSS.t356 clk_h.t63 VDD.t0 sg13_hv_pmos ad=0.38p pd=2.38u as=0.38p ps=2.38u w=2u l=0.5u
X87 clk_h.t50 VSS.t351 GROUP22_1.G.t17 VDD.t0 sg13_hv_pmos ad=0.38p pd=2.38u as=0.38p ps=2.38u w=2u l=0.5u
X88 VSS.t178 VSS.t175 VSS.t177 VSS.t176 sg13_hv_nmos ad=0.34p pd=2.68u as=0 ps=0 w=1u l=0.5u
X89 clk_h.t67 VSS.t349 GROUP22_1.G.t18 VDD.t0 sg13_hv_pmos ad=0.38p pd=2.38u as=0.38p ps=2.38u w=2u l=0.5u
X90 GROUP10_1.pmosHV$1_priv4_0.S GROUP20_1.G GROUP12_1.nmosHV_priv10_0.S VDD.t0 sg13_hv_pmos ad=0.68p pd=4.68u as=0.68p ps=4.68u w=2u l=0.5u
X91 clk_h.t48 VDD.t55 GROUP22_0.G.t0 VSS.t30 sg13_hv_nmos ad=0.38p pd=2.38u as=0.68p ps=4.68u w=2u l=0.5u
X92 clk_h.t33 VSS.t345 GROUP22_0.G.t8 VDD.t1 sg13_hv_pmos ad=0.38p pd=2.38u as=0.38p ps=2.38u w=2u l=0.5u
X93 GROUP8_3.nmosHV_priv1_0.S GROUP8_3.nmosHV_priv1_0.S GROUP8_3.nmosHV_priv1_0.S VDD.t2 sg13_hv_pmos ad=1.7p pd=10.68u as=0 ps=0 w=5u l=0.5u
X94 VSS.t219 VSS.t216 VSS.t218 VSS.t217 sg13_hv_nmos ad=0.34p pd=2.68u as=0 ps=0 w=1u l=0.5u
X95 GROUP22_3.G.t2 VDD.t40 clk_h.t0 VSS.t45 sg13_hv_nmos ad=0.38p pd=2.38u as=0.38p ps=2.38u w=2u l=0.5u
X96 clk_h.t36 VDD.t27 GROUP22_2.G.t2 VSS.t58 sg13_hv_nmos ad=0.38p pd=2.38u as=0.38p ps=2.38u w=2u l=0.5u
X97 VSS.t191 VSS.t189 VSS.t190 VSS.t130 sg13_hv_nmos ad=0.34p pd=2.68u as=0 ps=0 w=1u l=0.5u
X98 GROUP22_1.G.t2 GROUP22_1.G.t0 GROUP22_1.G.t1 VSS.t297 sg13_hv_nmos ad=0.68p pd=4.68u as=0 ps=0 w=2u l=0.5u
X99 clk_h.t32 VSS.t343 GROUP22_0.G.t9 VDD.t1 sg13_hv_pmos ad=0.38p pd=2.38u as=0.38p ps=2.38u w=2u l=0.5u
X100 GROUP22_0.G.t12 VSS.t338 clk_h.t47 VDD.t1 sg13_hv_pmos ad=0.38p pd=2.38u as=0.38p ps=2.38u w=2u l=0.5u
X101 VDDL.t35 GROUP22_3.nmosHV_priv28_0.D GROUP16_3.pmosHV$2_priv10_0.D VDDL.t10 sg13_hv_pmos ad=1.36p pd=8.68u as=1.36p ps=8.68u w=4u l=0.5u
X102 GROUP10_0.pmosHV$1_priv4_0.D GROUP10_0.pmosHV$1_priv4_0.D GROUP10_0.pmosHV$1_priv4_0.D VSS.t81 sg13_hv_nmos ad=0.34p pd=2.68u as=0 ps=0 w=1u l=0.5u
X103 GROUP22_3.G.t3 VDD.t38 clk_h.t34 VSS.t47 sg13_hv_nmos ad=0.38p pd=2.38u as=0.38p ps=2.38u w=2u l=0.5u
X104 clk_h.t49 VDD.t25 GROUP22_2.G.t3 VSS.t60 sg13_hv_nmos ad=0.38p pd=2.38u as=0.38p ps=2.38u w=2u l=0.5u
X105 GROUP22_0.G.t13 VSS.t336 clk_h.t46 VDD.t1 sg13_hv_pmos ad=0.68p pd=4.68u as=0.38p ps=2.38u w=2u l=0.5u
X106 GROUP22_3.G.t11 VSS.t328 clk_h.t54 VDD.t2 sg13_hv_pmos ad=0.38p pd=2.38u as=0.38p ps=2.38u w=2u l=0.5u
X107 GROUP22_3.nmosHV_priv28_0.D GROUP12_3.nmosHV_priv10_0.S VSS.t259 VSS.t258 sg13_hv_nmos ad=0.34p pd=2.68u as=0.34p ps=2.68u w=1u l=0.5u
X108 VSS.t238 VSS.t235 VSS.t237 VSS.t236 sg13_hv_nmos ad=0.34p pd=2.68u as=0 ps=0 w=1u l=0.5u
X109 GROUP16_0.pmosHV$2_priv10_0.D GROUP19_0.G q1 VDDL.t0 sg13_hv_pmos ad=1.36p pd=8.68u as=1.36p ps=8.68u w=4u l=0.5u
X110 clk_h.t15 clk_h.t13 clk_h.t14 VDD.t0 sg13_hv_pmos ad=0.68p pd=4.68u as=0 ps=0 w=2u l=0.5u
X111 GROUP15_2.pmosHV$2_priv7_0.D q2 GROUP19_3.G VDDL.t10 sg13_hv_pmos ad=1.36p pd=8.68u as=1.36p ps=8.68u w=4u l=0.5u
X112 GROUP19_3.G GROUP12_3.nmosHV_priv10_0.S VSS.t257 VSS.t256 sg13_hv_nmos ad=0.34p pd=2.68u as=0.34p ps=2.68u w=1u l=0.5u
X113 GROUP8_0.nmosHV_priv1_0.S GROUP8_0.nmosHV_priv1_0.S GROUP8_0.nmosHV_priv1_0.S VSS.t261 sg13_hv_nmos ad=0.34p pd=2.68u as=13.2594p ps=51.74u w=1u l=0.5u
X114 GROUP20_1.G GROUP20_1.G GROUP20_1.G VSS.t69 sg13_hv_nmos ad=0.34p pd=2.68u as=45.5261p ps=0.23483m w=1u l=0.5u
X115 GROUP13_1.pmosHV$2_priv1_0.D GROUP13_1.pmosHV$2_priv1_0.D GROUP13_1.pmosHV$2_priv1_0.D VDDL.t0 sg13_hv_pmos ad=1.36p pd=8.68u as=0 ps=0 w=4u l=0.5u
X116 GROUP8_2.nmosHV_priv1_0.S GROUP22_2.G.t23 VSS.t300 VSS.t298 sg13_hv_nmos ad=0.34p pd=2.68u as=0.34p ps=2.68u w=1u l=0.5u
X117 GROUP6_1.pmosHV_priv16_0.S GROUP6_1.pmosHV_priv16_0.S GROUP6_1.pmosHV_priv16_0.S VDD.t0 sg13_hv_pmos ad=1.7p pd=10.68u as=21.6594p ps=79.74u w=5u l=0.5u
X118 clk_h.t42 VDD.t61 GROUP22_1.G.t9 VSS.t24 sg13_hv_nmos ad=0.38p pd=2.38u as=0.38p ps=2.38u w=2u l=0.5u
X119 VDDL.t16 VDDL.t13 VDDL.t15 VDDL.t14 sg13_hv_pmos ad=1.36p pd=8.68u as=0 ps=0 w=4u l=0.5u
X120 clk_h.t9 clk_h.t7 clk_h.t8 VSS.t8 sg13_hv_nmos ad=0.68p pd=4.68u as=0 ps=0 w=2u l=0.5u
X121 VSS.t152 VSS.t149 VSS.t151 VSS.t150 sg13_hv_nmos ad=0.34p pd=2.68u as=0 ps=0 w=1u l=0.5u
X122 GROUP10_2.pmosHV$1_priv4_0.S GROUP10_2.pmosHV$1_priv4_0.S GROUP10_2.pmosHV$1_priv4_0.S VDD.t3 sg13_hv_pmos ad=1.7p pd=10.68u as=0 ps=0 w=5u l=0.5u
X123 GROUP20_2.G GROUP22_2.G.t20 VSS.t288 VSS.t287 sg13_hv_nmos ad=0.34p pd=2.68u as=0.34p ps=2.68u w=1u l=0.5u
X124 GROUP10_2.pmosHV$1_priv4_0.D GROUP10_2.pmosHV$1_priv4_0.D GROUP10_2.pmosHV$1_priv4_0.D VDD.t3 sg13_hv_pmos ad=0.68p pd=4.68u as=0 ps=0 w=2u l=0.5u
X125 GROUP12_3.nmosHV_priv10_0.S GROUP22_3.nmosHV_priv28_0.D VSS.t309 VSS.t308 sg13_hv_nmos ad=0.34p pd=2.68u as=0.34p ps=2.68u w=1u l=0.5u
X126 GROUP22_3.G.t19 GROUP22_3.G.t17 GROUP22_3.G.t18 VDD.t2 sg13_hv_pmos ad=0.68p pd=4.68u as=0 ps=0 w=2u l=0.5u
X127 GROUP20_2.G GROUP20_2.G GROUP20_2.G VSS.t280 sg13_hv_nmos ad=0.34p pd=2.68u as=0 ps=0 w=1u l=0.5u
X128 q2 q2 q2 VDDL.t10 sg13_hv_pmos ad=1.36p pd=8.68u as=24.1098p ps=0.13178m w=4u l=0.5u
X129 GROUP22_0.G.t4 VDD.t48 clk_h.t25 VSS.t37 sg13_hv_nmos ad=0.38p pd=2.38u as=0.38p ps=2.38u w=2u l=0.5u
X130 VSS.t140 VSS.t137 VSS.t139 VSS.t138 sg13_hv_nmos ad=0.34p pd=2.68u as=0 ps=0 w=1u l=0.5u
X131 GROUP22_3.nmosHV_priv28_0.D GROUP22_3.nmosHV_priv28_0.D GROUP22_3.nmosHV_priv28_0.D VDD.t2 sg13_hv_pmos ad=0.68p pd=4.68u as=45.5261p ps=0.23483m w=2u l=0.5u
X132 clk_h.t52 VSS.t355 GROUP22_1.G.t15 VDD.t0 sg13_hv_pmos ad=0.38p pd=2.38u as=0.38p ps=2.38u w=2u l=0.5u
X133 GROUP6_1.pmosHV_priv16_0.S vin.t3 GROUP8_0.nmosHV_priv1_0.S VDD.t0 sg13_hv_pmos ad=1.7p pd=10.68u as=1.7p ps=10.68u w=5u l=0.5u
X134 GROUP19_3.G GROUP19_3.G GROUP19_3.G VSS.t276 sg13_hv_nmos ad=0.34p pd=2.68u as=0 ps=0 w=1u l=0.5u
X135 GROUP15_0.pmosHV$2_priv7_0.D GROUP15_0.pmosHV$2_priv7_0.D GROUP15_0.pmosHV$2_priv7_0.D VDDL.t1 sg13_hv_pmos ad=1.36p pd=8.68u as=0 ps=0 w=4u l=0.5u
X136 GROUP22_3.G.t8 VSS.t334 clk_h.t71 VDD.t2 sg13_hv_pmos ad=0.38p pd=2.38u as=0.38p ps=2.38u w=2u l=0.5u
X137 clk_h.t28 VSS.t321 GROUP22_2.G.t14 VDD.t3 sg13_hv_pmos ad=0.38p pd=2.38u as=0.38p ps=2.38u w=2u l=0.5u
X138 GROUP10_0.pmosHV$1_priv4_0.D GROUP22_0.G.t24 VSS.t286 VSS.t285 sg13_hv_nmos ad=0.34p pd=2.68u as=0.34p ps=2.68u w=1u l=0.5u
X139 GROUP20_1.G GROUP20_1.G GROUP20_1.G VSS.t66 sg13_hv_nmos ad=0.34p pd=2.68u as=0 ps=0 w=1u l=0.5u
X140 q2 q2 q2 VSS.t86 sg13_hv_nmos ad=0.34p pd=2.68u as=0 ps=0 w=1u l=0.5u
X141 q1 GROUP20_0.G VSS.t95 VSS.t2 sg13_hv_nmos ad=0.34p pd=2.68u as=0.34p ps=2.68u w=1u l=0.5u
X142 VSS.t211 VSS.t208 VSS.t210 VSS.t209 sg13_hv_nmos ad=0.34p pd=2.68u as=0 ps=0 w=1u l=0.5u
X143 clk_h.t34 VDD.t39 GROUP22_3.G.t2 VSS.t46 sg13_hv_nmos ad=0.38p pd=2.38u as=0.38p ps=2.38u w=2u l=0.5u
X144 GROUP22_2.G.t3 VDD.t26 clk_h.t36 VSS.t59 sg13_hv_nmos ad=0.38p pd=2.38u as=0.38p ps=2.38u w=2u l=0.5u
X145 VSS.t100 VSS.t97 VSS.t99 VSS.t98 sg13_hv_nmos ad=0.34p pd=2.68u as=0 ps=0 w=1u l=0.5u
X146 clk_h.t46 VSS.t337 GROUP22_0.G.t12 VDD.t1 sg13_hv_pmos ad=0.38p pd=2.38u as=0.38p ps=2.38u w=2u l=0.5u
X147 GROUP20_2.G GROUP10_2.pmosHV$1_priv4_0.D VSS.t269 VSS.t268 sg13_hv_nmos ad=0.34p pd=2.68u as=0.34p ps=2.68u w=1u l=0.5u
X148 clk_h.t41 VDD.t37 GROUP22_3.G.t3 VSS.t48 sg13_hv_nmos ad=0.38p pd=2.38u as=0.38p ps=2.38u w=2u l=0.5u
X149 GROUP16_1.G GROUP16_1.G GROUP16_1.G VSS.t263 sg13_hv_nmos ad=0.34p pd=2.68u as=24.5292p ps=0.13411m w=1u l=0.5u
X150 GROUP10_2.pmosHV$1_priv4_0.D GROUP10_2.pmosHV$1_priv4_0.D GROUP10_2.pmosHV$1_priv4_0.D VSS.t270 sg13_hv_nmos ad=0.34p pd=2.68u as=0 ps=0 w=1u l=0.5u
X151 GROUP16_1.pmosHV$2_priv10_0.D GROUP16_1.pmosHV$2_priv10_0.D GROUP16_1.pmosHV$2_priv10_0.D VDDL.t1 sg13_hv_pmos ad=1.36p pd=8.68u as=12.0396p ps=45.16u w=4u l=0.5u
X152 GROUP22_3.nmosHV_priv28_0.D GROUP22_3.nmosHV_priv28_0.D GROUP22_3.nmosHV_priv28_0.D VSS.t310 sg13_hv_nmos ad=0.34p pd=2.68u as=0 ps=0 w=1u l=0.5u
X153 GROUP14_2.pmosHV$2_priv4_0.S GROUP19_2.G q3 VDDL.t14 sg13_hv_pmos ad=1.36p pd=8.68u as=1.36p ps=8.68u w=4u l=0.5u
X154 VSS.t199 VSS.t196 VSS.t198 VSS.t197 sg13_hv_nmos ad=0.34p pd=2.68u as=0 ps=0 w=1u l=0.5u
X155 GROUP22_0.G.t16 GROUP22_0.G.t14 GROUP22_0.G.t15 VSS.t96 sg13_hv_nmos ad=0.68p pd=4.68u as=0 ps=0 w=2u l=0.5u
X156 GROUP8_2.nmosHV_priv1_0.S GROUP10_2.pmosHV$1_priv4_0.D GROUP20_2.G VDD.t3 sg13_hv_pmos ad=0.68p pd=4.68u as=0.68p ps=4.68u w=2u l=0.5u
X157 q2 q2 q2 VSS.t86 sg13_hv_nmos ad=0.34p pd=2.68u as=0 ps=0 w=1u l=0.5u
X158 clk_h.t35 VDD.t67 GROUP22_1.G.t6 VSS.t18 sg13_hv_nmos ad=0.38p pd=2.38u as=0.68p ps=4.68u w=2u l=0.5u
X159 clk_h.t18 clk_h.t16 clk_h.t17 VDD.t1 sg13_hv_pmos ad=0.68p pd=4.68u as=0 ps=0 w=2u l=0.5u
X160 GROUP16_0.pmosHV$2_priv10_0.D GROUP16_0.pmosHV$2_priv10_0.D GROUP16_0.pmosHV$2_priv10_0.D VDDL.t0 sg13_hv_pmos ad=1.36p pd=8.68u as=12.0396p ps=45.16u w=4u l=0.5u
X161 GROUP6_3.pmosHV_priv16_0.S vin.t1 GROUP8_3.nmosHV_priv1_0.S VDD.t2 sg13_hv_pmos ad=1.7p pd=10.68u as=1.7p ps=10.68u w=5u l=0.5u
X162 GROUP8_1.nmosHV_priv1_0.S GROUP8_1.nmosHV_priv1_0.S GROUP8_1.nmosHV_priv1_0.S VSS.t87 sg13_hv_nmos ad=0.34p pd=2.68u as=13.2594p ps=51.74u w=1u l=0.5u
X163 VSS.t174 VSS.t172 VSS.t173 VSS.t169 sg13_hv_nmos ad=0.34p pd=2.68u as=0 ps=0 w=1u l=0.5u
X164 GROUP12_1.nmosHV_priv10_0.S GROUP12_1.nmosHV_priv10_0.S GROUP12_1.nmosHV_priv10_0.S VSS.t17 sg13_hv_nmos ad=0.34p pd=2.68u as=0 ps=0 w=1u l=0.5u
X165 GROUP22_1.G.t10 VDD.t60 clk_h.t42 VSS.t25 sg13_hv_nmos ad=0.38p pd=2.38u as=0.38p ps=2.38u w=2u l=0.5u
X166 GROUP22_1.G.t19 VSS.t348 clk_h.t67 VDD.t0 sg13_hv_pmos ad=0.68p pd=4.68u as=0.38p ps=2.38u w=2u l=0.5u
X167 VSS.t116 VSS.t113 VSS.t115 VSS.t114 sg13_hv_nmos ad=0.34p pd=2.68u as=0 ps=0 w=1u l=0.5u
X168 GROUP6_0.pmosHV_priv16_0.S GROUP6_0.pmosHV_priv16_0.S GROUP6_0.pmosHV_priv16_0.S VDD.t1 sg13_hv_pmos ad=1.7p pd=10.68u as=0 ps=0 w=5u l=0.5u
X169 GROUP15_2.pmosHV$2_priv7_0.D GROUP15_2.pmosHV$2_priv7_0.D GROUP15_2.pmosHV$2_priv7_0.D VDDL.t10 sg13_hv_pmos ad=1.36p pd=8.68u as=12.0396p ps=45.16u w=4u l=0.5u
X170 GROUP10_3.pmosHV$1_priv4_0.S GROUP10_3.pmosHV$1_priv4_0.S GROUP10_3.pmosHV$1_priv4_0.S VSS.t75 sg13_hv_nmos ad=0.34p pd=2.68u as=0 ps=0 w=1u l=0.5u
X171 GROUP10_2.pmosHV$1_priv4_0.D GROUP20_2.G VSS.t282 VSS.t281 sg13_hv_nmos ad=0.34p pd=2.68u as=0.34p ps=2.68u w=1u l=0.5u
X172 VDDL.t25 VDDL.t23 VDDL.t24 VDDL.t10 sg13_hv_pmos ad=1.36p pd=8.68u as=0 ps=0 w=4u l=0.5u
X173 GROUP16_1.pmosHV$2_priv10_0.D GROUP16_1.G q0 VDDL.t1 sg13_hv_pmos ad=1.36p pd=8.68u as=1.36p ps=8.68u w=4u l=0.5u
X174 GROUP8_2.nmosHV_priv1_0.S GROUP8_2.nmosHV_priv1_0.S GROUP8_2.nmosHV_priv1_0.S VSS.t88 sg13_hv_nmos ad=0.34p pd=2.68u as=0 ps=0 w=1u l=0.5u
X175 GROUP6_2.pmosHV_priv16_0.S GROUP6_2.pmosHV_priv16_0.S GROUP6_2.pmosHV_priv16_0.S VDD.t3 sg13_hv_pmos ad=1.7p pd=10.68u as=0 ps=0 w=5u l=0.5u
X176 GROUP12_3.nmosHV_priv10_0.S GROUP12_3.nmosHV_priv10_0.S GROUP12_3.nmosHV_priv10_0.S VDD.t2 sg13_hv_pmos ad=0.68p pd=4.68u as=45.658p ps=0.23585m w=2u l=0.5u
X177 clk_h.t58 VDD.t47 GROUP22_0.G.t4 VSS.t38 sg13_hv_nmos ad=0.38p pd=2.38u as=0.38p ps=2.38u w=2u l=0.5u
X178 GROUP22_3.nmosHV_priv28_0.D GROUP22_3.nmosHV_priv28_0.D GROUP22_3.nmosHV_priv28_0.D VSS.t307 sg13_hv_nmos ad=0.34p pd=2.68u as=0 ps=0 w=1u l=0.5u
X179 VSS.t231 VSS.t228 VSS.t230 VSS.t229 sg13_hv_nmos ad=0.34p pd=2.68u as=0 ps=0 w=1u l=0.5u
X180 GROUP19_2.G GROUP19_2.G GROUP19_2.G VSS.t272 sg13_hv_nmos ad=0.34p pd=2.68u as=24.5292p ps=0.13411m w=1u l=0.5u
X181 GROUP6_0.pmosHV_priv16_0.S vref_2 GROUP10_0.pmosHV$1_priv4_0.S VDD.t1 sg13_hv_pmos ad=1.7p pd=10.68u as=1.7p ps=10.68u w=5u l=0.5u
X182 GROUP22_2.G.t14 VSS.t322 clk_h.t29 VDD.t3 sg13_hv_pmos ad=0.38p pd=2.38u as=0.38p ps=2.38u w=2u l=0.5u
X183 VSS.t241 VSS.t239 VSS.t240 VSS.t205 sg13_hv_nmos ad=0.34p pd=2.68u as=0 ps=0 w=1u l=0.5u
X184 clk_h.t37 VDD.t43 GROUP22_3.G.t0 VSS.t42 sg13_hv_nmos ad=0.38p pd=2.38u as=0.68p ps=4.68u w=2u l=0.5u
X185 clk_h.t31 VSS.t341 GROUP22_0.G.t10 VDD.t1 sg13_hv_pmos ad=0.38p pd=2.38u as=0.38p ps=2.38u w=2u l=0.5u
X186 clk_h.t70 VSS.t333 GROUP22_3.G.t8 VDD.t2 sg13_hv_pmos ad=0.38p pd=2.38u as=0.38p ps=2.38u w=2u l=0.5u
X187 GROUP22_2.G.t15 VSS.t320 clk_h.t28 VDD.t3 sg13_hv_pmos ad=0.38p pd=2.38u as=0.38p ps=2.38u w=2u l=0.5u
X188 clk_h.t44 VSS.t315 GROUP22_2.G.t17 VDD.t3 sg13_hv_pmos ad=0.38p pd=2.38u as=0.38p ps=2.38u w=2u l=0.5u
X189 GROUP6_2.pmosHV_priv16_0.S vref_4 GROUP10_2.pmosHV$1_priv4_0.S VDD.t3 sg13_hv_pmos ad=1.7p pd=10.68u as=1.7p ps=10.68u w=5u l=0.5u
X190 clk_h.t43 VSS.t313 GROUP22_2.G.t18 VDD.t3 sg13_hv_pmos ad=0.38p pd=2.38u as=0.38p ps=2.38u w=2u l=0.5u
X191 q0 q0 q0 VSS.t252 sg13_hv_nmos ad=0.34p pd=2.68u as=0 ps=0 w=1u l=0.5u
X192 GROUP22_3.G.t12 VSS.t326 clk_h.t53 VDD.t2 sg13_hv_pmos ad=0.38p pd=2.38u as=0.38p ps=2.38u w=2u l=0.5u
X193 GROUP20_1.G GROUP22_1.G.t20 VSS.t296 VSS.t295 sg13_hv_nmos ad=0.34p pd=2.68u as=0.34p ps=2.68u w=1u l=0.5u
X194 GROUP10_2.pmosHV$1_priv4_0.S GROUP20_2.G GROUP10_2.pmosHV$1_priv4_0.D VDD.t3 sg13_hv_pmos ad=0.68p pd=4.68u as=0.68p ps=4.68u w=2u l=0.5u
X195 GROUP12_3.nmosHV_priv10_0.S GROUP12_3.nmosHV_priv10_0.S GROUP12_3.nmosHV_priv10_0.S VSS.t260 sg13_hv_nmos ad=0.34p pd=2.68u as=0 ps=0 w=1u l=0.5u
X196 GROUP22_3.G.t13 VSS.t324 clk_h.t30 VDD.t2 sg13_hv_pmos ad=0.68p pd=4.68u as=0.38p ps=2.38u w=2u l=0.5u
X197 GROUP8_3.nmosHV_priv1_0.S GROUP12_3.nmosHV_priv10_0.S GROUP22_3.nmosHV_priv28_0.D VDD.t2 sg13_hv_pmos ad=0.68p pd=4.68u as=0.68p ps=4.68u w=2u l=0.5u
X198 VSS.t167 VSS.t165 VSS.t166 VSS.t162 sg13_hv_nmos ad=0.34p pd=2.68u as=0 ps=0 w=1u l=0.5u
X199 q3 q3 q3 VSS.t305 sg13_hv_nmos ad=0.34p pd=2.68u as=0 ps=0 w=1u l=0.5u
X200 GROUP16_3.pmosHV$2_priv10_0.D GROUP19_3.G q2 VDDL.t10 sg13_hv_pmos ad=1.36p pd=8.68u as=1.36p ps=8.68u w=4u l=0.5u
X201 GROUP19_0.G GROUP19_0.G GROUP19_0.G VSS.t0 sg13_hv_nmos ad=0.34p pd=2.68u as=0 ps=0 w=1u l=0.5u
X202 GROUP19_0.G q1 VSS.t73 VSS.t72 sg13_hv_nmos ad=0.34p pd=2.68u as=0.34p ps=2.68u w=1u l=0.5u
X203 GROUP19_0.G GROUP19_0.G GROUP19_0.G VDDL.t0 sg13_hv_pmos ad=1.36p pd=8.68u as=0 ps=0 w=4u l=0.5u
X204 q3 GROUP20_2.G VSS.t284 VSS.t273 sg13_hv_nmos ad=0.34p pd=2.68u as=0.34p ps=2.68u w=1u l=0.5u
X205 GROUP16_0.pmosHV$2_priv10_0.D GROUP16_0.pmosHV$2_priv10_0.D GROUP16_0.pmosHV$2_priv10_0.D VDDL.t0 sg13_hv_pmos ad=1.36p pd=8.68u as=0 ps=0 w=4u l=0.5u
X206 GROUP22_1.G.t7 VDD.t66 clk_h.t35 VSS.t19 sg13_hv_nmos ad=0.38p pd=2.38u as=0.38p ps=2.38u w=2u l=0.5u
X207 GROUP15_2.pmosHV$2_priv7_0.D GROUP15_2.pmosHV$2_priv7_0.D GROUP15_2.pmosHV$2_priv7_0.D VDDL.t10 sg13_hv_pmos ad=1.36p pd=8.68u as=0 ps=0 w=4u l=0.5u
X208 GROUP10_3.pmosHV$1_priv4_0.S GROUP10_3.pmosHV$1_priv4_0.S GROUP10_3.pmosHV$1_priv4_0.S VDD.t2 sg13_hv_pmos ad=1.7p pd=10.68u as=0 ps=0 w=5u l=0.5u
X209 VSS.t124 VSS.t121 VSS.t123 VSS.t122 sg13_hv_nmos ad=0.34p pd=2.68u as=0 ps=0 w=1u l=0.5u
X210 VDDL.t2 GROUP12_1.nmosHV_priv10_0.S GROUP15_0.pmosHV$2_priv7_0.D VDDL.t1 sg13_hv_pmos ad=1.36p pd=8.68u as=1.36p ps=8.68u w=4u l=0.5u
X211 clk_h.t60 VDD.t59 GROUP22_1.G.t10 VSS.t26 sg13_hv_nmos ad=0.38p pd=2.38u as=0.38p ps=2.38u w=2u l=0.5u
X212 GROUP10_0.pmosHV$1_priv4_0.D GROUP10_0.pmosHV$1_priv4_0.D GROUP10_0.pmosHV$1_priv4_0.D VSS.t76 sg13_hv_nmos ad=0.34p pd=2.68u as=0 ps=0 w=1u l=0.5u
X213 GROUP13_3.pmosHV$2_priv1_0.D GROUP13_3.pmosHV$2_priv1_0.D GROUP13_3.pmosHV$2_priv1_0.D VDDL.t14 sg13_hv_pmos ad=1.36p pd=8.68u as=12.0396p ps=45.16u w=4u l=0.5u
X214 VDDL.t28 VDDL.t26 VDDL.t27 VDDL.t14 sg13_hv_pmos ad=1.36p pd=8.68u as=0 ps=0 w=4u l=0.5u
X215 clk_h.t61 VDD.t57 GROUP22_1.G.t11 VSS.t28 sg13_hv_nmos ad=0.38p pd=2.38u as=0.38p ps=2.38u w=2u l=0.5u
X216 clk_h.t62 VDD.t53 GROUP22_0.G.t1 VSS.t32 sg13_hv_nmos ad=0.38p pd=2.38u as=0.38p ps=2.38u w=2u l=0.5u
X217 GROUP6_3.pmosHV_priv16_0.S GROUP6_3.pmosHV_priv16_0.S GROUP6_3.pmosHV_priv16_0.S VDD.t2 sg13_hv_pmos ad=1.7p pd=10.68u as=21.6594p ps=79.74u w=5u l=0.5u
X218 q1 q1 q1 VSS.t74 sg13_hv_nmos ad=0.34p pd=2.68u as=0 ps=0 w=1u l=0.5u
X219 VDD.t17 GROUP22_0.G.t21 GROUP6_0.pmosHV_priv16_0.S VDD.t1 sg13_hv_pmos ad=1.7p pd=10.68u as=1.7p ps=10.68u w=5u l=0.5u
X220 q1 GROUP19_0.G VSS.t3 VSS.t2 sg13_hv_nmos ad=0.34p pd=2.68u as=0.34p ps=2.68u w=1u l=0.5u
X221 VSS.t148 VSS.t145 VSS.t147 VSS.t146 sg13_hv_nmos ad=0.34p pd=2.68u as=0 ps=0 w=1u l=0.5u
X222 GROUP6_3.pmosHV_priv16_0.S GROUP6_3.pmosHV_priv16_0.S GROUP6_3.pmosHV_priv16_0.S VDD.t2 sg13_hv_pmos ad=1.7p pd=10.68u as=0 ps=0 w=5u l=0.5u
X223 GROUP20_0.G GROUP20_0.G GROUP20_0.G VSS.t94 sg13_hv_nmos ad=0.34p pd=2.68u as=0 ps=0 w=1u l=0.5u
X224 GROUP6_1.pmosHV_priv16_0.S GROUP6_1.pmosHV_priv16_0.S GROUP6_1.pmosHV_priv16_0.S VDD.t0 sg13_hv_pmos ad=1.7p pd=10.68u as=0 ps=0 w=5u l=0.5u
X225 GROUP6_1.pmosHV_priv16_0.S GROUP6_1.pmosHV_priv16_0.S GROUP6_1.pmosHV_priv16_0.S VDD.t0 sg13_hv_pmos ad=1.7p pd=10.68u as=0 ps=0 w=5u l=0.5u
X226 GROUP16_1.pmosHV$2_priv10_0.D GROUP16_1.pmosHV$2_priv10_0.D GROUP16_1.pmosHV$2_priv10_0.D VDDL.t1 sg13_hv_pmos ad=1.36p pd=8.68u as=0 ps=0 w=4u l=0.5u
X227 VSS.t227 VSS.t224 VSS.t226 VSS.t225 sg13_hv_nmos ad=0.34p pd=2.68u as=0 ps=0 w=1u l=0.5u
X228 clk_h.t38 VDD.t31 GROUP22_2.G.t0 VSS.t54 sg13_hv_nmos ad=0.38p pd=2.38u as=0.68p ps=4.68u w=2u l=0.5u
X229 clk_h.t66 VSS.t347 GROUP22_0.G.t7 VDD.t1 sg13_hv_pmos ad=0.38p pd=2.38u as=0.68p ps=4.68u w=2u l=0.5u
X230 GROUP22_0.G.t10 VSS.t342 clk_h.t32 VDD.t1 sg13_hv_pmos ad=0.38p pd=2.38u as=0.38p ps=2.38u w=2u l=0.5u
X231 GROUP10_0.pmosHV$1_priv4_0.S GROUP22_0.G.t22 VSS.t279 VSS.t4 sg13_hv_nmos ad=0.34p pd=2.68u as=0.34p ps=2.68u w=1u l=0.5u
X232 GROUP22_3.G.t9 VSS.t332 clk_h.t70 VDD.t2 sg13_hv_pmos ad=0.38p pd=2.38u as=0.38p ps=2.38u w=2u l=0.5u
X233 clk_h.t53 VSS.t327 GROUP22_3.G.t11 VDD.t2 sg13_hv_pmos ad=0.38p pd=2.38u as=0.38p ps=2.38u w=2u l=0.5u
X234 GROUP22_2.G.t18 VSS.t314 clk_h.t44 VDD.t3 sg13_hv_pmos ad=0.38p pd=2.38u as=0.38p ps=2.38u w=2u l=0.5u
X235 GROUP16_1.G GROUP16_1.G GROUP16_1.G VDDL.t1 sg13_hv_pmos ad=1.36p pd=8.68u as=0 ps=0 w=4u l=0.5u
X236 VSS.t245 VSS.t242 VSS.t244 VSS.t243 sg13_hv_nmos ad=0.34p pd=2.68u as=0 ps=0 w=1u l=0.5u
X237 GROUP8_0.nmosHV_priv1_0.S GROUP8_0.nmosHV_priv1_0.S GROUP8_0.nmosHV_priv1_0.S VDD.t0 sg13_hv_pmos ad=0.68p pd=4.68u as=0 ps=0 w=2u l=0.5u
X238 VSS.t104 VSS.t101 VSS.t103 VSS.t102 sg13_hv_nmos ad=0.34p pd=2.68u as=0 ps=0 w=1u l=0.5u
X239 clk_h.t30 VSS.t325 GROUP22_3.G.t12 VDD.t2 sg13_hv_pmos ad=0.38p pd=2.38u as=0.38p ps=2.38u w=2u l=0.5u
X240 GROUP22_2.G.t19 VSS.t312 clk_h.t43 VDD.t3 sg13_hv_pmos ad=0.68p pd=4.68u as=0.38p ps=2.38u w=2u l=0.5u
X241 GROUP10_3.pmosHV$1_priv4_0.S GROUP22_3.nmosHV_priv28_0.D GROUP12_3.nmosHV_priv10_0.S VDD.t2 sg13_hv_pmos ad=0.68p pd=4.68u as=0.68p ps=4.68u w=2u l=0.5u
X242 VDDL.t8 VDDL.t6 VDDL.t7 VDDL.t0 sg13_hv_pmos ad=1.36p pd=8.68u as=0 ps=0 w=4u l=0.5u
X243 VSS.t207 VSS.t204 VSS.t206 VSS.t205 sg13_hv_nmos ad=0.34p pd=2.68u as=0 ps=0 w=1u l=0.5u
X244 GROUP6_1.pmosHV_priv16_0.S vref_1 GROUP10_1.pmosHV$1_priv4_0.S VDD.t0 sg13_hv_pmos ad=1.7p pd=10.68u as=1.7p ps=10.68u w=5u l=0.5u
X245 GROUP22_3.G.t16 GROUP22_3.G.t14 GROUP22_3.G.t15 VSS.t293 sg13_hv_nmos ad=0.68p pd=4.68u as=0 ps=0 w=2u l=0.5u
X246 GROUP19_2.G q3 VSS.t304 VSS.t303 sg13_hv_nmos ad=0.34p pd=2.68u as=0.34p ps=2.68u w=1u l=0.5u
X247 GROUP13_3.pmosHV$2_priv1_0.D GROUP13_3.pmosHV$2_priv1_0.D GROUP13_3.pmosHV$2_priv1_0.D VDDL.t14 sg13_hv_pmos ad=1.36p pd=8.68u as=0 ps=0 w=4u l=0.5u
X248 clk_h.t40 VDD.t65 GROUP22_1.G.t7 VSS.t20 sg13_hv_nmos ad=0.38p pd=2.38u as=0.38p ps=2.38u w=2u l=0.5u
X249 clk_h.t51 VSS.t353 GROUP22_1.G.t16 VDD.t0 sg13_hv_pmos ad=0.38p pd=2.38u as=0.38p ps=2.38u w=2u l=0.5u
X250 VSS.t171 VSS.t168 VSS.t170 VSS.t169 sg13_hv_nmos ad=0.34p pd=2.68u as=0 ps=0 w=1u l=0.5u
X251 GROUP22_1.G.t11 VDD.t58 clk_h.t60 VSS.t27 sg13_hv_nmos ad=0.38p pd=2.38u as=0.38p ps=2.38u w=2u l=0.5u
X252 clk_h.t21 clk_h.t19 clk_h.t20 VDD.t2 sg13_hv_pmos ad=0.68p pd=4.68u as=0 ps=0 w=2u l=0.5u
X253 VSS.t234 VSS.t232 VSS.t233 VSS.t197 sg13_hv_nmos ad=0.34p pd=2.68u as=0 ps=0 w=1u l=0.5u
X254 GROUP16_3.pmosHV$2_priv10_0.D GROUP16_3.pmosHV$2_priv10_0.D GROUP16_3.pmosHV$2_priv10_0.D VDDL.t10 sg13_hv_pmos ad=1.36p pd=8.68u as=12.0396p ps=45.16u w=4u l=0.5u
X255 GROUP22_0.G.t1 VDD.t54 clk_h.t48 VSS.t31 sg13_hv_nmos ad=0.38p pd=2.38u as=0.38p ps=2.38u w=2u l=0.5u
X256 GROUP8_1.nmosHV_priv1_0.S GROUP8_1.nmosHV_priv1_0.S GROUP8_1.nmosHV_priv1_0.S VDD.t1 sg13_hv_pmos ad=1.7p pd=10.68u as=0 ps=0 w=5u l=0.5u
X257 GROUP8_3.nmosHV_priv1_0.S GROUP8_3.nmosHV_priv1_0.S GROUP8_3.nmosHV_priv1_0.S VSS.t75 sg13_hv_nmos ad=0.34p pd=2.68u as=0 ps=0 w=1u l=0.5u
X258 GROUP22_0.G.t2 VDD.t52 clk_h.t62 VSS.t33 sg13_hv_nmos ad=0.38p pd=2.38u as=0.38p ps=2.38u w=2u l=0.5u
X259 VDDL.t30 GROUP10_0.pmosHV$1_priv4_0.D GROUP13_1.pmosHV$2_priv1_0.D VDDL.t0 sg13_hv_pmos ad=1.36p pd=8.68u as=1.36p ps=8.68u w=4u l=0.5u
X260 q3 q3 q3 VSS.t305 sg13_hv_nmos ad=0.34p pd=2.68u as=0 ps=0 w=1u l=0.5u
X261 GROUP22_3.nmosHV_priv28_0.D GROUP22_3.G.t20 VSS.t90 VSS.t89 sg13_hv_nmos ad=0.34p pd=2.68u as=0.34p ps=2.68u w=1u l=0.5u
X262 GROUP16_1.G q0 VSS.t250 VSS.t249 sg13_hv_nmos ad=0.34p pd=2.68u as=0.34p ps=2.68u w=1u l=0.5u
X263 GROUP6_2.pmosHV_priv16_0.S GROUP6_2.pmosHV_priv16_0.S GROUP6_2.pmosHV_priv16_0.S VDD.t3 sg13_hv_pmos ad=1.7p pd=10.68u as=0 ps=0 w=5u l=0.5u
X264 clk_h.t65 VDD.t45 GROUP22_0.G.t5 VSS.t40 sg13_hv_nmos ad=0.38p pd=2.38u as=0.38p ps=2.38u w=2u l=0.5u
X265 GROUP22_2.G.t4 VDD.t24 clk_h.t49 VSS.t61 sg13_hv_nmos ad=0.38p pd=2.38u as=0.38p ps=2.38u w=2u l=0.5u
X266 VSS.t156 VSS.t153 VSS.t155 VSS.t154 sg13_hv_nmos ad=0.34p pd=2.68u as=0 ps=0 w=1u l=0.5u
X267 q3 GROUP19_2.G VSS.t274 VSS.t273 sg13_hv_nmos ad=0.34p pd=2.68u as=0.34p ps=2.68u w=1u l=0.5u
X268 GROUP19_0.G GROUP10_0.pmosHV$1_priv4_0.D VSS.t78 VSS.t77 sg13_hv_nmos ad=0.34p pd=2.68u as=0.34p ps=2.68u w=1u l=0.5u
X269 GROUP12_1.nmosHV_priv10_0.S GROUP12_1.nmosHV_priv10_0.S GROUP12_1.nmosHV_priv10_0.S VSS.t12 sg13_hv_nmos ad=0.34p pd=2.68u as=0 ps=0 w=1u l=0.5u
X270 VDDL.t5 VDDL.t3 VDDL.t4 VDDL.t1 sg13_hv_pmos ad=1.36p pd=8.68u as=0 ps=0 w=4u l=0.5u
X271 GROUP6_3.pmosHV_priv16_0.S vref_3 GROUP10_3.pmosHV$1_priv4_0.S VDD.t2 sg13_hv_pmos ad=1.7p pd=10.68u as=1.7p ps=10.68u w=5u l=0.5u
X272 GROUP22_2.G.t16 VSS.t318 clk_h.t27 VDD.t3 sg13_hv_pmos ad=0.38p pd=2.38u as=0.38p ps=2.38u w=2u l=0.5u
X273 GROUP10_2.pmosHV$1_priv4_0.D GROUP22_2.G.t24 VSS.t302 VSS.t301 sg13_hv_nmos ad=0.34p pd=2.68u as=0.34p ps=2.68u w=1u l=0.5u
X274 VDD.t7 VDD.t5 VDD.t6 VDD.t0 sg13_hv_pmos ad=1.7p pd=10.68u as=0 ps=0 w=5u l=0.5u
X275 GROUP6_0.pmosHV_priv16_0.S GROUP6_0.pmosHV_priv16_0.S GROUP6_0.pmosHV_priv16_0.S VDD.t1 sg13_hv_pmos ad=1.7p pd=10.68u as=0 ps=0 w=5u l=0.5u
X276 clk_h.t55 VSS.t331 GROUP22_3.G.t9 VDD.t2 sg13_hv_pmos ad=0.38p pd=2.38u as=0.38p ps=2.38u w=2u l=0.5u
X277 GROUP10_1.pmosHV$1_priv4_0.S GROUP10_1.pmosHV$1_priv4_0.S GROUP10_1.pmosHV$1_priv4_0.S VDD.t0 sg13_hv_pmos ad=0.68p pd=4.68u as=0 ps=0 w=2u l=0.5u
X278 clk_h.t54 VSS.t329 GROUP22_3.G.t10 VDD.t2 sg13_hv_pmos ad=0.38p pd=2.38u as=0.38p ps=2.38u w=2u l=0.5u
X279 GROUP20_2.G GROUP20_2.G GROUP20_2.G VSS.t283 sg13_hv_nmos ad=0.34p pd=2.68u as=0 ps=0 w=1u l=0.5u
X280 VSS.t144 VSS.t141 VSS.t143 VSS.t142 sg13_hv_nmos ad=0.34p pd=2.68u as=0 ps=0 w=1u l=0.5u
X281 q0 GROUP16_1.G VSS.t264 VSS.t249 sg13_hv_nmos ad=0.34p pd=2.68u as=0.34p ps=2.68u w=1u l=0.5u
X282 VSS.t164 VSS.t161 VSS.t163 VSS.t162 sg13_hv_nmos ad=0.34p pd=2.68u as=0 ps=0 w=1u l=0.5u
X283 VSS.t215 VSS.t212 VSS.t214 VSS.t213 sg13_hv_nmos ad=0.34p pd=2.68u as=0 ps=0 w=1u l=0.5u
X284 GROUP22_2.G.t9 GROUP22_2.G.t7 GROUP22_2.G.t8 VSS.t294 sg13_hv_nmos ad=0.68p pd=4.68u as=0 ps=0 w=2u l=0.5u
X285 VSS.t112 VSS.t109 VSS.t111 VSS.t110 sg13_hv_nmos ad=0.34p pd=2.68u as=0 ps=0 w=1u l=0.5u
X286 GROUP22_0.G.t19 GROUP22_0.G.t17 GROUP22_0.G.t18 VDD.t1 sg13_hv_pmos ad=0.68p pd=4.68u as=0 ps=0 w=2u l=0.5u
X287 GROUP8_0.nmosHV_priv1_0.S GROUP8_0.nmosHV_priv1_0.S GROUP8_0.nmosHV_priv1_0.S VDD.t0 sg13_hv_pmos ad=1.7p pd=10.68u as=0 ps=0 w=5u l=0.5u
X288 GROUP8_1.nmosHV_priv1_0.S GROUP8_1.nmosHV_priv1_0.S GROUP8_1.nmosHV_priv1_0.S VDD.t1 sg13_hv_pmos ad=0.68p pd=4.68u as=0 ps=0 w=2u l=0.5u
X289 VDD.t10 VDD.t8 VDD.t9 VDD.t1 sg13_hv_pmos ad=1.7p pd=10.68u as=0 ps=0 w=5u l=0.5u
X290 q1 q1 q1 VDDL.t0 sg13_hv_pmos ad=1.36p pd=8.68u as=0 ps=0 w=4u l=0.5u
X291 GROUP16_3.pmosHV$2_priv10_0.D GROUP16_3.pmosHV$2_priv10_0.D GROUP16_3.pmosHV$2_priv10_0.D VDDL.t10 sg13_hv_pmos ad=1.36p pd=8.68u as=0 ps=0 w=4u l=0.5u
X292 GROUP22_1.G.t8 VDD.t64 clk_h.t40 VSS.t21 sg13_hv_nmos ad=0.38p pd=2.38u as=0.38p ps=2.38u w=2u l=0.5u
X293 GROUP22_1.G.t16 VSS.t354 clk_h.t52 VDD.t0 sg13_hv_pmos ad=0.38p pd=2.38u as=0.38p ps=2.38u w=2u l=0.5u
X294 clk_h.t24 clk_h.t22 clk_h.t23 VDD.t3 sg13_hv_pmos ad=0.68p pd=4.68u as=0 ps=0 w=2u l=0.5u
X295 GROUP19_3.G GROUP19_3.G GROUP19_3.G VSS.t275 sg13_hv_nmos ad=0.34p pd=2.68u as=0 ps=0 w=1u l=0.5u
X296 GROUP19_3.G q2 VSS.t85 VSS.t84 sg13_hv_nmos ad=0.34p pd=2.68u as=0.34p ps=2.68u w=1u l=0.5u
X297 GROUP10_1.pmosHV$1_priv4_0.S GROUP22_1.G.t22 VSS.t292 VSS.t291 sg13_hv_nmos ad=0.34p pd=2.68u as=0.34p ps=2.68u w=1u l=0.5u
X298 VDD.t4 GROUP22_1.G.t21 GROUP6_1.pmosHV_priv16_0.S VDD.t0 sg13_hv_pmos ad=1.7p pd=10.68u as=1.7p ps=10.68u w=5u l=0.5u
X299 VSS.t188 VSS.t186 VSS.t187 VSS.t183 sg13_hv_nmos ad=0.34p pd=2.68u as=0 ps=0 w=1u l=0.5u
X300 VDDL.t29 GROUP20_1.G GROUP16_1.pmosHV$2_priv10_0.D VDDL.t1 sg13_hv_pmos ad=1.36p pd=8.68u as=1.36p ps=8.68u w=4u l=0.5u
X301 GROUP22_1.G.t17 VSS.t352 clk_h.t51 VDD.t0 sg13_hv_pmos ad=0.38p pd=2.38u as=0.38p ps=2.38u w=2u l=0.5u
X302 GROUP8_2.nmosHV_priv1_0.S GROUP8_2.nmosHV_priv1_0.S GROUP8_2.nmosHV_priv1_0.S VDD.t3 sg13_hv_pmos ad=0.68p pd=4.68u as=0 ps=0 w=2u l=0.5u
X303 VSS.t248 VSS.t246 VSS.t247 VSS.t213 sg13_hv_nmos ad=0.34p pd=2.68u as=0 ps=0 w=1u l=0.5u
X304 GROUP14_2.pmosHV$2_priv4_0.S GROUP14_2.pmosHV$2_priv4_0.S GROUP14_2.pmosHV$2_priv4_0.S VDDL.t14 sg13_hv_pmos ad=1.36p pd=8.68u as=12.0396p ps=45.16u w=4u l=0.5u
X305 GROUP12_1.nmosHV_priv10_0.S GROUP22_1.G.t24 VSS.t290 VSS.t289 sg13_hv_nmos ad=0.34p pd=2.68u as=0.34p ps=2.68u w=1u l=0.5u
X306 GROUP20_1.G GROUP12_1.nmosHV_priv10_0.S VSS.t14 VSS.t13 sg13_hv_nmos ad=0.34p pd=2.68u as=0.34p ps=2.68u w=1u l=0.5u
X307 GROUP22_2.G.t1 VDD.t30 clk_h.t38 VSS.t55 sg13_hv_nmos ad=0.38p pd=2.38u as=0.38p ps=2.38u w=2u l=0.5u
X308 GROUP12_3.nmosHV_priv10_0.S GROUP12_3.nmosHV_priv10_0.S GROUP12_3.nmosHV_priv10_0.S VSS.t255 sg13_hv_nmos ad=0.34p pd=2.68u as=0 ps=0 w=1u l=0.5u
X309 VDDL.t33 GROUP10_2.pmosHV$1_priv4_0.D GROUP13_3.pmosHV$2_priv1_0.D VDDL.t14 sg13_hv_pmos ad=1.36p pd=8.68u as=1.36p ps=8.68u w=4u l=0.5u
X310 VSS.t203 VSS.t200 VSS.t202 VSS.t201 sg13_hv_nmos ad=0.34p pd=2.68u as=0 ps=0 w=1u l=0.5u
X311 clk_h.t69 VDD.t51 GROUP22_0.G.t2 VSS.t34 sg13_hv_nmos ad=0.38p pd=2.38u as=0.38p ps=2.38u w=2u l=0.5u
X312 GROUP22_0.G.t5 VDD.t46 clk_h.t58 VSS.t39 sg13_hv_nmos ad=0.38p pd=2.38u as=0.38p ps=2.38u w=2u l=0.5u
X313 clk_h.t47 VSS.t339 GROUP22_0.G.t11 VDD.t1 sg13_hv_pmos ad=0.38p pd=2.38u as=0.38p ps=2.38u w=2u l=0.5u
X314 GROUP22_3.G.t4 VDD.t36 clk_h.t41 VSS.t49 sg13_hv_nmos ad=0.38p pd=2.38u as=0.38p ps=2.38u w=2u l=0.5u
X315 GROUP22_0.G.t6 VDD.t44 clk_h.t65 VSS.t41 sg13_hv_nmos ad=0.68p pd=4.68u as=0.38p ps=2.38u w=2u l=0.5u
X316 q2 GROUP19_3.G VSS.t278 VSS.t277 sg13_hv_nmos ad=0.34p pd=2.68u as=0.34p ps=2.68u w=1u l=0.5u
X317 clk_h.t3 clk_h.t1 clk_h.t2 VSS.t6 sg13_hv_nmos ad=0.68p pd=4.68u as=0 ps=0 w=2u l=0.5u
X318 clk_h.t27 VSS.t319 GROUP22_2.G.t15 VDD.t3 sg13_hv_pmos ad=0.38p pd=2.38u as=0.38p ps=2.38u w=2u l=0.5u
X319 VSS.t136 VSS.t133 VSS.t135 VSS.t134 sg13_hv_nmos ad=0.34p pd=2.68u as=0 ps=0 w=1u l=0.5u
X320 GROUP8_1.nmosHV_priv1_0.S GROUP22_0.G.t23 VSS.t5 VSS.t4 sg13_hv_nmos ad=0.34p pd=2.68u as=0.34p ps=2.68u w=1u l=0.5u
X321 GROUP12_1.nmosHV_priv10_0.S GROUP20_1.G VSS.t68 VSS.t67 sg13_hv_nmos ad=0.34p pd=2.68u as=0.34p ps=2.68u w=1u l=0.5u
X322 GROUP22_1.G.t5 GROUP22_1.G.t3 GROUP22_1.G.t4 VDD.t0 sg13_hv_pmos ad=0.68p pd=4.68u as=0 ps=0 w=2u l=0.5u
X323 GROUP12_3.nmosHV_priv10_0.S GROUP22_3.G.t24 VSS.t83 VSS.t82 sg13_hv_nmos ad=0.34p pd=2.68u as=0.34p ps=2.68u w=1u l=0.5u
X324 q0 q0 q0 VDDL.t1 sg13_hv_pmos ad=1.36p pd=8.68u as=0 ps=0 w=4u l=0.5u
X325 GROUP22_3.G.t10 VSS.t330 clk_h.t55 VDD.t2 sg13_hv_pmos ad=0.38p pd=2.38u as=0.38p ps=2.38u w=2u l=0.5u
X326 clk_h.t45 VSS.t317 GROUP22_2.G.t16 VDD.t3 sg13_hv_pmos ad=0.38p pd=2.38u as=0.38p ps=2.38u w=2u l=0.5u
X327 GROUP10_3.pmosHV$1_priv4_0.S GROUP22_3.G.t22 VSS.t262 VSS.t10 sg13_hv_nmos ad=0.34p pd=2.68u as=0.34p ps=2.68u w=1u l=0.5u
X328 GROUP20_1.G GROUP20_1.G GROUP20_1.G VDD.t0 sg13_hv_pmos ad=0.68p pd=4.68u as=0 ps=0 w=2u l=0.5u
X329 VDDL.t22 VDDL.t20 VDDL.t21 VDDL.t0 sg13_hv_pmos ad=1.36p pd=8.68u as=0 ps=0 w=4u l=0.5u
X330 GROUP16_1.G GROUP16_1.G GROUP16_1.G VSS.t251 sg13_hv_nmos ad=0.34p pd=2.68u as=0 ps=0 w=1u l=0.5u
X331 GROUP6_3.pmosHV_priv16_0.S GROUP6_3.pmosHV_priv16_0.S GROUP6_3.pmosHV_priv16_0.S VDD.t2 sg13_hv_pmos ad=1.7p pd=10.68u as=0 ps=0 w=5u l=0.5u
X332 GROUP10_0.pmosHV$1_priv4_0.S GROUP10_0.pmosHV$1_priv4_0.S GROUP10_0.pmosHV$1_priv4_0.S VDD.t1 sg13_hv_pmos ad=0.68p pd=4.68u as=0 ps=0 w=2u l=0.5u
X333 GROUP19_2.G GROUP19_2.G GROUP19_2.G VDDL.t14 sg13_hv_pmos ad=1.36p pd=8.68u as=0 ps=0 w=4u l=0.5u
X334 GROUP14_2.pmosHV$2_priv4_0.S GROUP14_2.pmosHV$2_priv4_0.S GROUP14_2.pmosHV$2_priv4_0.S VDDL.t14 sg13_hv_pmos ad=1.36p pd=8.68u as=0 ps=0 w=4u l=0.5u
X335 GROUP22_1.G.t14 VSS.t358 clk_h.t64 VDD.t0 sg13_hv_pmos ad=0.38p pd=2.38u as=0.38p ps=2.38u w=2u l=0.5u
X336 GROUP19_2.G GROUP19_2.G GROUP19_2.G VSS.t271 sg13_hv_nmos ad=0.34p pd=2.68u as=0 ps=0 w=1u l=0.5u
X337 GROUP10_2.pmosHV$1_priv4_0.S GROUP10_2.pmosHV$1_priv4_0.S GROUP10_2.pmosHV$1_priv4_0.S VDD.t3 sg13_hv_pmos ad=0.68p pd=4.68u as=0 ps=0 w=2u l=0.5u
X338 VSS.t195 VSS.t192 VSS.t194 VSS.t193 sg13_hv_nmos ad=0.34p pd=2.68u as=0 ps=0 w=1u l=0.5u
X339 clk_h.t59 VDD.t63 GROUP22_1.G.t8 VSS.t22 sg13_hv_nmos ad=0.38p pd=2.38u as=0.38p ps=2.38u w=2u l=0.5u
R0 vin vin.n5 15.2802
R1 vin.n4 vin 15.2511
R2 vin.t3 vin 15.0005
R3 vin.n3 vin.t3 15.0005
R4 vin vin.t0 15.0005
R5 vin.t0 vin.n0 15.0005
R6 vin.t1 vin 15.0005
R7 vin.n1 vin.t1 15.0005
R8 vin.t2 vin 15.0005
R9 vin.n2 vin.t2 15.0005
R10 vin.n5 vin 10.4631
R11 vin.n4 vin 10.4454
R12 vin vin.n2 5.23467
R13 vin vin.n0 5.23467
R14 vin vin.n3 5.23467
R15 vin vin.n1 5.23467
R16 vin.n3 vin 5.06356
R17 vin vin.n0 5.06356
R18 vin.n1 vin 5.06356
R19 vin.n2 vin 5.06356
R20 vin.n5 vin.n4 4.82466
R21 clk_h.n14 clk_h.n15 0.063656
R22 clk_h.n12 clk_h.n13 0.063656
R23 clk_h.n10 clk_h.n11 0.063656
R24 clk_h.n8 clk_h.n9 0.063656
R25 clk_h.n6 clk_h.n7 0.063656
R26 clk_h.n4 clk_h.n5 0.063656
R27 clk_h.n3 clk_h.t1 7.50949
R28 clk_h.n0 clk_h.n1 0.063656
R29 clk_h.n54 clk_h.t57 12.3721
R30 clk_h.n57 clk_h.t68 12.3721
R31 clk_h.n58 clk_h.t49 12.3721
R32 clk_h.n59 clk_h.t36 12.3721
R33 clk_h.n49 clk_h.t26 12.3721
R34 clk_h.n68 clk_h.t43 12.3721
R35 clk_h.n71 clk_h.t44 12.3721
R36 clk_h.n72 clk_h.t45 12.3721
R37 clk_h.n73 clk_h.t27 12.3721
R38 clk_h.n63 clk_h.t28 12.3721
R39 clk_h.n25 clk_h.t56 12.3721
R40 clk_h.n28 clk_h.t39 12.3721
R41 clk_h.n29 clk_h.t41 12.3721
R42 clk_h.n30 clk_h.t34 12.3721
R43 clk_h.n20 clk_h.t0 12.3721
R44 clk_h.n39 clk_h.t30 12.3721
R45 clk_h.n42 clk_h.t53 12.3721
R46 clk_h.n43 clk_h.t54 12.3721
R47 clk_h.n44 clk_h.t55 12.3721
R48 clk_h.n34 clk_h.t70 12.3721
R49 clk_h.n84 clk_h.t65 12.3721
R50 clk_h.n87 clk_h.t58 12.3721
R51 clk_h.n88 clk_h.t25 12.3721
R52 clk_h.n89 clk_h.t69 12.3721
R53 clk_h.n79 clk_h.t62 12.3721
R54 clk_h.n98 clk_h.t46 12.3721
R55 clk_h.n101 clk_h.t47 12.3721
R56 clk_h.n102 clk_h.t31 12.3721
R57 clk_h.n103 clk_h.t32 12.3721
R58 clk_h.n93 clk_h.t33 12.3721
R59 clk_h.n112 clk_h.t61 12.3721
R60 clk_h.n115 clk_h.t60 12.3721
R61 clk_h.n116 clk_h.t42 12.3721
R62 clk_h.n117 clk_h.t59 12.3721
R63 clk_h.n108 clk_h.t40 12.3721
R64 clk_h.n127 clk_h.t67 12.3721
R65 clk_h.n130 clk_h.t50 12.3721
R66 clk_h.n131 clk_h.t51 12.3721
R67 clk_h.n132 clk_h.t52 12.3721
R68 clk_h.n122 clk_h.t63 12.3721
R69 clk_h.n17 clk_h.n62 9.26803
R70 clk_h.n55 clk_h.n54 9.26803
R71 clk_h.n77 clk_h.n76 9.26803
R72 clk_h.n69 clk_h.n68 9.26803
R73 clk_h.n18 clk_h.n33 9.26803
R74 clk_h.n26 clk_h.n25 9.26803
R75 clk_h.n48 clk_h.n47 9.26803
R76 clk_h.n40 clk_h.n39 9.26803
R77 clk_h.n19 clk_h.n92 9.26803
R78 clk_h.n85 clk_h.n84 9.26803
R79 clk_h.n107 clk_h.n106 9.26803
R80 clk_h.n99 clk_h.n98 9.26803
R81 clk_h.n16 clk_h.n120 9.26803
R82 clk_h.n113 clk_h.n112 9.26803
R83 clk_h.n136 clk_h.n135 9.26803
R84 clk_h.n128 clk_h.n127 9.26803
R85 clk_h.n17 clk_h.n50 9.0005
R86 clk_h.n51 clk_h.n49 9.0005
R87 clk_h.n60 clk_h.n59 9.0005
R88 clk_h.n58 clk_h.n53 9.0005
R89 clk_h.n57 clk_h.n56 9.0005
R90 clk_h.n61 clk_h.n60 9.0005
R91 clk_h.n53 clk_h.n52 9.0005
R92 clk_h.n77 clk_h.n64 9.0005
R93 clk_h.n71 clk_h.n70 9.0005
R94 clk_h.n72 clk_h.n67 9.0005
R95 clk_h.n74 clk_h.n73 9.0005
R96 clk_h.n65 clk_h.n63 9.0005
R97 clk_h.n75 clk_h.n74 9.0005
R98 clk_h.n67 clk_h.n66 9.0005
R99 clk_h.n18 clk_h.n21 9.0005
R100 clk_h.n22 clk_h.n20 9.0005
R101 clk_h.n31 clk_h.n30 9.0005
R102 clk_h.n29 clk_h.n24 9.0005
R103 clk_h.n28 clk_h.n27 9.0005
R104 clk_h.n32 clk_h.n31 9.0005
R105 clk_h.n24 clk_h.n23 9.0005
R106 clk_h.n48 clk_h.n35 9.0005
R107 clk_h.n42 clk_h.n41 9.0005
R108 clk_h.n43 clk_h.n38 9.0005
R109 clk_h.n45 clk_h.n44 9.0005
R110 clk_h.n36 clk_h.n34 9.0005
R111 clk_h.n46 clk_h.n45 9.0005
R112 clk_h.n38 clk_h.n37 9.0005
R113 clk_h.n19 clk_h.n80 9.0005
R114 clk_h.n81 clk_h.n79 9.0005
R115 clk_h.n90 clk_h.n89 9.0005
R116 clk_h.n88 clk_h.n83 9.0005
R117 clk_h.n87 clk_h.n86 9.0005
R118 clk_h.n91 clk_h.n90 9.0005
R119 clk_h.n83 clk_h.n82 9.0005
R120 clk_h.n107 clk_h.n94 9.0005
R121 clk_h.n101 clk_h.n100 9.0005
R122 clk_h.n102 clk_h.n97 9.0005
R123 clk_h.n104 clk_h.n103 9.0005
R124 clk_h.n95 clk_h.n93 9.0005
R125 clk_h.n105 clk_h.n104 9.0005
R126 clk_h.n97 clk_h.n96 9.0005
R127 clk_h.n16 clk_h.n121 9.0005
R128 clk_h.n109 clk_h.n108 9.0005
R129 clk_h.n118 clk_h.n117 9.0005
R130 clk_h.n116 clk_h.n111 9.0005
R131 clk_h.n115 clk_h.n114 9.0005
R132 clk_h.n119 clk_h.n118 9.0005
R133 clk_h.n111 clk_h.n110 9.0005
R134 clk_h.n136 clk_h.n123 9.0005
R135 clk_h.n130 clk_h.n129 9.0005
R136 clk_h.n131 clk_h.n126 9.0005
R137 clk_h.n133 clk_h.n132 9.0005
R138 clk_h.n124 clk_h.n122 9.0005
R139 clk_h.n134 clk_h.n133 9.0005
R140 clk_h.n126 clk_h.n125 9.0005
R141 clk_h.n15 clk_h.t12 2.84339
R142 clk_h.n14 clk_h.t11 2.81267
R143 clk_h.n13 clk_h.t24 2.84339
R144 clk_h.n12 clk_h.t23 2.81267
R145 clk_h.n11 clk_h.t9 2.84339
R146 clk_h.n10 clk_h.t8 2.81267
R147 clk_h.n9 clk_h.t21 2.84339
R148 clk_h.n8 clk_h.t20 2.81267
R149 clk_h.n7 clk_h.t6 2.84339
R150 clk_h.n6 clk_h.t5 2.81267
R151 clk_h.n5 clk_h.t18 2.84339
R152 clk_h.n4 clk_h.t17 2.81267
R153 clk_h.n3 clk_h.n2 0.063656
R154 clk_h.n3 clk_h.t3 2.84339
R155 clk_h.n2 clk_h.t2 2.81267
R156 clk_h.n1 clk_h.t15 2.84339
R157 clk_h.n0 clk_h.t14 2.81267
R158 clk_h.n137 clk_h 6.43462
R159 clk_h.n78 clk_h 6.19878
R160 clk_h.n62 clk_h.n61 5.03507
R161 clk_h.n55 clk_h.n52 5.03507
R162 clk_h.n76 clk_h.n75 5.03507
R163 clk_h.n69 clk_h.n66 5.03507
R164 clk_h.n33 clk_h.n32 5.03507
R165 clk_h.n26 clk_h.n23 5.03507
R166 clk_h.n47 clk_h.n46 5.03507
R167 clk_h.n40 clk_h.n37 5.03507
R168 clk_h.n92 clk_h.n91 5.03507
R169 clk_h.n85 clk_h.n82 5.03507
R170 clk_h.n106 clk_h.n105 5.03507
R171 clk_h.n99 clk_h.n96 5.03507
R172 clk_h.n120 clk_h.n119 5.03507
R173 clk_h.n113 clk_h.n110 5.03507
R174 clk_h.n135 clk_h.n134 5.03507
R175 clk_h.n128 clk_h.n125 5.03507
R176 clk_h.n50 clk_h.t38 3.37206
R177 clk_h.n64 clk_h.t29 3.37206
R178 clk_h.n21 clk_h.t37 3.37206
R179 clk_h.n35 clk_h.t71 3.37206
R180 clk_h.n80 clk_h.t48 3.37206
R181 clk_h.n94 clk_h.t66 3.37206
R182 clk_h.n121 clk_h.t35 3.37206
R183 clk_h.n123 clk_h.t64 3.37206
R184 clk_h clk_h.n137 2.94102
R185 clk_h clk_h.n78 1.79966
R186 clk_h.n78 clk_h 1.35702
R187 clk_h.n137 clk_h 1.26902
R188 clk_h.n50 clk_h.n14 1.2585
R189 clk_h.n64 clk_h.n12 1.2585
R190 clk_h.n21 clk_h.n10 1.2585
R191 clk_h.n35 clk_h.n8 1.2585
R192 clk_h.n80 clk_h.n6 1.2585
R193 clk_h.n94 clk_h.n4 1.2585
R194 clk_h.n121 clk_h.n2 1.2585
R195 clk_h.n123 clk_h.n0 1.2585
R196 clk_h clk_h.n77 1.06139
R197 clk_h clk_h.n48 1.06139
R198 clk_h clk_h.n107 1.06139
R199 clk_h clk_h.n136 1.06139
R200 clk_h.n59 clk_h.n49 0.534569
R201 clk_h.n59 clk_h.n58 0.534569
R202 clk_h.n58 clk_h.n57 0.534569
R203 clk_h.n57 clk_h.n54 0.534569
R204 clk_h.n60 clk_h.n51 0.534569
R205 clk_h.n60 clk_h.n53 0.534569
R206 clk_h.n56 clk_h.n53 0.534569
R207 clk_h.n61 clk_h.n52 0.534569
R208 clk_h.n73 clk_h.n63 0.534569
R209 clk_h.n73 clk_h.n72 0.534569
R210 clk_h.n72 clk_h.n71 0.534569
R211 clk_h.n71 clk_h.n68 0.534569
R212 clk_h.n74 clk_h.n65 0.534569
R213 clk_h.n74 clk_h.n67 0.534569
R214 clk_h.n70 clk_h.n67 0.534569
R215 clk_h.n75 clk_h.n66 0.534569
R216 clk_h.n30 clk_h.n20 0.534569
R217 clk_h.n30 clk_h.n29 0.534569
R218 clk_h.n29 clk_h.n28 0.534569
R219 clk_h.n28 clk_h.n25 0.534569
R220 clk_h.n31 clk_h.n22 0.534569
R221 clk_h.n31 clk_h.n24 0.534569
R222 clk_h.n27 clk_h.n24 0.534569
R223 clk_h.n32 clk_h.n23 0.534569
R224 clk_h.n44 clk_h.n34 0.534569
R225 clk_h.n44 clk_h.n43 0.534569
R226 clk_h.n43 clk_h.n42 0.534569
R227 clk_h.n42 clk_h.n39 0.534569
R228 clk_h.n45 clk_h.n36 0.534569
R229 clk_h.n45 clk_h.n38 0.534569
R230 clk_h.n41 clk_h.n38 0.534569
R231 clk_h.n46 clk_h.n37 0.534569
R232 clk_h.n89 clk_h.n79 0.534569
R233 clk_h.n89 clk_h.n88 0.534569
R234 clk_h.n88 clk_h.n87 0.534569
R235 clk_h.n87 clk_h.n84 0.534569
R236 clk_h.n90 clk_h.n81 0.534569
R237 clk_h.n90 clk_h.n83 0.534569
R238 clk_h.n86 clk_h.n83 0.534569
R239 clk_h.n91 clk_h.n82 0.534569
R240 clk_h.n103 clk_h.n93 0.534569
R241 clk_h.n103 clk_h.n102 0.534569
R242 clk_h.n102 clk_h.n101 0.534569
R243 clk_h.n101 clk_h.n98 0.534569
R244 clk_h.n104 clk_h.n95 0.534569
R245 clk_h.n104 clk_h.n97 0.534569
R246 clk_h.n100 clk_h.n97 0.534569
R247 clk_h.n105 clk_h.n96 0.534569
R248 clk_h.n117 clk_h.n108 0.534569
R249 clk_h.n117 clk_h.n116 0.534569
R250 clk_h.n116 clk_h.n115 0.534569
R251 clk_h.n115 clk_h.n112 0.534569
R252 clk_h.n118 clk_h.n109 0.534569
R253 clk_h.n118 clk_h.n111 0.534569
R254 clk_h.n114 clk_h.n111 0.534569
R255 clk_h.n119 clk_h.n110 0.534569
R256 clk_h.n132 clk_h.n122 0.534569
R257 clk_h.n132 clk_h.n131 0.534569
R258 clk_h.n131 clk_h.n130 0.534569
R259 clk_h.n130 clk_h.n127 0.534569
R260 clk_h.n133 clk_h.n124 0.534569
R261 clk_h.n133 clk_h.n126 0.534569
R262 clk_h.n129 clk_h.n126 0.534569
R263 clk_h.n134 clk_h.n125 0.534569
R264 clk_h.n17 clk_h.n49 0.528669
R265 clk_h.n18 clk_h.n20 0.528669
R266 clk_h.n19 clk_h.n79 0.528669
R267 clk_h.n16 clk_h.n108 0.528669
R268 clk_h.n77 clk_h.n63 0.528374
R269 clk_h.n48 clk_h.n34 0.528374
R270 clk_h.n107 clk_h.n93 0.528374
R271 clk_h.n136 clk_h.n122 0.528374
R272 clk_h clk_h.n19 0.484109
R273 clk_h clk_h.n18 0.484109
R274 clk_h clk_h.n17 0.484109
R275 clk_h clk_h.n16 0.484109
R276 clk_h.n62 clk_h.n51 0.253076
R277 clk_h.n56 clk_h.n55 0.253076
R278 clk_h.n76 clk_h.n65 0.253076
R279 clk_h.n70 clk_h.n69 0.253076
R280 clk_h.n33 clk_h.n22 0.253076
R281 clk_h.n27 clk_h.n26 0.253076
R282 clk_h.n47 clk_h.n36 0.253076
R283 clk_h.n41 clk_h.n40 0.253076
R284 clk_h.n92 clk_h.n81 0.253076
R285 clk_h.n86 clk_h.n85 0.253076
R286 clk_h.n106 clk_h.n95 0.253076
R287 clk_h.n100 clk_h.n99 0.253076
R288 clk_h.n120 clk_h.n109 0.253076
R289 clk_h.n114 clk_h.n113 0.253076
R290 clk_h.n135 clk_h.n124 0.253076
R291 clk_h.n129 clk_h.n128 0.253076
R292 clk_h.t10 clk_h.n15 7.50949
R293 clk_h.t22 clk_h.n13 7.50949
R294 clk_h.t7 clk_h.n11 7.50949
R295 clk_h.t19 clk_h.n9 7.50949
R296 clk_h.t4 clk_h.n7 7.50949
R297 clk_h.t16 clk_h.n5 7.50949
R298 clk_h.t13 clk_h.n1 7.50949
R299 VDDL.n95 VDDL.t5 17.0005
R300 VDDL.t4 VDDL.n84 17.0005
R301 VDDL.n1 VDDL.t19 8.49099
R302 VDDL.n1 VDDL.n0 0.0345366
R303 VDDL.t19 VDDL.n3 5.65043
R304 VDDL.t19 VDDL.n5 8.49099
R305 VDDL.n5 VDDL.n4 0.0210212
R306 VDDL.n0 VDDL.n78 0.047104
R307 VDDL.n2 VDDL.t18 5.65465
R308 VDDL.t18 VDDL.n80 17.0005
R309 VDDL.n6 VDDL.n7 0.0410098
R310 VDDL.t16 VDDL.n10 5.65465
R311 VDDL.n9 VDDL.n8 0.0410098
R312 VDDL.t15 VDDL.n11 5.65043
R313 VDDL.n17 VDDL.t28 8.49099
R314 VDDL.n17 VDDL.n16 0.0345366
R315 VDDL.t28 VDDL.n14 5.65465
R316 VDDL.n16 VDDL.n14 0.0609366
R317 VDDL.n15 VDDL.t27 5.65043
R318 VDDL.n13 VDDL.n12 0.0410098
R319 VDDL.n18 VDDL.n19 0.0563252
R320 VDDL.t12 VDDL.n19 4.23015
R321 VDDL.n21 VDDL.n20 0.0410098
R322 VDDL.t11 VDDL.n22 5.65043
R323 VDDL.n25 VDDL.n26 0.0410098
R324 VDDL.n24 VDDL.n23 0.0410098
R325 VDDL.n29 VDDL.n30 0.0563252
R326 VDDL.t8 VDDL.n30 4.23015
R327 VDDL.t8 VDDL.n32 5.65043
R328 VDDL.t7 VDDL.n31 5.65043
R329 VDDL.n28 VDDL.n32 0.0617869
R330 VDDL.t7 VDDL.n28 4.23388
R331 VDDL.n35 VDDL.n36 0.0410098
R332 VDDL.n34 VDDL.n33 0.0410098
R333 VDDL VDDL.n99 16.3366
R334 VDDL.n98 VDDL 16.2702
R335 VDDL.t3 VDDL.n95 15.0513
R336 VDDL.t13 VDDL.n6 15.0513
R337 VDDL.t9 VDDL.n18 15.0513
R338 VDDL.t23 VDDL.n25 15.0513
R339 VDDL.t6 VDDL.n29 15.0513
R340 VDDL.t20 VDDL.n35 15.0513
R341 VDDL.n96 VDDL.t3 15.0005
R342 VDDL.n81 VDDL.t17 15.0005
R343 VDDL.n48 VDDL.t13 15.0005
R344 VDDL.n44 VDDL.t26 15.0005
R345 VDDL.n62 VDDL.t9 15.0005
R346 VDDL.n55 VDDL.t23 15.0005
R347 VDDL.n75 VDDL.t6 15.0005
R348 VDDL.n70 VDDL.t20 15.0005
R349 VDDL.n83 VDDL.t1 13.6742
R350 VDDL.n57 VDDL.t10 13.6742
R351 VDDL.n72 VDDL.t0 13.6742
R352 VDDL.n99 VDDL 11.5789
R353 VDDL.n98 VDDL 11.5459
R354 VDDL.n83 VDDL.n82 9.58922
R355 VDDL.t14 VDDL.t34 9.58922
R356 VDDL.n57 VDDL.n56 9.58922
R357 VDDL.n72 VDDL.n71 9.58922
R358 VDDL.n37 VDDL.n97 9.13118
R359 VDDL.n39 VDDL.t33 9.13118
R360 VDDL.n38 VDDL.n63 9.13118
R361 VDDL.n40 VDDL.n76 9.13118
R362 VDDL.t5 VDDL.n89 8.49123
R363 VDDL.t5 VDDL.n88 8.49123
R364 VDDL.t5 VDDL.n87 8.49123
R365 VDDL.t5 VDDL.n94 8.49123
R366 VDDL.t5 VDDL.n86 8.49123
R367 VDDL.t4 VDDL.n85 8.49123
R368 VDDL.t4 VDDL.n92 8.49123
R369 VDDL.t4 VDDL.n91 8.49123
R370 VDDL.n93 VDDL.t4 8.49123
R371 VDDL.t4 VDDL.n90 8.49123
R372 VDDL.t19 VDDL.n78 8.49123
R373 VDDL.n3 VDDL.n2 0.0478606
R374 VDDL.t19 VDDL.n77 8.49123
R375 VDDL.t18 VDDL.n0 5.65486
R376 VDDL.t18 VDDL.n79 8.49123
R377 VDDL.t18 VDDL.n4 8.49123
R378 VDDL.t16 VDDL.n7 5.65022
R379 VDDL.t16 VDDL.n45 8.49123
R380 VDDL.t16 VDDL.n9 5.65022
R381 VDDL.t15 VDDL.n6 8.49123
R382 VDDL.n47 VDDL.t15 8.49123
R383 VDDL.n11 VDDL.n10 0.0478606
R384 VDDL.t15 VDDL.n46 8.49123
R385 VDDL.t15 VDDL.n8 8.49123
R386 VDDL.t28 VDDL.n43 8.49123
R387 VDDL.t28 VDDL.n41 8.49123
R388 VDDL.t28 VDDL.n12 8.49123
R389 VDDL.t27 VDDL.n16 5.65486
R390 VDDL.n15 VDDL.n14 0.0478606
R391 VDDL.t27 VDDL.n42 8.49123
R392 VDDL.t27 VDDL.n13 5.65022
R393 VDDL.t12 VDDL.n59 8.49123
R394 VDDL.t12 VDDL.n58 8.49123
R395 VDDL.t12 VDDL.n21 5.65022
R396 VDDL.t11 VDDL.n18 8.49123
R397 VDDL.t11 VDDL.n61 8.49123
R398 VDDL.t11 VDDL.n60 8.49123
R399 VDDL.t11 VDDL.n20 8.49123
R400 VDDL.t25 VDDL.n26 5.65022
R401 VDDL.t25 VDDL.n54 8.49123
R402 VDDL.t25 VDDL.n50 8.49123
R403 VDDL.t25 VDDL.n49 8.49123
R404 VDDL.t25 VDDL.n23 8.49123
R405 VDDL.t24 VDDL.n25 8.49123
R406 VDDL.n53 VDDL.t24 8.49123
R407 VDDL.t24 VDDL.n51 8.49123
R408 VDDL.t24 VDDL.n52 8.49123
R409 VDDL.t24 VDDL.n24 5.65022
R410 VDDL.t8 VDDL.n73 8.49123
R411 VDDL.t8 VDDL.n27 8.49123
R412 VDDL.t7 VDDL.n29 8.49123
R413 VDDL.n74 VDDL.t7 8.49123
R414 VDDL.t22 VDDL.n36 5.65022
R415 VDDL.t22 VDDL.n65 8.49123
R416 VDDL.t22 VDDL.n69 8.49123
R417 VDDL.t22 VDDL.n64 8.49123
R418 VDDL.t22 VDDL.n33 8.49123
R419 VDDL.t21 VDDL.n35 8.49123
R420 VDDL.t21 VDDL.n67 8.49123
R421 VDDL.n68 VDDL.t21 8.49123
R422 VDDL.t21 VDDL.n66 8.49123
R423 VDDL.t21 VDDL.n34 5.65022
R424 VDDL.n99 VDDL.n98 4.8581
R425 VDDL.n71 VDDL.t31 2.45957
R426 VDDL.n97 VDDL.t2 2.45942
R427 VDDL.n56 VDDL.t35 2.45919
R428 VDDL.n76 VDDL.t30 2.45892
R429 VDDL.n82 VDDL.t29 2.45873
R430 VDDL.n63 VDDL.t32 2.45852
R431 VDDL.n37 VDDL.n83 0.88446
R432 VDDL.n39 VDDL.t14 0.88446
R433 VDDL.n38 VDDL.n57 0.88446
R434 VDDL.n40 VDDL.n72 0.88446
R435 VDDL.n97 VDDL.n96 0.653499
R436 VDDL.n82 VDDL.n81 0.653499
R437 VDDL.t33 VDDL.n48 0.653499
R438 VDDL.t34 VDDL.n44 0.653499
R439 VDDL.n63 VDDL.n62 0.653499
R440 VDDL.n56 VDDL.n55 0.653499
R441 VDDL.n76 VDDL.n75 0.653499
R442 VDDL.n71 VDDL.n70 0.653499
R443 VDDL.n22 VDDL.n19 0.0667616
R444 VDDL.n75 VDDL.n27 0.071314
R445 VDDL.n31 VDDL.n30 0.0667616
R446 VDDL VDDL.n40 0.06078
R447 VDDL.n67 VDDL.n36 0.0610727
R448 VDDL.n64 VDDL.n34 0.0610727
R449 VDDL.n53 VDDL.n26 0.0610727
R450 VDDL.n49 VDDL.n24 0.0610727
R451 VDDL.n21 VDDL.n60 0.0610727
R452 VDDL VDDL.n39 0.0599
R453 VDDL.n74 VDDL.n32 0.0604207
R454 VDDL.n73 VDDL.n31 0.0604207
R455 VDDL.n59 VDDL.n22 0.0604207
R456 VDDL VDDL.n38 0.05814
R457 VDDL VDDL.n37 0.05726
R458 VDDL.n96 VDDL.n84 0.0512692
R459 VDDL.n81 VDDL.n4 0.0512692
R460 VDDL.n48 VDDL.n8 0.0512692
R461 VDDL.n44 VDDL.n12 0.0512692
R462 VDDL.n62 VDDL.n20 0.0512692
R463 VDDL.n55 VDDL.n23 0.0512692
R464 VDDL.n70 VDDL.n33 0.0512692
R465 VDDL.n91 VDDL.n88 0.0405896
R466 VDDL.n93 VDDL.n87 0.0405896
R467 VDDL.n89 VDDL.n85 0.0405896
R468 VDDL.n92 VDDL.n89 0.0405896
R469 VDDL.n92 VDDL.n88 0.0405896
R470 VDDL.n91 VDDL.n87 0.0405896
R471 VDDL.n94 VDDL.n93 0.0405896
R472 VDDL.n94 VDDL.n90 0.0405896
R473 VDDL.n90 VDDL.n86 0.0405896
R474 VDDL.n2 VDDL.n78 0.0544221
R475 VDDL.n79 VDDL.n77 0.0405896
R476 VDDL.n7 VDDL.n47 0.0610727
R477 VDDL.n47 VDDL.n10 0.0544221
R478 VDDL.n46 VDDL.n45 0.0405896
R479 VDDL.n43 VDDL.n42 0.0405896
R480 VDDL.n42 VDDL.n41 0.0405896
R481 VDDL.n61 VDDL.n59 0.0405896
R482 VDDL.n61 VDDL.n58 0.0405896
R483 VDDL.n60 VDDL.n58 0.0405896
R484 VDDL.n52 VDDL.n50 0.0405896
R485 VDDL.n54 VDDL.n53 0.0405896
R486 VDDL.n54 VDDL.n51 0.0405896
R487 VDDL.n51 VDDL.n50 0.0405896
R488 VDDL.n52 VDDL.n49 0.0405896
R489 VDDL.n74 VDDL.n73 0.0405896
R490 VDDL.n28 VDDL.n27 0.0413679
R491 VDDL.n69 VDDL.n68 0.0405896
R492 VDDL.n67 VDDL.n65 0.0405896
R493 VDDL.n68 VDDL.n65 0.0405896
R494 VDDL.n69 VDDL.n66 0.0405896
R495 VDDL.n66 VDDL.n64 0.0405896
R496 VDDL.t26 VDDL.n17 15.0718
R497 VDDL.n41 VDDL.n13 0.0610727
R498 VDDL.n9 VDDL.n46 0.0610727
R499 VDDL.n43 VDDL.n15 0.0604207
R500 VDDL.n45 VDDL.n11 0.0604207
R501 VDDL.n5 VDDL.n80 0.0601558
R502 VDDL.n86 VDDL.n84 0.0205448
R503 VDDL.n95 VDDL.n85 0.0205448
R504 VDDL.n80 VDDL.n77 0.0205448
R505 VDDL.n3 VDDL.n79 0.0604207
R506 VDDL.t17 VDDL.n1 15.0718
R507 VDD.t10 VDD.n15 4.22725
R508 VDD.n15 VDD.n16 0.0470542
R509 VDD.t9 VDD.n16 5.65491
R510 VDD.n11 VDD.n12 0.0552765
R511 VDD.t16 VDD.n12 4.23061
R512 VDD.n18 VDD.n17 0.0399586
R513 VDD.n5 VDD.n12 0.123396
R514 VDD.t15 VDD.n5 2.09448
R515 VDD.t7 VDD.n19 4.22725
R516 VDD.n19 VDD.n20 0.0470542
R517 VDD.n13 VDD.n14 0.0403089
R518 VDD.n20 VDD.t6 5.65491
R519 VDD.n127 VDD.t0 15.0569
R520 VDD.n69 VDD.t1 15.0569
R521 VDD.n96 VDD.t2 15.0569
R522 VDD.n124 VDD.t3 15.0569
R523 VDD.t11 VDD.n6 15.0716
R524 VDD.t14 VDD.n11 15.0513
R525 VDD.t5 VDD.n13 15.0513
R526 VDD.n27 VDD.t66 15.0005
R527 VDD.t65 VDD.n28 15.0005
R528 VDD.t64 VDD.n25 15.0005
R529 VDD.n32 VDD.t63 15.0005
R530 VDD.n33 VDD.t62 15.0005
R531 VDD.t61 VDD.n34 15.0005
R532 VDD.t60 VDD.n23 15.0005
R533 VDD.n38 VDD.t59 15.0005
R534 VDD.n39 VDD.t58 15.0005
R535 VDD.t57 VDD.n40 15.0005
R536 VDD.t56 VDD.n21 15.0005
R537 VDD.t66 VDD.n26 15.0005
R538 VDD.n29 VDD.t65 15.0005
R539 VDD.n30 VDD.t64 15.0005
R540 VDD.t63 VDD.n31 15.0005
R541 VDD.t62 VDD.n24 15.0005
R542 VDD.n35 VDD.t61 15.0005
R543 VDD.n36 VDD.t60 15.0005
R544 VDD.t59 VDD.n37 15.0005
R545 VDD.t58 VDD.n22 15.0005
R546 VDD.n41 VDD.t57 15.0005
R547 VDD.n42 VDD.t56 15.0005
R548 VDD.n66 VDD.t8 15.0005
R549 VDD.n50 VDD.t54 15.0005
R550 VDD.t53 VDD.n51 15.0005
R551 VDD.t52 VDD.n47 15.0005
R552 VDD.n55 VDD.t51 15.0005
R553 VDD.n56 VDD.t50 15.0005
R554 VDD.t49 VDD.n57 15.0005
R555 VDD.t48 VDD.n45 15.0005
R556 VDD.n61 VDD.t47 15.0005
R557 VDD.n62 VDD.t46 15.0005
R558 VDD.t45 VDD.n63 15.0005
R559 VDD.t44 VDD.n43 15.0005
R560 VDD.t54 VDD.n48 15.0005
R561 VDD.n52 VDD.t53 15.0005
R562 VDD.n53 VDD.t52 15.0005
R563 VDD.t51 VDD.n54 15.0005
R564 VDD.t50 VDD.n46 15.0005
R565 VDD.n58 VDD.t49 15.0005
R566 VDD.n59 VDD.t48 15.0005
R567 VDD.t47 VDD.n60 15.0005
R568 VDD.t46 VDD.n44 15.0005
R569 VDD.n64 VDD.t45 15.0005
R570 VDD.n65 VDD.t44 15.0005
R571 VDD.n93 VDD.t11 15.0005
R572 VDD.n77 VDD.t42 15.0005
R573 VDD.t41 VDD.n78 15.0005
R574 VDD.t40 VDD.n74 15.0005
R575 VDD.n82 VDD.t39 15.0005
R576 VDD.n83 VDD.t38 15.0005
R577 VDD.t37 VDD.n84 15.0005
R578 VDD.t36 VDD.n72 15.0005
R579 VDD.n88 VDD.t35 15.0005
R580 VDD.n89 VDD.t34 15.0005
R581 VDD.t33 VDD.n90 15.0005
R582 VDD.t32 VDD.n70 15.0005
R583 VDD.t42 VDD.n75 15.0005
R584 VDD.n79 VDD.t41 15.0005
R585 VDD.n80 VDD.t40 15.0005
R586 VDD.t39 VDD.n81 15.0005
R587 VDD.t38 VDD.n73 15.0005
R588 VDD.n85 VDD.t37 15.0005
R589 VDD.n86 VDD.t36 15.0005
R590 VDD.t35 VDD.n87 15.0005
R591 VDD.t34 VDD.n71 15.0005
R592 VDD.n91 VDD.t33 15.0005
R593 VDD.n92 VDD.t32 15.0005
R594 VDD.n121 VDD.t14 15.0005
R595 VDD.n104 VDD.t30 15.0005
R596 VDD.t29 VDD.n105 15.0005
R597 VDD.t28 VDD.n101 15.0005
R598 VDD.n109 VDD.t27 15.0005
R599 VDD.n110 VDD.t26 15.0005
R600 VDD.t25 VDD.n111 15.0005
R601 VDD.t24 VDD.n99 15.0005
R602 VDD.n115 VDD.t23 15.0005
R603 VDD.n116 VDD.t22 15.0005
R604 VDD.t21 VDD.n117 15.0005
R605 VDD.t20 VDD.n97 15.0005
R606 VDD.t30 VDD.n102 15.0005
R607 VDD.n106 VDD.t29 15.0005
R608 VDD.n107 VDD.t28 15.0005
R609 VDD.t27 VDD.n108 15.0005
R610 VDD.t26 VDD.n100 15.0005
R611 VDD.n112 VDD.t25 15.0005
R612 VDD.n113 VDD.t24 15.0005
R613 VDD.t23 VDD.n114 15.0005
R614 VDD.t22 VDD.n98 15.0005
R615 VDD.n118 VDD.t21 15.0005
R616 VDD.n119 VDD.t20 15.0005
R617 VDD.n129 VDD.t5 15.0005
R618 VDD VDD.n130 9.25394
R619 VDD VDD.n67 9.25394
R620 VDD VDD.n94 9.25394
R621 VDD VDD.n122 9.25394
R622 VDD.n3 VDD.n7 0.114387
R623 VDD.t10 VDD.n3 1.66971
R624 VDD.t13 VDD.n1 1.16138
R625 VDD.t12 VDD.n6 4.23653
R626 VDD.n0 VDD.n1 0.164891
R627 VDD.t12 VDD.n0 1.63054
R628 VDD.n4 VDD.n5 0.0976861
R629 VDD.t16 VDD.n18 5.65068
R630 VDD.t15 VDD.n120 8.49149
R631 VDD.t15 VDD.n17 8.49149
R632 VDD.t7 VDD.n128 8.49149
R633 VDD.t7 VDD.n8 2.80549
R634 VDD.n14 VDD.t6 5.65057
R635 VDD.n10 VDD.t6 4.23666
R636 VDD.n8 VDD.n9 0.0927643
R637 VDD.n3 VDD.n2 0.115323
R638 VDD.t9 VDD.n7 4.22186
R639 VDD.t9 VDD.n2 2.38583
R640 VDD.n1 VDD.n6 0.161381
R641 VDD.t16 VDD.n4 2.38635
R642 VDD.t15 VDD.n11 8.49136
R643 VDD.n13 VDD.t7 8.49136
R644 VDD.n8 VDD.n10 0.0866122
R645 VDD.n9 VDD.t6 4.22697
R646 VDD VDD.n131 8.36777
R647 VDD.n68 VDD 8.36777
R648 VDD.n95 VDD 8.36777
R649 VDD.n123 VDD 8.36777
R650 VDD.n49 VDD.t55 6.7177
R651 VDD.n76 VDD.t43 6.7177
R652 VDD.n103 VDD.t31 6.7177
R653 VDD.n125 VDD.n124 5.68266
R654 VDD.n127 VDD.n126 5.56122
R655 VDD.n126 VDD.n125 4.82818
R656 VDD.n94 VDD.t19 2.27984
R657 VDD.n122 VDD.t18 2.27934
R658 VDD.n67 VDD.t17 2.27917
R659 VDD.n130 VDD.t4 2.27898
R660 VDD.n27 VDD.t67 1.8365
R661 VDD.t67 VDD.n26 1.8365
R662 VDD.n50 VDD.n49 1.8365
R663 VDD.n49 VDD.n48 1.8365
R664 VDD.n77 VDD.n76 1.8365
R665 VDD.n76 VDD.n75 1.8365
R666 VDD.n104 VDD.n103 1.8365
R667 VDD.n103 VDD.n102 1.8365
R668 VDD VDD.n42 1.47481
R669 VDD VDD.n65 1.47481
R670 VDD VDD.n92 1.47481
R671 VDD VDD.n119 1.47481
R672 VDD VDD.n97 1.47481
R673 VDD VDD.n70 1.47481
R674 VDD VDD.n43 1.47481
R675 VDD VDD.n21 1.47481
R676 VDD.n131 VDD.n127 1.26902
R677 VDD.n69 VDD.n68 1.26902
R678 VDD.n96 VDD.n95 1.26902
R679 VDD.n124 VDD.n123 1.26902
R680 VDD.n126 VDD.n69 0.8409
R681 VDD.n125 VDD.n96 0.8409
R682 VDD.n67 VDD.n66 0.653499
R683 VDD.n94 VDD.n93 0.653499
R684 VDD.n122 VDD.n121 0.653499
R685 VDD.n130 VDD.n129 0.653499
R686 VDD.n28 VDD.n27 0.269389
R687 VDD.n28 VDD.n25 0.269389
R688 VDD.n32 VDD.n25 0.269389
R689 VDD.n33 VDD.n32 0.269389
R690 VDD.n34 VDD.n33 0.269389
R691 VDD.n34 VDD.n23 0.269389
R692 VDD.n38 VDD.n23 0.269389
R693 VDD.n39 VDD.n38 0.269389
R694 VDD.n40 VDD.n39 0.269389
R695 VDD.n40 VDD.n21 0.269389
R696 VDD.n29 VDD.n26 0.269389
R697 VDD.n30 VDD.n29 0.269389
R698 VDD.n31 VDD.n30 0.269389
R699 VDD.n31 VDD.n24 0.269389
R700 VDD.n35 VDD.n24 0.269389
R701 VDD.n36 VDD.n35 0.269389
R702 VDD.n37 VDD.n36 0.269389
R703 VDD.n37 VDD.n22 0.269389
R704 VDD.n41 VDD.n22 0.269389
R705 VDD.n42 VDD.n41 0.269389
R706 VDD.n51 VDD.n50 0.269389
R707 VDD.n51 VDD.n47 0.269389
R708 VDD.n55 VDD.n47 0.269389
R709 VDD.n56 VDD.n55 0.269389
R710 VDD.n57 VDD.n56 0.269389
R711 VDD.n57 VDD.n45 0.269389
R712 VDD.n61 VDD.n45 0.269389
R713 VDD.n62 VDD.n61 0.269389
R714 VDD.n63 VDD.n62 0.269389
R715 VDD.n63 VDD.n43 0.269389
R716 VDD.n52 VDD.n48 0.269389
R717 VDD.n53 VDD.n52 0.269389
R718 VDD.n54 VDD.n53 0.269389
R719 VDD.n54 VDD.n46 0.269389
R720 VDD.n58 VDD.n46 0.269389
R721 VDD.n59 VDD.n58 0.269389
R722 VDD.n60 VDD.n59 0.269389
R723 VDD.n60 VDD.n44 0.269389
R724 VDD.n64 VDD.n44 0.269389
R725 VDD.n65 VDD.n64 0.269389
R726 VDD.n78 VDD.n77 0.269389
R727 VDD.n78 VDD.n74 0.269389
R728 VDD.n82 VDD.n74 0.269389
R729 VDD.n83 VDD.n82 0.269389
R730 VDD.n84 VDD.n83 0.269389
R731 VDD.n84 VDD.n72 0.269389
R732 VDD.n88 VDD.n72 0.269389
R733 VDD.n89 VDD.n88 0.269389
R734 VDD.n90 VDD.n89 0.269389
R735 VDD.n90 VDD.n70 0.269389
R736 VDD.n79 VDD.n75 0.269389
R737 VDD.n80 VDD.n79 0.269389
R738 VDD.n81 VDD.n80 0.269389
R739 VDD.n81 VDD.n73 0.269389
R740 VDD.n85 VDD.n73 0.269389
R741 VDD.n86 VDD.n85 0.269389
R742 VDD.n87 VDD.n86 0.269389
R743 VDD.n87 VDD.n71 0.269389
R744 VDD.n91 VDD.n71 0.269389
R745 VDD.n92 VDD.n91 0.269389
R746 VDD.n105 VDD.n104 0.269389
R747 VDD.n105 VDD.n101 0.269389
R748 VDD.n109 VDD.n101 0.269389
R749 VDD.n110 VDD.n109 0.269389
R750 VDD.n111 VDD.n110 0.269389
R751 VDD.n111 VDD.n99 0.269389
R752 VDD.n115 VDD.n99 0.269389
R753 VDD.n116 VDD.n115 0.269389
R754 VDD.n117 VDD.n116 0.269389
R755 VDD.n117 VDD.n97 0.269389
R756 VDD.n106 VDD.n102 0.269389
R757 VDD.n107 VDD.n106 0.269389
R758 VDD.n108 VDD.n107 0.269389
R759 VDD.n108 VDD.n100 0.269389
R760 VDD.n112 VDD.n100 0.269389
R761 VDD.n113 VDD.n112 0.269389
R762 VDD.n114 VDD.n113 0.269389
R763 VDD.n114 VDD.n98 0.269389
R764 VDD.n118 VDD.n98 0.269389
R765 VDD.n119 VDD.n118 0.269389
R766 VDD.n131 VDD 0.08014
R767 VDD.n68 VDD 0.08014
R768 VDD.n95 VDD 0.08014
R769 VDD.n123 VDD 0.08014
R770 VDD.n15 VDD.n2 0.176393
R771 VDD.n66 VDD.n16 0.0648925
R772 VDD.n93 VDD.n0 0.210096
R773 VDD.n121 VDD.n17 0.0512692
R774 VDD.n129 VDD.n20 0.0648925
R775 VDD.n14 VDD.n128 0.059668
R776 VDD.n18 VDD.n120 0.059493
R777 VDD.n120 VDD.n4 0.140665
R778 VDD.n10 VDD.n128 0.0599017
R779 VDD.n9 VDD.n19 0.118275
R780 VDD.t8 VDD.n7 15.101
R781 VSS.n222 VSS.t294 14680.1
R782 VSS.n225 VSS.t158 13019
R783 VSS.n257 VSS.t150 13019
R784 VSS.n283 VSS.t142 13019
R785 VSS.t134 VSS.t263 12179.9
R786 VSS.n254 VSS.t243 4604.04
R787 VSS.n280 VSS.t236 4582.31
R788 VSS.n303 VSS.t229 4416.62
R789 VSS.t252 VSS.n304 3518.67
R790 VSS.n224 VSS.t305 3415.48
R791 VSS.n256 VSS.t86 3415.48
R792 VSS.n282 VSS.t74 3415.48
R793 VSS.n227 VSS.t293 2767.73
R794 VSS.n204 VSS.t96 2751.2
R795 VSS.n195 VSS.t297 2625.12
R796 VSS.n225 VSS.t9 2488.58
R797 VSS.n257 VSS.t8 2488.58
R798 VSS.n283 VSS.t7 2488.58
R799 VSS.t281 VSS.t217 1684.62
R800 VSS.t308 VSS.t209 1684.62
R801 VSS.t92 VSS.t201 1684.62
R802 VSS.t67 VSS.t193 1684.62
R803 VSS.n224 VSS.t270 1578.46
R804 VSS.n256 VSS.t260 1578.46
R805 VSS.n282 VSS.t81 1578.46
R806 VSS.n304 VSS.t17 1578.46
R807 VSS.t289 VSS.t98 1537.92
R808 VSS.t12 VSS.t289 1537.92
R809 VSS.t263 VSS.t15 1537.92
R810 VSS.t102 VSS.n322 1403.09
R811 VSS.t6 VSS.n324 1391.24
R812 VSS.n290 VSS.n289 1129.07
R813 VSS.n323 VSS.n188 1116.82
R814 VSS.n264 VSS.n263 1051.69
R815 VSS.n238 VSS.n237 1042.32
R816 VSS.n323 VSS.t15 1028.09
R817 VSS.n224 VSS.t183 924
R818 VSS.n256 VSS.t176 924
R819 VSS.n282 VSS.t169 924
R820 VSS.n304 VSS.t162 924
R821 VSS.t158 VSS.t268 805.148
R822 VSS.t150 VSS.t258 805.148
R823 VSS.t142 VSS.t79 805.148
R824 VSS.t13 VSS.t134 805.148
R825 VSS.n224 VSS.t280 754.413
R826 VSS.n256 VSS.t307 754.413
R827 VSS.n282 VSS.t91 754.413
R828 VSS.n304 VSS.t66 754.413
R829 VSS.n322 VSS.t12 610.956
R830 VSS.n323 VSS.t102 509.832
R831 VSS.t70 VSS.t225 378.632
R832 VSS.t298 VSS.t88 365
R833 VSS.t10 VSS.t75 365
R834 VSS.t4 VSS.t87 365
R835 VSS.t291 VSS.t261 365
R836 VSS.n189 VSS.t221 352.697
R837 VSS.n322 VSS.t225 347.51
R838 VSS.t69 VSS.n321 334.026
R839 VSS.n324 VSS.n323 328.401
R840 VSS.t213 VSS.t283 323.224
R841 VSS.t205 VSS.t310 323.224
R842 VSS.t197 VSS.t94 323.224
R843 VSS.n224 VSS.n222 307.68
R844 VSS.n256 VSS.n254 307.68
R845 VSS.n282 VSS.n280 307.68
R846 VSS.n304 VSS.n303 307.68
R847 VSS.t7 VSS.n139 305.606
R848 VSS.t8 VSS.n114 305.606
R849 VSS.n213 VSS.t9 305.606
R850 VSS.n325 VSS.t6 305.604
R851 VSS.t183 VSS.t298 303.759
R852 VSS.t176 VSS.t10 303.759
R853 VSS.t169 VSS.t4 303.759
R854 VSS.t162 VSS.t291 303.759
R855 VSS.t130 VSS.t249 254.77
R856 VSS.t273 VSS.t213 247.851
R857 VSS.t277 VSS.t205 247.851
R858 VSS.t2 VSS.t197 247.851
R859 VSS.t265 VSS.t126 246.987
R860 VSS.t118 VSS.t255 246.987
R861 VSS.t110 VSS.t76 246.987
R862 VSS.n322 VSS.t130 233.831
R863 VSS.n212 VSS.t243 230.875
R864 VSS.n203 VSS.t236 230.875
R865 VSS.n194 VSS.t229 230.875
R866 VSS.t249 VSS.t251 210.056
R867 VSS.n305 VSS.t70 209.133
R868 VSS.n238 VSS.t283 205.071
R869 VSS.n264 VSS.t310 194.207
R870 VSS.t154 VSS.t266 187.565
R871 VSS.t256 VSS.t146 187.565
R872 VSS.t77 VSS.t138 187.565
R873 VSS.t301 VSS.n236 181.364
R874 VSS.t82 VSS.n262 181.364
R875 VSS.t285 VSS.n288 181.364
R876 VSS.t55 VSS.t54 180.698
R877 VSS.t56 VSS.t55 180.698
R878 VSS.t57 VSS.t56 180.698
R879 VSS.t58 VSS.t57 180.698
R880 VSS.t59 VSS.t58 180.698
R881 VSS.t60 VSS.t59 180.698
R882 VSS.t61 VSS.t60 180.698
R883 VSS.t62 VSS.t61 180.698
R884 VSS.t63 VSS.t62 180.698
R885 VSS.t64 VSS.t63 180.698
R886 VSS.t65 VSS.t64 180.698
R887 VSS.t42 VSS.t43 180.698
R888 VSS.t43 VSS.t44 180.698
R889 VSS.t44 VSS.t45 180.698
R890 VSS.t45 VSS.t46 180.698
R891 VSS.t46 VSS.t47 180.698
R892 VSS.t47 VSS.t48 180.698
R893 VSS.t48 VSS.t49 180.698
R894 VSS.t49 VSS.t50 180.698
R895 VSS.t50 VSS.t51 180.698
R896 VSS.t51 VSS.t52 180.698
R897 VSS.t52 VSS.t53 180.698
R898 VSS.t30 VSS.t31 180.698
R899 VSS.t31 VSS.t32 180.698
R900 VSS.t32 VSS.t33 180.698
R901 VSS.t33 VSS.t34 180.698
R902 VSS.t34 VSS.t35 180.698
R903 VSS.t35 VSS.t36 180.698
R904 VSS.t36 VSS.t37 180.698
R905 VSS.t37 VSS.t38 180.698
R906 VSS.t38 VSS.t39 180.698
R907 VSS.t39 VSS.t40 180.698
R908 VSS.t40 VSS.t41 180.698
R909 VSS.t18 VSS.t19 180.698
R910 VSS.t19 VSS.t20 180.698
R911 VSS.t20 VSS.t21 180.698
R912 VSS.t21 VSS.t22 180.698
R913 VSS.t22 VSS.t23 180.698
R914 VSS.t23 VSS.t24 180.698
R915 VSS.t24 VSS.t25 180.698
R916 VSS.t25 VSS.t26 180.698
R917 VSS.t26 VSS.t27 180.698
R918 VSS.t27 VSS.t28 180.698
R919 VSS.t28 VSS.t29 180.698
R920 VSS.t29 VSS.n163 171.108
R921 VSS.t41 VSS.n138 171.108
R922 VSS.t53 VSS.n113 171.108
R923 VSS.n214 VSS.t65 171.108
R924 VSS.n237 VSS.t265 153.98
R925 VSS.t272 VSS.n225 148.812
R926 VSS.t276 VSS.n257 148.812
R927 VSS.t1 VSS.n283 148.812
R928 VSS.n214 VSS.t294 147.494
R929 VSS.t293 VSS.n113 147.494
R930 VSS.t96 VSS.n138 147.494
R931 VSS.t297 VSS.n163 147.494
R932 VSS.n322 VSS.t69 146.267
R933 VSS.n263 VSS.t255 145.712
R934 VSS.n305 VSS.t252 112.659
R935 VSS.n290 VSS.t94 111.364
R936 VSS.n291 VSS.n290 107.288
R937 VSS.n224 VSS.t281 106.154
R938 VSS.n256 VSS.t308 106.154
R939 VSS.n282 VSS.t92 106.154
R940 VSS.n304 VSS.t67 106.154
R941 VSS.n289 VSS.t285 105.925
R942 VSS.n281 VSS.t2 104.879
R943 VSS.n255 VSS.t277 104.879
R944 VSS.n223 VSS.t273 104.879
R945 VSS.n226 VSS.t271 85.146
R946 VSS.n258 VSS.t275 85.146
R947 VSS.n284 VSS.t0 85.146
R948 VSS.n289 VSS.t76 82.6736
R949 VSS.t305 VSS.n223 75.4759
R950 VSS.t86 VSS.n255 75.4759
R951 VSS.t74 VSS.n281 75.4759
R952 VSS.t303 VSS.n226 73.4441
R953 VSS.n258 VSS.t84 73.4441
R954 VSS.n284 VSS.t72 73.4441
R955 VSS.t268 VSS.n224 50.7358
R956 VSS.t258 VSS.n256 50.7358
R957 VSS.t79 VSS.n282 50.7358
R958 VSS.n304 VSS.t13 50.7358
R959 VSS.n321 VSS.t295 44.6063
R960 VSS.n263 VSS.t82 42.8872
R961 VSS.n237 VSS.t301 34.6199
R962 VSS.n239 VSS.t287 29.1992
R963 VSS.n265 VSS.t89 29.1992
R964 VSS.n291 VSS.t253 29.1992
R965 VSS.n227 VSS.t122 27.9027
R966 VSS.n204 VSS.t114 27.9027
R967 VSS.n195 VSS.t106 27.9027
R968 VSS.n189 VSS.t295 25.9341
R969 VSS.n265 VSS.n264 24.446
R970 VSS.t287 VSS.n212 16.9765
R971 VSS.t89 VSS.n203 16.9765
R972 VSS.t253 VSS.n194 16.9765
R973 VSS.t212 VSS.n1 7.48182
R974 VSS.t246 VSS.n3 7.48182
R975 VSS.t242 VSS.n5 7.48182
R976 VSS.t121 VSS.n7 7.48182
R977 VSS.t153 VSS.n9 7.48182
R978 VSS.t125 VSS.n11 7.48182
R979 VSS.t196 VSS.n13 7.48182
R980 VSS.t232 VSS.n15 7.48182
R981 VSS.t228 VSS.n17 7.48182
R982 VSS.t105 VSS.n19 7.48182
R983 VSS.t137 VSS.n21 7.48182
R984 VSS.t109 VSS.n23 7.48182
R985 VSS.t204 VSS.n25 7.48182
R986 VSS.t239 VSS.n27 7.48182
R987 VSS.t235 VSS.n29 7.48182
R988 VSS.t113 VSS.n31 7.48182
R989 VSS.t145 VSS.n33 7.48182
R990 VSS.t117 VSS.n35 7.48182
R991 VSS.t189 VSS.n37 7.48182
R992 VSS.t224 VSS.n39 7.48182
R993 VSS.t220 VSS.n41 7.48182
R994 VSS.t97 VSS.n43 7.48182
R995 VSS.t129 VSS.n45 7.48182
R996 VSS.t101 VSS.n47 7.48182
R997 VSS.t182 VSS.n49 7.48182
R998 VSS.t186 VSS.n51 7.48182
R999 VSS.t157 VSS.n53 7.48182
R1000 VSS.t216 VSS.n55 7.48182
R1001 VSS.t133 VSS.n57 7.48182
R1002 VSS.t192 VSS.n59 7.48182
R1003 VSS.t141 VSS.n61 7.48182
R1004 VSS.t200 VSS.n63 7.48182
R1005 VSS.t149 VSS.n65 7.48182
R1006 VSS.t208 VSS.n67 7.48182
R1007 VSS.t175 VSS.n69 7.48182
R1008 VSS.t179 VSS.n71 7.48182
R1009 VSS.t168 VSS.n73 7.48182
R1010 VSS.t172 VSS.n75 7.48182
R1011 VSS.t165 VSS.n77 7.48182
R1012 VSS.t161 VSS.n79 7.48182
R1013 VSS.t323 VSS.n334 15.0005
R1014 VSS.t322 VSS.n111 15.0005
R1015 VSS.n338 VSS.t321 15.0005
R1016 VSS.n339 VSS.t320 15.0005
R1017 VSS.t319 VSS.n340 15.0005
R1018 VSS.t318 VSS.n109 15.0005
R1019 VSS.n344 VSS.t317 15.0005
R1020 VSS.n345 VSS.t316 15.0005
R1021 VSS.t315 VSS.n346 15.0005
R1022 VSS.t314 VSS.n107 15.0005
R1023 VSS.n350 VSS.t313 15.0005
R1024 VSS.n351 VSS.t312 15.0005
R1025 VSS.n335 VSS.t323 15.0005
R1026 VSS.n336 VSS.t322 15.0005
R1027 VSS.t321 VSS.n337 15.0005
R1028 VSS.t320 VSS.n110 15.0005
R1029 VSS.n341 VSS.t319 15.0005
R1030 VSS.n342 VSS.t318 15.0005
R1031 VSS.t317 VSS.n343 15.0005
R1032 VSS.t316 VSS.n108 15.0005
R1033 VSS.n347 VSS.t315 15.0005
R1034 VSS.n348 VSS.t314 15.0005
R1035 VSS.t313 VSS.n349 15.0005
R1036 VSS.t312 VSS.n106 15.0005
R1037 VSS.n0 VSS.n1 0.0646034
R1038 VSS.n2 VSS.n3 0.0646034
R1039 VSS.n4 VSS.n5 0.0646034
R1040 VSS.n6 VSS.n7 0.0646034
R1041 VSS.n8 VSS.n9 0.0646034
R1042 VSS.n10 VSS.n11 0.0646034
R1043 VSS.n12 VSS.n13 0.0646034
R1044 VSS.n14 VSS.n15 0.0646034
R1045 VSS.n16 VSS.n17 0.0646034
R1046 VSS.n18 VSS.n19 0.0646034
R1047 VSS.n20 VSS.n21 0.0646034
R1048 VSS.n22 VSS.n23 0.0646034
R1049 VSS.n162 VSS.t347 15.0005
R1050 VSS.n161 VSS.t346 15.0005
R1051 VSS.t345 VSS.n140 15.0005
R1052 VSS.t344 VSS.n157 15.0005
R1053 VSS.n156 VSS.t343 15.0005
R1054 VSS.n155 VSS.t342 15.0005
R1055 VSS.t341 VSS.n142 15.0005
R1056 VSS.t340 VSS.n151 15.0005
R1057 VSS.n150 VSS.t339 15.0005
R1058 VSS.n149 VSS.t338 15.0005
R1059 VSS.t337 VSS.n144 15.0005
R1060 VSS.t336 VSS.n145 15.0005
R1061 VSS.t347 VSS.n102 15.0005
R1062 VSS.t346 VSS.n160 15.0005
R1063 VSS.n159 VSS.t345 15.0005
R1064 VSS.n158 VSS.t344 15.0005
R1065 VSS.t343 VSS.n141 15.0005
R1066 VSS.t342 VSS.n154 15.0005
R1067 VSS.n153 VSS.t341 15.0005
R1068 VSS.n152 VSS.t340 15.0005
R1069 VSS.t339 VSS.n143 15.0005
R1070 VSS.t338 VSS.n148 15.0005
R1071 VSS.n147 VSS.t337 15.0005
R1072 VSS.n146 VSS.t336 15.0005
R1073 VSS.n24 VSS.n25 0.0646034
R1074 VSS.n26 VSS.n27 0.0646034
R1075 VSS.n28 VSS.n29 0.0646034
R1076 VSS.n30 VSS.n31 0.0646034
R1077 VSS.n32 VSS.n33 0.0646034
R1078 VSS.n34 VSS.n35 0.0646034
R1079 VSS.n137 VSS.t335 15.0005
R1080 VSS.n136 VSS.t334 15.0005
R1081 VSS.t333 VSS.n115 15.0005
R1082 VSS.t332 VSS.n132 15.0005
R1083 VSS.n131 VSS.t331 15.0005
R1084 VSS.n130 VSS.t330 15.0005
R1085 VSS.t329 VSS.n117 15.0005
R1086 VSS.t328 VSS.n126 15.0005
R1087 VSS.n125 VSS.t327 15.0005
R1088 VSS.n124 VSS.t326 15.0005
R1089 VSS.t325 VSS.n119 15.0005
R1090 VSS.t324 VSS.n120 15.0005
R1091 VSS.t335 VSS.n104 15.0005
R1092 VSS.t334 VSS.n135 15.0005
R1093 VSS.n134 VSS.t333 15.0005
R1094 VSS.n133 VSS.t332 15.0005
R1095 VSS.t331 VSS.n116 15.0005
R1096 VSS.t330 VSS.n129 15.0005
R1097 VSS.n128 VSS.t329 15.0005
R1098 VSS.n127 VSS.t328 15.0005
R1099 VSS.t327 VSS.n118 15.0005
R1100 VSS.t326 VSS.n123 15.0005
R1101 VSS.n122 VSS.t325 15.0005
R1102 VSS.n121 VSS.t324 15.0005
R1103 VSS.n186 VSS.t359 15.0005
R1104 VSS.n185 VSS.t358 15.0005
R1105 VSS.t357 VSS.n164 15.0005
R1106 VSS.t356 VSS.n181 15.0005
R1107 VSS.n180 VSS.t355 15.0005
R1108 VSS.n179 VSS.t354 15.0005
R1109 VSS.t353 VSS.n166 15.0005
R1110 VSS.t352 VSS.n175 15.0005
R1111 VSS.n174 VSS.t351 15.0005
R1112 VSS.n173 VSS.t350 15.0005
R1113 VSS.t349 VSS.n168 15.0005
R1114 VSS.t348 VSS.n169 15.0005
R1115 VSS.t359 VSS.n96 15.0005
R1116 VSS.t358 VSS.n184 15.0005
R1117 VSS.n183 VSS.t357 15.0005
R1118 VSS.n182 VSS.t356 15.0005
R1119 VSS.t355 VSS.n165 15.0005
R1120 VSS.t354 VSS.n178 15.0005
R1121 VSS.n177 VSS.t353 15.0005
R1122 VSS.n176 VSS.t352 15.0005
R1123 VSS.t351 VSS.n167 15.0005
R1124 VSS.t350 VSS.n172 15.0005
R1125 VSS.n171 VSS.t349 15.0005
R1126 VSS.n170 VSS.t348 15.0005
R1127 VSS.n36 VSS.n37 0.0646034
R1128 VSS.n38 VSS.n39 0.0646034
R1129 VSS.n40 VSS.n41 0.0646034
R1130 VSS.n42 VSS.n43 0.0646034
R1131 VSS.n44 VSS.n45 0.0646034
R1132 VSS.n46 VSS.n47 0.0646034
R1133 VSS.n48 VSS.n49 0.0646034
R1134 VSS.n50 VSS.n51 0.0646034
R1135 VSS.n52 VSS.n53 0.0646034
R1136 VSS.n54 VSS.n55 0.0646034
R1137 VSS.n56 VSS.n57 0.0646034
R1138 VSS.n58 VSS.n59 0.0646034
R1139 VSS.n60 VSS.n61 0.0646034
R1140 VSS.n62 VSS.n63 0.0646034
R1141 VSS.n64 VSS.n65 0.0646034
R1142 VSS.n66 VSS.n67 0.0646034
R1143 VSS.n68 VSS.n69 0.0646034
R1144 VSS.n70 VSS.n71 0.0646034
R1145 VSS.n72 VSS.n73 0.0646034
R1146 VSS.n74 VSS.n75 0.0646034
R1147 VSS.n76 VSS.n77 0.0646034
R1148 VSS.n78 VSS.n79 0.0646034
R1149 VSS.n239 VSS.n238 13.5813
R1150 VSS.t54 VSS.n213 12.9968
R1151 VSS.n114 VSS.t42 12.9968
R1152 VSS.n139 VSS.t30 12.9968
R1153 VSS.n325 VSS.t18 12.9967
R1154 VSS VSS.n220 11.3924
R1155 VSS VSS.n191 11.3924
R1156 VSS VSS.n278 11.3924
R1157 VSS VSS.n252 11.3924
R1158 VSS.n231 VSS.n229 10.0284
R1159 VSS.n199 VSS.n197 10.0284
R1160 VSS.n208 VSS.n206 10.0284
R1161 VSS.n310 VSS.n308 10.0284
R1162 VSS VSS.n217 10.0259
R1163 VSS VSS.n249 10.0259
R1164 VSS VSS.n275 10.0259
R1165 VSS VSS.n301 10.0259
R1166 VSS.n243 VSS.n241 10.0088
R1167 VSS.n295 VSS.n293 10.0088
R1168 VSS.n269 VSS.n267 10.0088
R1169 VSS.n316 VSS.n314 10.0088
R1170 VSS VSS.n228 9.32806
R1171 VSS VSS.n196 9.32806
R1172 VSS VSS.n205 9.32806
R1173 VSS VSS.n307 9.32806
R1174 VSS.n231 VSS.n230 9.23639
R1175 VSS.n199 VSS.n198 9.23639
R1176 VSS.n208 VSS.n207 9.23639
R1177 VSS.n310 VSS.n309 9.23639
R1178 VSS.n243 VSS.n242 9.21194
R1179 VSS.n295 VSS.n294 9.21194
R1180 VSS.n269 VSS.n268 9.21194
R1181 VSS.n316 VSS.n315 9.21194
R1182 VSS.n89 VSS.n215 9.20613
R1183 VSS.n302 VSS.n300 9.0005
R1184 VSS.n246 VSS.n245 9.0005
R1185 VSS.n298 VSS.n297 9.0005
R1186 VSS.n272 VSS.n271 9.0005
R1187 VSS.n319 VSS.n318 9.0005
R1188 VSS.n218 VSS.n216 9.0005
R1189 VSS.n221 VSS.n219 9.0005
R1190 VSS.n192 VSS.n190 9.0005
R1191 VSS.n279 VSS.n277 9.0005
R1192 VSS.n253 VSS.n251 9.0005
R1193 VSS.n250 VSS.n248 9.0005
R1194 VSS.n276 VSS.n274 9.0005
R1195 VSS.n80 VSS.n302 8.83694
R1196 VSS.n89 VSS.n218 8.83694
R1197 VSS.n86 VSS.n250 8.83694
R1198 VSS.n83 VSS.n276 8.83694
R1199 VSS.n321 VSS.n320 8.5005
R1200 VSS.n320 VSS.n189 8.5005
R1201 VSS.n292 VSS.n291 8.5005
R1202 VSS.n292 VSS.n194 8.5005
R1203 VSS.n266 VSS.n265 8.5005
R1204 VSS.n266 VSS.n203 8.5005
R1205 VSS.n240 VSS.n239 8.5005
R1206 VSS.n240 VSS.n212 8.5005
R1207 VSS.n236 VSS.n235 8.5005
R1208 VSS.n235 VSS.n227 8.5005
R1209 VSS.n262 VSS.n261 8.5005
R1210 VSS.n261 VSS.n204 8.5005
R1211 VSS.n288 VSS.n287 8.5005
R1212 VSS.n287 VSS.n195 8.5005
R1213 VSS.n0 VSS.t214 5.63557
R1214 VSS.n2 VSS.t247 5.63557
R1215 VSS.n4 VSS.t244 5.63557
R1216 VSS.n6 VSS.t123 5.63557
R1217 VSS.n8 VSS.t155 5.63557
R1218 VSS.n10 VSS.t127 5.63557
R1219 VSS.n12 VSS.t198 5.63557
R1220 VSS.n14 VSS.t233 5.63557
R1221 VSS.n16 VSS.t230 5.63557
R1222 VSS.n18 VSS.t107 5.63557
R1223 VSS.n20 VSS.t139 5.63557
R1224 VSS.n22 VSS.t111 5.63557
R1225 VSS.n24 VSS.t206 5.63557
R1226 VSS.n26 VSS.t240 5.63557
R1227 VSS.n28 VSS.t237 5.63557
R1228 VSS.n30 VSS.t115 5.63557
R1229 VSS.n32 VSS.t147 5.63557
R1230 VSS.n34 VSS.t119 5.63557
R1231 VSS.n36 VSS.t190 5.63557
R1232 VSS.n38 VSS.t226 5.63557
R1233 VSS.n40 VSS.t222 5.63557
R1234 VSS.n42 VSS.t99 5.63557
R1235 VSS.n44 VSS.t131 5.63557
R1236 VSS.n46 VSS.t103 5.63557
R1237 VSS.n48 VSS.t184 5.63557
R1238 VSS.n50 VSS.t187 5.63557
R1239 VSS.n52 VSS.t159 5.63557
R1240 VSS.n54 VSS.t218 5.63557
R1241 VSS.n56 VSS.t135 5.63557
R1242 VSS.n58 VSS.t194 5.63557
R1243 VSS.n60 VSS.t143 5.63557
R1244 VSS.n62 VSS.t202 5.63557
R1245 VSS.n64 VSS.t151 5.63557
R1246 VSS.n66 VSS.t210 5.63557
R1247 VSS.n68 VSS.t177 5.63557
R1248 VSS.n70 VSS.t180 5.63557
R1249 VSS.n72 VSS.t170 5.63557
R1250 VSS.n74 VSS.t173 5.63557
R1251 VSS.n76 VSS.t166 5.63557
R1252 VSS.n78 VSS.t163 5.63557
R1253 VSS.n236 VSS.t122 7.2344
R1254 VSS.n262 VSS.t114 7.2344
R1255 VSS.n288 VSS.t106 7.2344
R1256 VSS.n226 VSS.n99 6.91886
R1257 VSS.n259 VSS.n258 6.91886
R1258 VSS.n285 VSS.n284 6.91886
R1259 VSS.n90 VSS.n221 6.63939
R1260 VSS.n81 VSS.n192 6.63939
R1261 VSS.n84 VSS.n279 6.63939
R1262 VSS.n87 VSS.n253 6.63939
R1263 VSS.n242 VSS.t274 5.99293
R1264 VSS.n241 VSS.t284 5.99293
R1265 VSS.n245 VSS.t288 5.99293
R1266 VSS.n228 VSS.t302 5.99293
R1267 VSS.n230 VSS.t304 5.99293
R1268 VSS.n229 VSS.t267 5.99293
R1269 VSS.n294 VSS.t3 5.99293
R1270 VSS.n293 VSS.t95 5.99293
R1271 VSS.n297 VSS.t254 5.99293
R1272 VSS.n196 VSS.t286 5.99293
R1273 VSS.n198 VSS.t73 5.99293
R1274 VSS.n197 VSS.t78 5.99293
R1275 VSS.n268 VSS.t278 5.99293
R1276 VSS.n267 VSS.t311 5.99293
R1277 VSS.n271 VSS.t90 5.99293
R1278 VSS.n205 VSS.t83 5.99293
R1279 VSS.n207 VSS.t85 5.99293
R1280 VSS.n206 VSS.t257 5.99293
R1281 VSS.n315 VSS.t264 5.99293
R1282 VSS.n314 VSS.t71 5.99293
R1283 VSS.n318 VSS.t296 5.99293
R1284 VSS.n307 VSS.t290 5.99293
R1285 VSS.n309 VSS.t250 5.99293
R1286 VSS.n308 VSS.t16 5.99293
R1287 VSS.n217 VSS.t300 5.99293
R1288 VSS.n216 VSS.t299 5.99293
R1289 VSS.n220 VSS.t269 5.99293
R1290 VSS.n219 VSS.t282 5.99293
R1291 VSS.n191 VSS.t14 5.99293
R1292 VSS.n190 VSS.t68 5.99293
R1293 VSS.n278 VSS.t80 5.99293
R1294 VSS.n277 VSS.t93 5.99293
R1295 VSS.n252 VSS.t259 5.99293
R1296 VSS.n251 VSS.t309 5.99293
R1297 VSS.n249 VSS.t11 5.99293
R1298 VSS.n248 VSS.t262 5.99293
R1299 VSS.n275 VSS.t5 5.99293
R1300 VSS.n274 VSS.t279 5.99293
R1301 VSS.n300 VSS.t292 5.99293
R1302 VSS.n301 VSS.t306 5.99293
R1303 VSS.n222 VSS.n90 5.59923
R1304 VSS.n254 VSS.n87 5.59923
R1305 VSS.n280 VSS.n84 5.59923
R1306 VSS.n303 VSS.n81 5.59923
R1307 VSS.n95 VSS.n246 5.57361
R1308 VSS.n93 VSS.n298 5.57361
R1309 VSS.n94 VSS.n272 5.57361
R1310 VSS.n92 VSS.n319 5.57361
R1311 VSS.n281 VSS.n82 5.38626
R1312 VSS.n255 VSS.n85 5.38626
R1313 VSS.n223 VSS.n88 5.38626
R1314 VSS.n244 VSS.n211 5.30594
R1315 VSS.n296 VSS.n193 5.30594
R1316 VSS.n270 VSS.n202 5.30594
R1317 VSS.n317 VSS.n313 5.30594
R1318 VSS.n233 VSS.n232 5.30106
R1319 VSS.n201 VSS.n200 5.30106
R1320 VSS.n210 VSS.n209 5.30106
R1321 VSS.n312 VSS.n311 5.30106
R1322 VSS.n324 VSS.n187 5.21707
R1323 VSS.n327 VSS.n163 5.07483
R1324 VSS.n329 VSS.n139 5.07483
R1325 VSS.n330 VSS.n138 5.07483
R1326 VSS.n332 VSS.n114 5.07483
R1327 VSS.n333 VSS.n113 5.07483
R1328 VSS.n213 VSS.n112 5.07483
R1329 VSS.n215 VSS.n214 5.07483
R1330 VSS.n326 VSS.n325 5.07459
R1331 VSS.n91 VSS.n305 5.06795
R1332 VSS.n100 VSS.n333 4.48163
R1333 VSS.n331 VSS.n330 4.46403
R1334 VSS.n328 VSS.n327 4.32983
R1335 VSS.n261 VSS.n260 4.25614
R1336 VSS.n287 VSS.n286 4.25614
R1337 VSS.n235 VSS.n234 4.25596
R1338 VSS.n320 VSS.n92 4.24186
R1339 VSS.n93 VSS.n292 4.24186
R1340 VSS.n94 VSS.n266 4.24186
R1341 VSS.n95 VSS.n240 4.24186
R1342 VSS.n306 VSS.n97 2.7241
R1343 VSS.n221 VSS 2.6735
R1344 VSS.n192 VSS 2.6735
R1345 VSS.n279 VSS 2.6735
R1346 VSS.n253 VSS 2.6735
R1347 VSS.n334 VSS.n101 2.42524
R1348 VSS.n103 VSS.n162 2.42524
R1349 VSS.n105 VSS.n137 2.42524
R1350 VSS.n98 VSS.n186 2.42524
R1351 VSS.n86 VSS.n247 2.0993
R1352 VSS.n83 VSS.n273 2.0817
R1353 VSS.n232 VSS 2.01472
R1354 VSS.n200 VSS 2.01472
R1355 VSS.n209 VSS 2.01472
R1356 VSS.n311 VSS 2.01472
R1357 VSS.n91 VSS.n81 1.99343
R1358 VSS.n84 VSS.n82 1.99343
R1359 VSS.n87 VSS.n85 1.99343
R1360 VSS.n90 VSS.n88 1.99343
R1361 VSS.n244 VSS 1.9805
R1362 VSS.n296 VSS 1.9805
R1363 VSS.n270 VSS 1.9805
R1364 VSS.n317 VSS 1.9805
R1365 VSS.n80 VSS.n299 1.9475
R1366 VSS VSS.n351 1.75256
R1367 VSS.n145 VSS 1.75256
R1368 VSS.n120 VSS 1.75256
R1369 VSS.n169 VSS 1.75256
R1370 VSS VSS.n106 1.74706
R1371 VSS.n146 VSS 1.74706
R1372 VSS.n121 VSS 1.74706
R1373 VSS.n170 VSS 1.74706
R1374 VSS.n92 VSS.n313 1.7374
R1375 VSS.n232 VSS 1.63461
R1376 VSS.n200 VSS 1.63461
R1377 VSS.n209 VSS 1.63461
R1378 VSS.n311 VSS 1.63461
R1379 VSS VSS.n244 1.5955
R1380 VSS VSS.n296 1.5955
R1381 VSS VSS.n270 1.5955
R1382 VSS VSS.n317 1.5955
R1383 VSS.n247 VSS.n211 1.4294
R1384 VSS.n299 VSS.n193 1.4294
R1385 VSS.n273 VSS.n202 1.4294
R1386 VSS.n286 VSS.n201 1.40978
R1387 VSS.n260 VSS.n210 1.40978
R1388 VSS.n234 VSS.n233 1.40941
R1389 VSS.n302 VSS 1.27283
R1390 VSS.n218 VSS 1.27283
R1391 VSS.n250 VSS 1.27283
R1392 VSS.n276 VSS 1.27283
R1393 VSS.n312 VSS.n306 1.227
R1394 VSS.n327 VSS.n326 1.19617
R1395 VSS.n330 VSS.n329 1.19592
R1396 VSS.n333 VSS.n332 1.19592
R1397 VSS.n215 VSS.n112 1.19592
R1398 VSS.t126 VSS.t154 1.03391
R1399 VSS.t266 VSS.t303 1.03391
R1400 VSS.t271 VSS.t272 1.03391
R1401 VSS.t146 VSS.t118 1.03391
R1402 VSS.t84 VSS.t256 1.03391
R1403 VSS.t275 VSS.t276 1.03391
R1404 VSS.t138 VSS.t110 1.03391
R1405 VSS.t72 VSS.t77 1.03391
R1406 VSS.t0 VSS.t1 1.03391
R1407 VSS.n313 VSS.n312 0.996
R1408 VSS.n233 VSS.n211 0.996
R1409 VSS.n201 VSS.n193 0.996
R1410 VSS.n210 VSS.n202 0.996
R1411 VSS.n260 VSS.n259 0.987616
R1412 VSS.n286 VSS.n285 0.987616
R1413 VSS.n188 VSS.n187 0.986991
R1414 VSS.n234 VSS.n99 0.986991
R1415 VSS.n92 VSS.n91 0.895601
R1416 VSS.n335 VSS.n101 0.84341
R1417 VSS.n103 VSS.n102 0.84341
R1418 VSS.n105 VSS.n104 0.84341
R1419 VSS.n98 VSS.n96 0.84341
R1420 VSS.n93 VSS.n82 0.786717
R1421 VSS.n94 VSS.n85 0.786717
R1422 VSS.n95 VSS.n88 0.786717
R1423 VSS.n90 VSS.n89 0.7617
R1424 VSS.n87 VSS.n86 0.7617
R1425 VSS.n84 VSS.n83 0.7617
R1426 VSS.n81 VSS.n80 0.7617
R1427 VSS.n98 VSS.n97 0.7177
R1428 VSS.n101 VSS.n100 0.7177
R1429 VSS.n328 VSS.n103 0.7177
R1430 VSS.n331 VSS.n105 0.7177
R1431 VSS.n242 VSS.n0 0.653499
R1432 VSS.n241 VSS.n2 0.653499
R1433 VSS.n245 VSS.n4 0.653499
R1434 VSS.n228 VSS.n6 0.653499
R1435 VSS.n230 VSS.n8 0.653499
R1436 VSS.n229 VSS.n10 0.653499
R1437 VSS.n294 VSS.n12 0.653499
R1438 VSS.n293 VSS.n14 0.653499
R1439 VSS.n297 VSS.n16 0.653499
R1440 VSS.n196 VSS.n18 0.653499
R1441 VSS.n198 VSS.n20 0.653499
R1442 VSS.n197 VSS.n22 0.653499
R1443 VSS.n268 VSS.n24 0.653499
R1444 VSS.n267 VSS.n26 0.653499
R1445 VSS.n271 VSS.n28 0.653499
R1446 VSS.n205 VSS.n30 0.653499
R1447 VSS.n207 VSS.n32 0.653499
R1448 VSS.n206 VSS.n34 0.653499
R1449 VSS.n315 VSS.n36 0.653499
R1450 VSS.n314 VSS.n38 0.653499
R1451 VSS.n318 VSS.n40 0.653499
R1452 VSS.n307 VSS.n42 0.653499
R1453 VSS.n309 VSS.n44 0.653499
R1454 VSS.n308 VSS.n46 0.653499
R1455 VSS.n217 VSS.n48 0.653499
R1456 VSS.n216 VSS.n50 0.653499
R1457 VSS.n220 VSS.n52 0.653499
R1458 VSS.n219 VSS.n54 0.653499
R1459 VSS.n191 VSS.n56 0.653499
R1460 VSS.n190 VSS.n58 0.653499
R1461 VSS.n278 VSS.n60 0.653499
R1462 VSS.n277 VSS.n62 0.653499
R1463 VSS.n252 VSS.n64 0.653499
R1464 VSS.n251 VSS.n66 0.653499
R1465 VSS.n249 VSS.n68 0.653499
R1466 VSS.n248 VSS.n70 0.653499
R1467 VSS.n275 VSS.n72 0.653499
R1468 VSS.n274 VSS.n74 0.653499
R1469 VSS.n300 VSS.n76 0.653499
R1470 VSS.n301 VSS.n78 0.653499
R1471 VSS.n259 VSS.n105 0.638801
R1472 VSS.n285 VSS.n103 0.638801
R1473 VSS.n101 VSS.n99 0.638801
R1474 VSS.n187 VSS.n98 0.638801
R1475 VSS.n246 VSS 0.6165
R1476 VSS.n298 VSS 0.6165
R1477 VSS.n272 VSS 0.6165
R1478 VSS.n319 VSS 0.6165
R1479 VSS VSS.n243 0.565167
R1480 VSS VSS.n295 0.565167
R1481 VSS VSS.n269 0.565167
R1482 VSS VSS.n316 0.565167
R1483 VSS.n247 VSS.n95 0.417384
R1484 VSS.n273 VSS.n94 0.417384
R1485 VSS.n299 VSS.n93 0.417384
R1486 VSS.n329 VSS.n328 0.379984
R1487 VSS.n332 VSS.n331 0.379984
R1488 VSS.n100 VSS.n112 0.379984
R1489 VSS.n326 VSS.n97 0.379733
R1490 VSS.n334 VSS.n111 0.269389
R1491 VSS.n338 VSS.n111 0.269389
R1492 VSS.n339 VSS.n338 0.269389
R1493 VSS.n340 VSS.n339 0.269389
R1494 VSS.n340 VSS.n109 0.269389
R1495 VSS.n344 VSS.n109 0.269389
R1496 VSS.n345 VSS.n344 0.269389
R1497 VSS.n346 VSS.n345 0.269389
R1498 VSS.n346 VSS.n107 0.269389
R1499 VSS.n350 VSS.n107 0.269389
R1500 VSS.n351 VSS.n350 0.269389
R1501 VSS.n336 VSS.n335 0.269389
R1502 VSS.n337 VSS.n336 0.269389
R1503 VSS.n337 VSS.n110 0.269389
R1504 VSS.n341 VSS.n110 0.269389
R1505 VSS.n342 VSS.n341 0.269389
R1506 VSS.n343 VSS.n342 0.269389
R1507 VSS.n343 VSS.n108 0.269389
R1508 VSS.n347 VSS.n108 0.269389
R1509 VSS.n348 VSS.n347 0.269389
R1510 VSS.n349 VSS.n348 0.269389
R1511 VSS.n349 VSS.n106 0.269389
R1512 VSS.n162 VSS.n161 0.269389
R1513 VSS.n161 VSS.n140 0.269389
R1514 VSS.n157 VSS.n140 0.269389
R1515 VSS.n157 VSS.n156 0.269389
R1516 VSS.n156 VSS.n155 0.269389
R1517 VSS.n155 VSS.n142 0.269389
R1518 VSS.n151 VSS.n142 0.269389
R1519 VSS.n151 VSS.n150 0.269389
R1520 VSS.n150 VSS.n149 0.269389
R1521 VSS.n149 VSS.n144 0.269389
R1522 VSS.n145 VSS.n144 0.269389
R1523 VSS.n160 VSS.n102 0.269389
R1524 VSS.n160 VSS.n159 0.269389
R1525 VSS.n159 VSS.n158 0.269389
R1526 VSS.n158 VSS.n141 0.269389
R1527 VSS.n154 VSS.n141 0.269389
R1528 VSS.n154 VSS.n153 0.269389
R1529 VSS.n153 VSS.n152 0.269389
R1530 VSS.n152 VSS.n143 0.269389
R1531 VSS.n148 VSS.n143 0.269389
R1532 VSS.n148 VSS.n147 0.269389
R1533 VSS.n147 VSS.n146 0.269389
R1534 VSS.n137 VSS.n136 0.269389
R1535 VSS.n136 VSS.n115 0.269389
R1536 VSS.n132 VSS.n115 0.269389
R1537 VSS.n132 VSS.n131 0.269389
R1538 VSS.n131 VSS.n130 0.269389
R1539 VSS.n130 VSS.n117 0.269389
R1540 VSS.n126 VSS.n117 0.269389
R1541 VSS.n126 VSS.n125 0.269389
R1542 VSS.n125 VSS.n124 0.269389
R1543 VSS.n124 VSS.n119 0.269389
R1544 VSS.n120 VSS.n119 0.269389
R1545 VSS.n135 VSS.n104 0.269389
R1546 VSS.n135 VSS.n134 0.269389
R1547 VSS.n134 VSS.n133 0.269389
R1548 VSS.n133 VSS.n116 0.269389
R1549 VSS.n129 VSS.n116 0.269389
R1550 VSS.n129 VSS.n128 0.269389
R1551 VSS.n128 VSS.n127 0.269389
R1552 VSS.n127 VSS.n118 0.269389
R1553 VSS.n123 VSS.n118 0.269389
R1554 VSS.n123 VSS.n122 0.269389
R1555 VSS.n122 VSS.n121 0.269389
R1556 VSS.n186 VSS.n185 0.269389
R1557 VSS.n185 VSS.n164 0.269389
R1558 VSS.n181 VSS.n164 0.269389
R1559 VSS.n181 VSS.n180 0.269389
R1560 VSS.n180 VSS.n179 0.269389
R1561 VSS.n179 VSS.n166 0.269389
R1562 VSS.n175 VSS.n166 0.269389
R1563 VSS.n175 VSS.n174 0.269389
R1564 VSS.n174 VSS.n173 0.269389
R1565 VSS.n173 VSS.n168 0.269389
R1566 VSS.n169 VSS.n168 0.269389
R1567 VSS.n184 VSS.n96 0.269389
R1568 VSS.n184 VSS.n183 0.269389
R1569 VSS.n183 VSS.n182 0.269389
R1570 VSS.n182 VSS.n165 0.269389
R1571 VSS.n178 VSS.n165 0.269389
R1572 VSS.n178 VSS.n177 0.269389
R1573 VSS.n177 VSS.n176 0.269389
R1574 VSS.n176 VSS.n167 0.269389
R1575 VSS.n172 VSS.n167 0.269389
R1576 VSS.n172 VSS.n171 0.269389
R1577 VSS.n171 VSS.n170 0.269389
R1578 VSS VSS.n231 0.2645
R1579 VSS VSS.n199 0.2645
R1580 VSS VSS.n208 0.2645
R1581 VSS VSS.n310 0.2645
R1582 VSS.n306 VSS.n188 0.18291
R1583 VSS.t164 VSS.n79 5.71547
R1584 VSS.t167 VSS.n77 5.71547
R1585 VSS.t174 VSS.n75 5.71547
R1586 VSS.t171 VSS.n73 5.71547
R1587 VSS.t181 VSS.n71 5.71547
R1588 VSS.t178 VSS.n69 5.71547
R1589 VSS.t211 VSS.n67 5.71547
R1590 VSS.t152 VSS.n65 5.71547
R1591 VSS.t203 VSS.n63 5.71547
R1592 VSS.t144 VSS.n61 5.71547
R1593 VSS.t195 VSS.n59 5.71547
R1594 VSS.t136 VSS.n57 5.71547
R1595 VSS.t219 VSS.n55 5.71547
R1596 VSS.t160 VSS.n53 5.71547
R1597 VSS.t188 VSS.n51 5.71547
R1598 VSS.t185 VSS.n49 5.71547
R1599 VSS.t104 VSS.n47 5.71547
R1600 VSS.t132 VSS.n45 5.71547
R1601 VSS.t100 VSS.n43 5.71547
R1602 VSS.t223 VSS.n41 5.71547
R1603 VSS.t227 VSS.n39 5.71547
R1604 VSS.t191 VSS.n37 5.71547
R1605 VSS.t120 VSS.n35 5.71547
R1606 VSS.t148 VSS.n33 5.71547
R1607 VSS.t116 VSS.n31 5.71547
R1608 VSS.t238 VSS.n29 5.71547
R1609 VSS.t241 VSS.n27 5.71547
R1610 VSS.t207 VSS.n25 5.71547
R1611 VSS.t112 VSS.n23 5.71547
R1612 VSS.t140 VSS.n21 5.71547
R1613 VSS.t108 VSS.n19 5.71547
R1614 VSS.t231 VSS.n17 5.71547
R1615 VSS.t234 VSS.n15 5.71547
R1616 VSS.t199 VSS.n13 5.71547
R1617 VSS.t128 VSS.n11 5.71547
R1618 VSS.t156 VSS.n9 5.71547
R1619 VSS.t124 VSS.n7 5.71547
R1620 VSS.t245 VSS.n5 5.71547
R1621 VSS.t248 VSS.n3 5.71547
R1622 VSS.t215 VSS.n1 5.71547
R1623 GROUP22_2.G.n39 GROUP22_2.G.n7 18.0594
R1624 GROUP22_2.G.n0 GROUP22_2.G.n15 17.7473
R1625 GROUP22_2.G.t7 GROUP22_2.G.n13 7.53302
R1626 GROUP22_2.G.n18 GROUP22_2.G.t24 15.0033
R1627 GROUP22_2.G.n12 GROUP22_2.G.n13 0.0397382
R1628 GROUP22_2.G.t21 GROUP22_2.G.n14 7.09562
R1629 GROUP22_2.G.n8 GROUP22_2.G.t23 7.42005
R1630 GROUP22_2.G.n7 GROUP22_2.G.t22 7.69815
R1631 GROUP22_2.G.n11 GROUP22_2.G.t10 7.53302
R1632 GROUP22_2.G.t24 GROUP22_2.G.n15 15.0005
R1633 GROUP22_2.G.n14 GROUP22_2.G.n39 15.9045
R1634 GROUP22_2.G.n0 GROUP22_2.G.t18 12.3725
R1635 GROUP22_2.G.n27 GROUP22_2.G.t17 12.3725
R1636 GROUP22_2.G.n26 GROUP22_2.G.t16 12.3725
R1637 GROUP22_2.G.n25 GROUP22_2.G.t15 12.3725
R1638 GROUP22_2.G.n20 GROUP22_2.G.t14 12.3725
R1639 GROUP22_2.G.n6 GROUP22_2.G.t5 12.3725
R1640 GROUP22_2.G.n5 GROUP22_2.G.t4 12.3725
R1641 GROUP22_2.G.n35 GROUP22_2.G.t3 12.3725
R1642 GROUP22_2.G.n34 GROUP22_2.G.t2 12.3725
R1643 GROUP22_2.G.n33 GROUP22_2.G.t1 12.3725
R1644 GROUP22_2.G.n21 GROUP22_2.G.t13 12.3719
R1645 GROUP22_2.G.n30 GROUP22_2.G.t0 12.3719
R1646 GROUP22_2.G.n6 GROUP22_2.G.n38 9.0005
R1647 GROUP22_2.G.n0 GROUP22_2.G.n19 9.0005
R1648 GROUP22_2.G.n26 GROUP22_2.G.n2 9.0005
R1649 GROUP22_2.G.n25 GROUP22_2.G.n24 9.0005
R1650 GROUP22_2.G.n23 GROUP22_2.G.n20 9.0005
R1651 GROUP22_2.G.n22 GROUP22_2.G.n21 9.0005
R1652 GROUP22_2.G.n22 GROUP22_2.G 9.0005
R1653 GROUP22_2.G.n23 GROUP22_2.G 9.0005
R1654 GROUP22_2.G.n24 GROUP22_2.G.n3 0.387234
R1655 GROUP22_2.G.n31 GROUP22_2.G.n30 9.0005
R1656 GROUP22_2.G.n33 GROUP22_2.G.n32 9.0005
R1657 GROUP22_2.G.n34 GROUP22_2.G.n29 9.0005
R1658 GROUP22_2.G.n36 GROUP22_2.G.n35 9.0005
R1659 GROUP22_2.G.n37 GROUP22_2.G.n5 9.0005
R1660 GROUP22_2.G.n31 GROUP22_2.G 9.0005
R1661 GROUP22_2.G.n32 GROUP22_2.G 9.0005
R1662 GROUP22_2.G.n4 GROUP22_2.G.n29 9.0005
R1663 GROUP22_2.G.n36 GROUP22_2.G.n28 9.0005
R1664 GROUP22_2.G.t9 GROUP22_2.G.n13 2.80929
R1665 GROUP22_2.G.t8 GROUP22_2.G.n12 2.81267
R1666 GROUP22_2.G.t12 GROUP22_2.G.n11 2.80929
R1667 GROUP22_2.G.n11 GROUP22_2.G.n10 0.0397382
R1668 GROUP22_2.G.t11 GROUP22_2.G.n10 2.81267
R1669 GROUP22_2.G.n17 GROUP22_2.G.t20 7.36589
R1670 GROUP22_2.G.n0 GROUP22_2.G.n1 0.447853
R1671 GROUP22_2.G.n9 GROUP22_2.G.n6 4.70638
R1672 GROUP22_2.G.n38 GROUP22_2.G.t6 3.37375
R1673 GROUP22_2.G.n19 GROUP22_2.G.t19 3.37187
R1674 GROUP22_2.G.n15 GROUP22_2.G.n16 0.395384
R1675 GROUP22_2.G.n18 GROUP22_2.G.n17 2.64186
R1676 GROUP22_2.G.n8 GROUP22_2.G.n7 0.358942
R1677 GROUP22_2.G.n18 GROUP22_2.G.n16 0.989254
R1678 GROUP22_2.G.n39 GROUP22_2.G.n0 1.54539
R1679 GROUP22_2.G.n0 GROUP22_2.G.n6 1.02228
R1680 GROUP22_2.G GROUP22_2.G.n14 1.40059
R1681 GROUP22_2.G.n17 GROUP22_2.G 0.798426
R1682 GROUP22_2.G.n9 GROUP22_2.G.n37 0.47868
R1683 GROUP22_2.G GROUP22_2.G.n16 0.282579
R1684 GROUP22_2.G.n8 GROUP22_2.G 0.612892
R1685 GROUP22_2.G.n38 GROUP22_2.G.n12 0.653499
R1686 GROUP22_2.G.n19 GROUP22_2.G.n10 0.653499
R1687 GROUP22_2.G.n21 GROUP22_2.G.n20 0.534569
R1688 GROUP22_2.G.n25 GROUP22_2.G.n20 0.534569
R1689 GROUP22_2.G.n26 GROUP22_2.G.n25 0.534569
R1690 GROUP22_2.G.n27 GROUP22_2.G.n26 0.534569
R1691 GROUP22_2.G.n23 GROUP22_2.G.n22 0.534569
R1692 GROUP22_2.G.n24 GROUP22_2.G.n23 0.534569
R1693 GROUP22_2.G.n3 GROUP22_2.G.n2 0.125915
R1694 GROUP22_2.G GROUP22_2.G.n3 3.17418
R1695 GROUP22_2.G.n33 GROUP22_2.G.n30 0.534569
R1696 GROUP22_2.G.n34 GROUP22_2.G.n33 0.534569
R1697 GROUP22_2.G.n35 GROUP22_2.G.n34 0.534569
R1698 GROUP22_2.G.n35 GROUP22_2.G.n5 0.534569
R1699 GROUP22_2.G.n32 GROUP22_2.G.n31 0.534569
R1700 GROUP22_2.G.n32 GROUP22_2.G.n29 0.534569
R1701 GROUP22_2.G.n36 GROUP22_2.G.n29 0.534569
R1702 GROUP22_2.G.n37 GROUP22_2.G.n36 0.534569
R1703 GROUP22_2.G.n4 GROUP22_2.G.n28 0.534569
R1704 GROUP22_2.G.n28 GROUP22_2.G.n9 3.59225
R1705 GROUP22_2.G.n27 GROUP22_2.G.n1 0.855606
R1706 GROUP22_2.G GROUP22_2.G.n4 1.06864
R1707 GROUP22_2.G.n6 GROUP22_2.G.n5 1.04862
R1708 GROUP22_2.G.n1 GROUP22_2.G.n2 3.73563
R1709 GROUP22_3.G.n39 GROUP22_3.G.n7 18.0594
R1710 GROUP22_3.G.n0 GROUP22_3.G.n15 17.7473
R1711 GROUP22_3.G.t14 GROUP22_3.G.n13 7.53302
R1712 GROUP22_3.G.n18 GROUP22_3.G.t24 15.0033
R1713 GROUP22_3.G.n12 GROUP22_3.G.n13 0.0397382
R1714 GROUP22_3.G.t21 GROUP22_3.G.n14 7.09562
R1715 GROUP22_3.G.n8 GROUP22_3.G.t23 7.42005
R1716 GROUP22_3.G.n7 GROUP22_3.G.t22 7.69815
R1717 GROUP22_3.G.n11 GROUP22_3.G.t17 7.53302
R1718 GROUP22_3.G.t24 GROUP22_3.G.n15 15.0005
R1719 GROUP22_3.G.n14 GROUP22_3.G.n39 15.9045
R1720 GROUP22_3.G.n0 GROUP22_3.G.t12 12.3725
R1721 GROUP22_3.G.n27 GROUP22_3.G.t11 12.3725
R1722 GROUP22_3.G.n26 GROUP22_3.G.t10 12.3725
R1723 GROUP22_3.G.n25 GROUP22_3.G.t9 12.3725
R1724 GROUP22_3.G.n20 GROUP22_3.G.t8 12.3725
R1725 GROUP22_3.G.n6 GROUP22_3.G.t5 12.3725
R1726 GROUP22_3.G.n5 GROUP22_3.G.t4 12.3725
R1727 GROUP22_3.G.n35 GROUP22_3.G.t3 12.3725
R1728 GROUP22_3.G.n34 GROUP22_3.G.t2 12.3725
R1729 GROUP22_3.G.n33 GROUP22_3.G.t1 12.3725
R1730 GROUP22_3.G.n21 GROUP22_3.G.t7 12.3719
R1731 GROUP22_3.G.n30 GROUP22_3.G.t0 12.3719
R1732 GROUP22_3.G.n6 GROUP22_3.G.n38 9.0005
R1733 GROUP22_3.G.n0 GROUP22_3.G.n19 9.0005
R1734 GROUP22_3.G.n26 GROUP22_3.G.n2 9.0005
R1735 GROUP22_3.G.n25 GROUP22_3.G.n24 9.0005
R1736 GROUP22_3.G.n23 GROUP22_3.G.n20 9.0005
R1737 GROUP22_3.G.n22 GROUP22_3.G.n21 9.0005
R1738 GROUP22_3.G.n22 GROUP22_3.G 9.0005
R1739 GROUP22_3.G.n23 GROUP22_3.G 9.0005
R1740 GROUP22_3.G.n24 GROUP22_3.G.n3 0.387234
R1741 GROUP22_3.G.n31 GROUP22_3.G.n30 9.0005
R1742 GROUP22_3.G.n33 GROUP22_3.G.n32 9.0005
R1743 GROUP22_3.G.n34 GROUP22_3.G.n29 9.0005
R1744 GROUP22_3.G.n36 GROUP22_3.G.n35 9.0005
R1745 GROUP22_3.G.n37 GROUP22_3.G.n5 9.0005
R1746 GROUP22_3.G.n31 GROUP22_3.G 9.0005
R1747 GROUP22_3.G.n32 GROUP22_3.G 9.0005
R1748 GROUP22_3.G.n4 GROUP22_3.G.n29 9.0005
R1749 GROUP22_3.G.n36 GROUP22_3.G.n28 9.0005
R1750 GROUP22_3.G.t16 GROUP22_3.G.n13 2.80929
R1751 GROUP22_3.G.t15 GROUP22_3.G.n12 2.81267
R1752 GROUP22_3.G.t19 GROUP22_3.G.n11 2.80929
R1753 GROUP22_3.G.n11 GROUP22_3.G.n10 0.0397382
R1754 GROUP22_3.G.t18 GROUP22_3.G.n10 2.81267
R1755 GROUP22_3.G.n17 GROUP22_3.G.t20 7.36589
R1756 GROUP22_3.G.n0 GROUP22_3.G.n1 0.447853
R1757 GROUP22_3.G.n9 GROUP22_3.G.n6 4.70638
R1758 GROUP22_3.G.n38 GROUP22_3.G.t6 3.37375
R1759 GROUP22_3.G.n19 GROUP22_3.G.t13 3.37187
R1760 GROUP22_3.G.n15 GROUP22_3.G.n16 0.395384
R1761 GROUP22_3.G.n18 GROUP22_3.G.n17 2.64186
R1762 GROUP22_3.G.n8 GROUP22_3.G.n7 0.358942
R1763 GROUP22_3.G.n18 GROUP22_3.G.n16 0.989254
R1764 GROUP22_3.G.n39 GROUP22_3.G.n0 1.54539
R1765 GROUP22_3.G.n0 GROUP22_3.G.n6 1.02228
R1766 GROUP22_3.G GROUP22_3.G.n14 1.40059
R1767 GROUP22_3.G.n17 GROUP22_3.G 0.798426
R1768 GROUP22_3.G.n9 GROUP22_3.G.n37 0.47868
R1769 GROUP22_3.G GROUP22_3.G.n16 0.282579
R1770 GROUP22_3.G.n8 GROUP22_3.G 0.612892
R1771 GROUP22_3.G.n38 GROUP22_3.G.n12 0.653499
R1772 GROUP22_3.G.n19 GROUP22_3.G.n10 0.653499
R1773 GROUP22_3.G.n21 GROUP22_3.G.n20 0.534569
R1774 GROUP22_3.G.n25 GROUP22_3.G.n20 0.534569
R1775 GROUP22_3.G.n26 GROUP22_3.G.n25 0.534569
R1776 GROUP22_3.G.n27 GROUP22_3.G.n26 0.534569
R1777 GROUP22_3.G.n23 GROUP22_3.G.n22 0.534569
R1778 GROUP22_3.G.n24 GROUP22_3.G.n23 0.534569
R1779 GROUP22_3.G.n3 GROUP22_3.G.n2 0.125915
R1780 GROUP22_3.G GROUP22_3.G.n3 3.17418
R1781 GROUP22_3.G.n33 GROUP22_3.G.n30 0.534569
R1782 GROUP22_3.G.n34 GROUP22_3.G.n33 0.534569
R1783 GROUP22_3.G.n35 GROUP22_3.G.n34 0.534569
R1784 GROUP22_3.G.n35 GROUP22_3.G.n5 0.534569
R1785 GROUP22_3.G.n32 GROUP22_3.G.n31 0.534569
R1786 GROUP22_3.G.n32 GROUP22_3.G.n29 0.534569
R1787 GROUP22_3.G.n36 GROUP22_3.G.n29 0.534569
R1788 GROUP22_3.G.n37 GROUP22_3.G.n36 0.534569
R1789 GROUP22_3.G.n4 GROUP22_3.G.n28 0.534569
R1790 GROUP22_3.G.n28 GROUP22_3.G.n9 3.59225
R1791 GROUP22_3.G.n27 GROUP22_3.G.n1 0.855606
R1792 GROUP22_3.G GROUP22_3.G.n4 1.06864
R1793 GROUP22_3.G.n6 GROUP22_3.G.n5 1.04862
R1794 GROUP22_3.G.n1 GROUP22_3.G.n2 3.73563
R1795 GROUP22_0.G.n39 GROUP22_0.G.n7 18.0594
R1796 GROUP22_0.G.n0 GROUP22_0.G.n15 17.7473
R1797 GROUP22_0.G.t14 GROUP22_0.G.n13 7.53302
R1798 GROUP22_0.G.n18 GROUP22_0.G.t24 15.0033
R1799 GROUP22_0.G.n12 GROUP22_0.G.n13 0.0397382
R1800 GROUP22_0.G.t21 GROUP22_0.G.n14 7.09562
R1801 GROUP22_0.G.n8 GROUP22_0.G.t23 7.42005
R1802 GROUP22_0.G.n7 GROUP22_0.G.t22 7.69815
R1803 GROUP22_0.G.n11 GROUP22_0.G.t17 7.53302
R1804 GROUP22_0.G.t24 GROUP22_0.G.n15 15.0005
R1805 GROUP22_0.G.n14 GROUP22_0.G.n39 15.9045
R1806 GROUP22_0.G.n0 GROUP22_0.G.t12 12.3725
R1807 GROUP22_0.G.n27 GROUP22_0.G.t11 12.3725
R1808 GROUP22_0.G.n26 GROUP22_0.G.t10 12.3725
R1809 GROUP22_0.G.n25 GROUP22_0.G.t9 12.3725
R1810 GROUP22_0.G.n20 GROUP22_0.G.t8 12.3725
R1811 GROUP22_0.G.n6 GROUP22_0.G.t5 12.3725
R1812 GROUP22_0.G.n5 GROUP22_0.G.t4 12.3725
R1813 GROUP22_0.G.n35 GROUP22_0.G.t3 12.3725
R1814 GROUP22_0.G.n34 GROUP22_0.G.t2 12.3725
R1815 GROUP22_0.G.n33 GROUP22_0.G.t1 12.3725
R1816 GROUP22_0.G.n21 GROUP22_0.G.t7 12.3719
R1817 GROUP22_0.G.n30 GROUP22_0.G.t0 12.3719
R1818 GROUP22_0.G.n6 GROUP22_0.G.n38 9.0005
R1819 GROUP22_0.G.n0 GROUP22_0.G.n19 9.0005
R1820 GROUP22_0.G.n26 GROUP22_0.G.n2 9.0005
R1821 GROUP22_0.G.n25 GROUP22_0.G.n24 9.0005
R1822 GROUP22_0.G.n23 GROUP22_0.G.n20 9.0005
R1823 GROUP22_0.G.n22 GROUP22_0.G.n21 9.0005
R1824 GROUP22_0.G.n22 GROUP22_0.G 9.0005
R1825 GROUP22_0.G.n23 GROUP22_0.G 9.0005
R1826 GROUP22_0.G.n24 GROUP22_0.G.n3 0.387234
R1827 GROUP22_0.G.n31 GROUP22_0.G.n30 9.0005
R1828 GROUP22_0.G.n33 GROUP22_0.G.n32 9.0005
R1829 GROUP22_0.G.n34 GROUP22_0.G.n29 9.0005
R1830 GROUP22_0.G.n36 GROUP22_0.G.n35 9.0005
R1831 GROUP22_0.G.n37 GROUP22_0.G.n5 9.0005
R1832 GROUP22_0.G.n31 GROUP22_0.G 9.0005
R1833 GROUP22_0.G.n32 GROUP22_0.G 9.0005
R1834 GROUP22_0.G.n4 GROUP22_0.G.n29 9.0005
R1835 GROUP22_0.G.n36 GROUP22_0.G.n28 9.0005
R1836 GROUP22_0.G.t16 GROUP22_0.G.n13 2.80929
R1837 GROUP22_0.G.t15 GROUP22_0.G.n12 2.81267
R1838 GROUP22_0.G.t19 GROUP22_0.G.n11 2.80929
R1839 GROUP22_0.G.n11 GROUP22_0.G.n10 0.0397382
R1840 GROUP22_0.G.t18 GROUP22_0.G.n10 2.81267
R1841 GROUP22_0.G.n17 GROUP22_0.G.t20 7.36589
R1842 GROUP22_0.G.n0 GROUP22_0.G.n1 0.447853
R1843 GROUP22_0.G.n9 GROUP22_0.G.n6 4.70638
R1844 GROUP22_0.G.n38 GROUP22_0.G.t6 3.37375
R1845 GROUP22_0.G.n19 GROUP22_0.G.t13 3.37187
R1846 GROUP22_0.G.n15 GROUP22_0.G.n16 0.395384
R1847 GROUP22_0.G.n18 GROUP22_0.G.n17 2.64186
R1848 GROUP22_0.G.n8 GROUP22_0.G.n7 0.358942
R1849 GROUP22_0.G.n18 GROUP22_0.G.n16 0.989254
R1850 GROUP22_0.G.n39 GROUP22_0.G.n0 1.54539
R1851 GROUP22_0.G.n0 GROUP22_0.G.n6 1.02228
R1852 GROUP22_0.G GROUP22_0.G.n14 1.40059
R1853 GROUP22_0.G.n17 GROUP22_0.G 0.798426
R1854 GROUP22_0.G.n9 GROUP22_0.G.n37 0.47868
R1855 GROUP22_0.G GROUP22_0.G.n16 0.282579
R1856 GROUP22_0.G.n8 GROUP22_0.G 0.612892
R1857 GROUP22_0.G.n38 GROUP22_0.G.n12 0.653499
R1858 GROUP22_0.G.n19 GROUP22_0.G.n10 0.653499
R1859 GROUP22_0.G.n21 GROUP22_0.G.n20 0.534569
R1860 GROUP22_0.G.n25 GROUP22_0.G.n20 0.534569
R1861 GROUP22_0.G.n26 GROUP22_0.G.n25 0.534569
R1862 GROUP22_0.G.n27 GROUP22_0.G.n26 0.534569
R1863 GROUP22_0.G.n23 GROUP22_0.G.n22 0.534569
R1864 GROUP22_0.G.n24 GROUP22_0.G.n23 0.534569
R1865 GROUP22_0.G.n3 GROUP22_0.G.n2 0.125915
R1866 GROUP22_0.G GROUP22_0.G.n3 3.17418
R1867 GROUP22_0.G.n33 GROUP22_0.G.n30 0.534569
R1868 GROUP22_0.G.n34 GROUP22_0.G.n33 0.534569
R1869 GROUP22_0.G.n35 GROUP22_0.G.n34 0.534569
R1870 GROUP22_0.G.n35 GROUP22_0.G.n5 0.534569
R1871 GROUP22_0.G.n32 GROUP22_0.G.n31 0.534569
R1872 GROUP22_0.G.n32 GROUP22_0.G.n29 0.534569
R1873 GROUP22_0.G.n36 GROUP22_0.G.n29 0.534569
R1874 GROUP22_0.G.n37 GROUP22_0.G.n36 0.534569
R1875 GROUP22_0.G.n4 GROUP22_0.G.n28 0.534569
R1876 GROUP22_0.G.n28 GROUP22_0.G.n9 3.59225
R1877 GROUP22_0.G.n27 GROUP22_0.G.n1 0.855606
R1878 GROUP22_0.G GROUP22_0.G.n4 1.06864
R1879 GROUP22_0.G.n6 GROUP22_0.G.n5 1.04862
R1880 GROUP22_0.G.n1 GROUP22_0.G.n2 3.73563
R1881 GROUP22_1.G.n39 GROUP22_1.G.n7 18.0594
R1882 GROUP22_1.G.n0 GROUP22_1.G.n15 17.7473
R1883 GROUP22_1.G.t0 GROUP22_1.G.n13 7.53302
R1884 GROUP22_1.G.n18 GROUP22_1.G.t24 15.0033
R1885 GROUP22_1.G.n12 GROUP22_1.G.n13 0.0397382
R1886 GROUP22_1.G.t21 GROUP22_1.G.n14 7.09562
R1887 GROUP22_1.G.n8 GROUP22_1.G.t23 7.42005
R1888 GROUP22_1.G.n7 GROUP22_1.G.t22 7.69815
R1889 GROUP22_1.G.n11 GROUP22_1.G.t3 7.53302
R1890 GROUP22_1.G.t24 GROUP22_1.G.n15 15.0005
R1891 GROUP22_1.G.n14 GROUP22_1.G.n39 15.9045
R1892 GROUP22_1.G.n0 GROUP22_1.G.t18 12.3725
R1893 GROUP22_1.G.n27 GROUP22_1.G.t17 12.3725
R1894 GROUP22_1.G.n26 GROUP22_1.G.t16 12.3725
R1895 GROUP22_1.G.n25 GROUP22_1.G.t15 12.3725
R1896 GROUP22_1.G.n20 GROUP22_1.G.t14 12.3725
R1897 GROUP22_1.G.n6 GROUP22_1.G.t11 12.3725
R1898 GROUP22_1.G.n5 GROUP22_1.G.t10 12.3725
R1899 GROUP22_1.G.n35 GROUP22_1.G.t9 12.3725
R1900 GROUP22_1.G.n34 GROUP22_1.G.t8 12.3725
R1901 GROUP22_1.G.n33 GROUP22_1.G.t7 12.3725
R1902 GROUP22_1.G.n21 GROUP22_1.G.t13 12.3719
R1903 GROUP22_1.G.n30 GROUP22_1.G.t6 12.3719
R1904 GROUP22_1.G.n6 GROUP22_1.G.n38 9.0005
R1905 GROUP22_1.G.n0 GROUP22_1.G.n19 9.0005
R1906 GROUP22_1.G.n26 GROUP22_1.G.n2 9.0005
R1907 GROUP22_1.G.n25 GROUP22_1.G.n24 9.0005
R1908 GROUP22_1.G.n23 GROUP22_1.G.n20 9.0005
R1909 GROUP22_1.G.n22 GROUP22_1.G.n21 9.0005
R1910 GROUP22_1.G.n22 GROUP22_1.G 9.0005
R1911 GROUP22_1.G.n23 GROUP22_1.G 9.0005
R1912 GROUP22_1.G.n24 GROUP22_1.G.n3 0.387234
R1913 GROUP22_1.G.n31 GROUP22_1.G.n30 9.0005
R1914 GROUP22_1.G.n33 GROUP22_1.G.n32 9.0005
R1915 GROUP22_1.G.n34 GROUP22_1.G.n29 9.0005
R1916 GROUP22_1.G.n36 GROUP22_1.G.n35 9.0005
R1917 GROUP22_1.G.n37 GROUP22_1.G.n5 9.0005
R1918 GROUP22_1.G.n31 GROUP22_1.G 9.0005
R1919 GROUP22_1.G.n32 GROUP22_1.G 9.0005
R1920 GROUP22_1.G.n4 GROUP22_1.G.n29 9.0005
R1921 GROUP22_1.G.n36 GROUP22_1.G.n28 9.0005
R1922 GROUP22_1.G.t2 GROUP22_1.G.n13 2.80929
R1923 GROUP22_1.G.t1 GROUP22_1.G.n12 2.81267
R1924 GROUP22_1.G.t5 GROUP22_1.G.n11 2.80929
R1925 GROUP22_1.G.n11 GROUP22_1.G.n10 0.0397382
R1926 GROUP22_1.G.t4 GROUP22_1.G.n10 2.81267
R1927 GROUP22_1.G.n17 GROUP22_1.G.t20 7.36589
R1928 GROUP22_1.G.n0 GROUP22_1.G.n1 0.447853
R1929 GROUP22_1.G.n9 GROUP22_1.G.n6 4.70638
R1930 GROUP22_1.G.n38 GROUP22_1.G.t12 3.37375
R1931 GROUP22_1.G.n19 GROUP22_1.G.t19 3.37187
R1932 GROUP22_1.G.n15 GROUP22_1.G.n16 0.395384
R1933 GROUP22_1.G.n18 GROUP22_1.G.n17 2.64186
R1934 GROUP22_1.G.n8 GROUP22_1.G.n7 0.358942
R1935 GROUP22_1.G.n18 GROUP22_1.G.n16 0.989254
R1936 GROUP22_1.G.n39 GROUP22_1.G.n0 1.54539
R1937 GROUP22_1.G.n0 GROUP22_1.G.n6 1.02228
R1938 GROUP22_1.G GROUP22_1.G.n14 1.40059
R1939 GROUP22_1.G.n17 GROUP22_1.G 0.798426
R1940 GROUP22_1.G.n9 GROUP22_1.G.n37 0.47868
R1941 GROUP22_1.G GROUP22_1.G.n16 0.282579
R1942 GROUP22_1.G.n8 GROUP22_1.G 0.612892
R1943 GROUP22_1.G.n38 GROUP22_1.G.n12 0.653499
R1944 GROUP22_1.G.n19 GROUP22_1.G.n10 0.653499
R1945 GROUP22_1.G.n21 GROUP22_1.G.n20 0.534569
R1946 GROUP22_1.G.n25 GROUP22_1.G.n20 0.534569
R1947 GROUP22_1.G.n26 GROUP22_1.G.n25 0.534569
R1948 GROUP22_1.G.n27 GROUP22_1.G.n26 0.534569
R1949 GROUP22_1.G.n23 GROUP22_1.G.n22 0.534569
R1950 GROUP22_1.G.n24 GROUP22_1.G.n23 0.534569
R1951 GROUP22_1.G.n3 GROUP22_1.G.n2 0.125915
R1952 GROUP22_1.G GROUP22_1.G.n3 3.17418
R1953 GROUP22_1.G.n33 GROUP22_1.G.n30 0.534569
R1954 GROUP22_1.G.n34 GROUP22_1.G.n33 0.534569
R1955 GROUP22_1.G.n35 GROUP22_1.G.n34 0.534569
R1956 GROUP22_1.G.n35 GROUP22_1.G.n5 0.534569
R1957 GROUP22_1.G.n32 GROUP22_1.G.n31 0.534569
R1958 GROUP22_1.G.n32 GROUP22_1.G.n29 0.534569
R1959 GROUP22_1.G.n36 GROUP22_1.G.n29 0.534569
R1960 GROUP22_1.G.n37 GROUP22_1.G.n36 0.534569
R1961 GROUP22_1.G.n4 GROUP22_1.G.n28 0.534569
R1962 GROUP22_1.G.n28 GROUP22_1.G.n9 3.59225
R1963 GROUP22_1.G.n27 GROUP22_1.G.n1 0.855606
R1964 GROUP22_1.G GROUP22_1.G.n4 1.06864
R1965 GROUP22_1.G.n6 GROUP22_1.G.n5 1.04862
R1966 GROUP22_1.G.n1 GROUP22_1.G.n2 3.73563
C0 VDDL a_3081_1674# 0.37565f
C1 a_16647_5524# GROUP10_0.pmosHV$1_priv4_0.D 0.03816f
C2 a_11703_6246# GROUP10_0.pmosHV$1_priv4_0.D 0.10908f
C3 GROUP12_3.nmosHV_priv10_0.S a_22675_6246# 0.10908f
C4 GROUP13_1.pmosHV$2_priv1_0.D VDDL 1.55536f
C5 a_34890_5524# GROUP19_2.G 0.11294f
C6 VDDL GROUP22_3.G 0.52793f
C7 GROUP12_1.nmosHV_priv10_0.S a_1819_6246# 0.04313f
C8 vref_4 GROUP10_2.pmosHV$1_priv4_0.S 2.25994f
C9 a_34889_950# a_34890_1674# 0.01042f
C10 clk_h a_14718_6684# 0.13177f
C11 a_3081_1674# q0 0.29089f
C12 GROUP6_0.pmosHV_priv16_0.S GROUP22_0.G 2.20239f
C13 GROUP12_1.nmosHV_priv10_0.S GROUP16_1.G 1.30224f
C14 VDD GROUP20_1.G 0.81002f
C15 GROUP8_3.nmosHV_priv1_0.S GROUP22_3.nmosHV_priv28_0.D 0.29318f
C16 GROUP8_2.nmosHV_priv1_0.S a_40784_4724# 0.30815f
C17 a_26041_1674# VDDL 0.37987f
C18 GROUP6_2.pmosHV_priv16_0.S a_41149_4724# 0.33002f
C19 a_3990_6684# clk_h 0.13177f
C20 a_13809_4924# q1 0.04124f
C21 GROUP6_3.pmosHV_priv16_0.S VDD 3.05694f
C22 q3 VDDL 2.17312f
C23 VDDL a_37044_4924# 0.3891f
C24 VDD GROUP10_3.pmosHV$1_priv4_0.S 1.55016f
C25 a_975_6246# GROUP22_1.G 0.0384f
C26 GROUP14_2.pmosHV$2_priv4_0.S GROUP20_2.G 1.8762f
C27 GROUP12_1.nmosHV_priv10_0.S a_7179_5324# 0.03987f
C28 GROUP8_3.nmosHV_priv1_0.S a_28879_5324# 0.17614f
C29 a_16647_1674# GROUP10_0.pmosHV$1_priv4_0.D 0.11078f
C30 a_41983_3200# GROUP22_2.G 0.04187f
C31 a_15068_4924# VDDL 0.3891f
C32 a_27991_6684# GROUP22_3.G 0.17996f
C33 a_2185_950# GROUP20_1.G 0.0389f
C34 GROUP16_1.pmosHV$2_priv10_0.D GROUP16_1.G 1.88074f
C35 a_8445_4724# VDD 0.4548f
C36 GROUP8_3.nmosHV_priv1_0.S a_28931_4000# 0.10967f
C37 q3 GROUP19_2.G 6.6419f
C38 GROUP12_1.nmosHV_priv10_0.S GROUP15_0.pmosHV$2_priv7_0.D 1.88235f
C39 VDDL a_26040_4924# 0.3891f
C40 GROUP10_1.pmosHV$1_priv4_0.S GROUP22_1.G 1.21908f
C41 a_4341_1674# GROUP20_1.G 0.04145f
C42 a_38995_6684# GROUP22_2.G 0.17996f
C43 GROUP20_1.G a_6814_5324# 0.1654f
C44 GROUP10_2.pmosHV$1_priv4_0.D vin 0.23196f
C45 a_15433_4924# GROUP10_0.pmosHV$1_priv4_0.D 0.04169f
C46 GROUP12_3.nmosHV_priv10_0.S vin 0.23135f
C47 q2 GROUP15_2.pmosHV$2_priv7_0.D 1.87806f
C48 GROUP16_0.pmosHV$2_priv10_0.D q1 0.42301f
C49 a_39883_5324# GROUP10_2.pmosHV$1_priv4_0.D 0.03987f
C50 GROUP8_2.nmosHV_priv1_0.S VDD 1.06001f
C51 GROUP16_0.pmosHV$2_priv10_0.D GROUP20_0.G 1.8762f
C52 a_15434_1674# GROUP20_0.G 0.04129f
C53 a_22680_950# GROUP22_3.G 0.038f
C54 GROUP10_2.pmosHV$1_priv4_0.D GROUP10_2.pmosHV$1_priv4_0.S 0.17341f
C55 clk_h GROUP22_3.G 7.05053f
C56 a_12547_6246# GROUP10_0.pmosHV$1_priv4_0.D 0.04313f
C57 VDDL a_35785_4924# 0.37565f
C58 a_14174_4924# q1 0.04108f
C59 VDD GROUP22_0.G 7.13764f
C60 a_6814_1676# GROUP12_1.nmosHV_priv10_0.S 0.16968f
C61 a_28566_4000# GROUP22_3.G 0.04194f
C62 a_28514_5324# VDD 0.20577f
C63 a_29780_4724# vin 0.0619f
C64 a_38991_7670# GROUP22_2.G 0.17776f
C65 vref_2 GROUP20_0.G 0.23627f
C66 a_17907_1676# VDD 0.20554f
C67 GROUP19_0.G a_12914_5524# 0.11294f
C68 VDD GROUP20_2.G 0.84565f
C69 GROUP8_1.nmosHV_priv1_0.S a_18808_4724# 0.30815f
C70 GROUP22_1.G GROUP8_0.nmosHV_priv1_0.S 1.46935f
C71 GROUP16_1.G a_2184_6246# 0.11641f
C72 a_17959_4000# GROUP22_0.G 0.04346f
C73 a_12549_1674# a_12548_950# 0.01042f
C74 GROUP13_3.pmosHV$2_priv1_0.D GROUP22_2.G 0.11141f
C75 vref_1 a_8445_1676# 0.04159f
C76 GROUP19_2.G a_35785_4924# 0.26793f
C77 GROUP6_0.pmosHV_priv16_0.S a_19173_4724# 0.33002f
C78 a_17959_3198# GROUP22_0.G 0.04064f
C79 a_25146_1674# q2 0.01557f
C80 vin GROUP22_1.G 0.48447f
C81 GROUP20_0.G VDD 0.84632f
C82 GROUP6_2.pmosHV_priv16_0.S a_41149_1676# 0.29522f
C83 clk_h a_36690_7670# 0.11706f
C84 a_23521_1674# a_23520_950# 0.01042f
C85 vin GROUP8_1.nmosHV_priv1_0.S 2.09171f
C86 a_33684_950# GROUP20_2.G 0.11639f
C87 q3 a_34890_5524# 0.038f
C88 VDD GROUP22_3.nmosHV_priv28_0.D 0.8457f
C89 GROUP15_0.pmosHV$2_priv7_0.D a_3446_4924# 0.2681f
C90 VDDL a_4706_1674# 0.63505f
C91 VDDL a_3081_4924# 0.37565f
C92 VDDL GROUP8_0.nmosHV_priv1_0.S 0.04221f
C93 a_34524_950# a_34525_1674# 0.01042f
C94 a_36694_6684# VDD 0.20583f
C95 a_25690_6684# VDD 0.20583f
C96 GROUP20_0.G a_12548_950# 0.03884f
C97 GROUP12_1.nmosHV_priv10_0.S VDD 0.86188f
C98 a_30979_3200# GROUP22_3.G 0.04187f
C99 a_39518_1676# GROUP20_2.G 0.03974f
C100 VDDL vin 3.70851f
C101 a_13809_1674# GROUP19_0.G 0.04177f
C102 VDDL a_35785_1674# 0.37565f
C103 a_41149_4724# vin 0.04159f
C104 a_3081_4924# q0 0.04124f
C105 vref_4 GROUP20_2.G 0.23502f
C106 q2 a_25146_4924# 0.04108f
C107 a_23884_6246# a_23886_5524# 0.01035f
C108 VDD a_9279_3200# 0.4513f
C109 vref_3 a_30145_1676# 0.04159f
C110 a_34524_950# GROUP20_2.G 0.03884f
C111 GROUP14_2.pmosHV$2_priv4_0.S a_36150_1674# 0.26836f
C112 a_12549_5524# q1 0.03816f
C113 a_28879_5324# VDD 0.20539f
C114 GROUP12_3.nmosHV_priv10_0.S GROUP10_3.pmosHV$1_priv4_0.S 0.17341f
C115 a_13809_1674# VDDL 0.37565f
C116 a_15069_1674# VDDL 0.37987f
C117 a_15068_4924# GROUP13_1.pmosHV$2_priv1_0.D 0.26717f
C118 GROUP10_1.pmosHV$1_priv4_0.S a_7231_3198# 0.1195f
C119 GROUP10_2.pmosHV$1_priv4_0.D a_38623_1674# 0.11078f
C120 a_40784_4724# GROUP22_2.G 0.01132f
C121 GROUP19_0.G a_12912_6246# 0.11641f
C122 a_35785_1674# GROUP19_2.G 0.04177f
C123 VDD a_3986_7670# 0.04055f
C124 GROUP22_1.G GROUP20_1.G 1.73473f
C125 a_980_950# GROUP20_1.G 0.11639f
C126 a_22675_6246# GROUP22_3.G 0.0384f
C127 GROUP6_1.pmosHV_priv16_0.S VDD 3.05694f
C128 a_2186_1674# GROUP16_1.G 0.038f
C129 a_29780_4724# GROUP6_3.pmosHV_priv16_0.S 0.01476f
C130 VDD a_19173_4724# 0.4548f
C131 a_7231_4000# GROUP22_1.G 0.04346f
C132 GROUP12_1.nmosHV_priv10_0.S a_6814_5324# 0.0397f
C133 GROUP19_3.G a_23886_5524# 0.11294f
C134 GROUP16_3.pmosHV$2_priv10_0.D GROUP22_3.nmosHV_priv28_0.D 1.8762f
C135 a_33679_6246# GROUP22_2.G 0.0384f
C136 GROUP15_0.pmosHV$2_priv7_0.D GROUP16_1.G 0.38265f
C137 a_12914_1674# q1 0.11851f
C138 a_14174_1674# q1 0.01557f
C139 GROUP8_2.nmosHV_priv1_0.S GROUP10_2.pmosHV$1_priv4_0.D 1.4116f
C140 a_24781_1674# GROUP19_3.G 0.04177f
C141 VDD a_29780_1676# 0.52227f
C142 a_28514_1676# GROUP22_3.nmosHV_priv28_0.D 0.03974f
C143 VDDL GROUP20_1.G 2.97675f
C144 GROUP12_3.nmosHV_priv10_0.S a_27619_1674# 0.11078f
C145 a_31344_3200# VDD 0.75802f
C146 VDD a_6287_7670# 0.04038f
C147 a_41983_3200# VDD 0.4513f
C148 VDD GROUP10_0.pmosHV$1_priv4_0.D 0.86323f
C149 GROUP12_3.nmosHV_priv10_0.S a_28514_5324# 0.0397f
C150 a_8080_1676# VDD 0.52227f
C151 q2 a_24781_4924# 0.04124f
C152 vin clk_h 1.26984f
C153 a_38623_5524# GROUP10_2.pmosHV$1_priv4_0.D 0.03816f
C154 q0 GROUP20_1.G 1.281f
C155 GROUP10_2.pmosHV$1_priv4_0.D GROUP20_2.G 5.67299f
C156 GROUP6_3.pmosHV_priv16_0.S a_30145_1676# 0.29522f
C157 a_11343_950# GROUP22_0.G 0.03816f
C158 VDD GROUP22_2.G 7.13255f
C159 VDD a_38995_6684# 0.20583f
C160 q3 a_35785_4924# 0.04124f
C161 GROUP16_1.pmosHV$2_priv10_0.D a_4341_1674# 0.26682f
C162 a_7179_1676# GROUP10_1.pmosHV$1_priv4_0.S 0.16083f
C163 GROUP16_3.pmosHV$2_priv10_0.D q2 0.42301f
C164 GROUP13_3.pmosHV$2_priv1_0.D a_36150_4924# 0.2681f
C165 a_8080_4724# GROUP8_0.nmosHV_priv1_0.S 0.30815f
C166 GROUP10_0.pmosHV$1_priv4_0.S GROUP22_0.G 1.21908f
C167 a_8080_4724# vin 0.06337f
C168 GROUP12_3.nmosHV_priv10_0.S GROUP22_3.nmosHV_priv28_0.D 5.67306f
C169 a_33684_950# GROUP22_2.G 0.038f
C170 a_6866_4000# GROUP22_1.G 0.04194f
C171 a_17907_1676# GROUP10_0.pmosHV$1_priv4_0.S 0.16083f
C172 GROUP19_3.G GROUP22_3.nmosHV_priv28_0.D 1.00529f
C173 vin GROUP22_3.G 0.5834f
C174 VDDL a_3446_1674# 0.37565f
C175 a_23886_1674# q2 0.11851f
C176 GROUP19_0.G GROUP22_0.G 0.21217f
C177 a_38991_7670# VDD 0.04038f
C178 GROUP8_1.nmosHV_priv1_0.S GROUP22_0.G 1.46943f
C179 a_17907_5324# GROUP10_0.pmosHV$1_priv4_0.D 0.03987f
C180 GROUP12_1.nmosHV_priv10_0.S a_5554_5524# 0.03845f
C181 a_38258_1674# GROUP20_2.G 0.0382f
C182 a_12549_1674# GROUP19_0.G 0.03816f
C183 GROUP20_0.G GROUP10_0.pmosHV$1_priv4_0.S 1.47006f
C184 a_24781_1674# VDDL 0.37565f
C185 a_42348_3200# GROUP22_2.G 0.04142f
C186 a_23885_950# GROUP22_3.nmosHV_priv28_0.D 0.0389f
C187 GROUP8_2.nmosHV_priv1_0.S VDDL 0.05189f
C188 a_3446_1674# q0 0.01557f
C189 GROUP6_2.pmosHV_priv16_0.S vin 2.0779f
C190 a_1821_5524# q0 0.03816f
C191 GROUP20_0.G a_17542_5324# 0.1654f
C192 q3 a_34889_950# 0.11526f
C193 GROUP15_2.pmosHV$2_priv7_0.D a_25146_4924# 0.2681f
C194 GROUP12_3.nmosHV_priv10_0.S a_28879_5324# 0.03987f
C195 VDDL GROUP22_0.G 0.49622f
C196 a_2186_5524# a_2184_6246# 0.01035f
C197 GROUP19_0.G q1 6.6419f
C198 GROUP6_2.pmosHV_priv16_0.S GROUP10_2.pmosHV$1_priv4_0.S 0.37529f
C199 VDDL a_37410_1674# 0.63505f
C200 GROUP8_3.nmosHV_priv1_0.S VDD 1.05997f
C201 clk_h GROUP20_1.G 0.01021f
C202 GROUP12_3.nmosHV_priv10_0.S q2 1.18243f
C203 GROUP19_0.G GROUP20_0.G 1.00529f
C204 VDD a_20372_3200# 0.75802f
C205 GROUP20_0.G GROUP8_1.nmosHV_priv1_0.S 0.29318f
C206 GROUP10_2.pmosHV$1_priv4_0.S a_39935_3198# 0.1195f
C207 q3 a_35785_1674# 0.29089f
C208 a_14714_7670# GROUP22_0.G 0.04842f
C209 vref_1 GROUP10_1.pmosHV$1_priv4_0.S 2.23204f
C210 q2 GROUP19_3.G 6.6419f
C211 a_39518_5324# GROUP20_2.G 0.1654f
C212 vref_2 GROUP6_0.pmosHV_priv16_0.S 2.03213f
C213 VDDL GROUP20_2.G 2.9979f
C214 GROUP12_3.nmosHV_priv10_0.S a_27619_5524# 0.03816f
C215 a_34525_1674# GROUP19_2.G 0.03816f
C216 GROUP12_1.nmosHV_priv10_0.S GROUP22_1.G 2.36765f
C217 VDD a_40784_1676# 0.52227f
C218 a_12547_6246# a_12549_5524# 0.01035f
C219 VDDL q1 2.17312f
C220 a_39570_3198# GROUP22_2.G 0.04048f
C221 a_7179_5324# VDD 0.20539f
C222 GROUP22_0.G a_11338_6246# 0.038f
C223 a_37045_1674# GROUP20_2.G 0.04145f
C224 GROUP20_0.G VDDL 3.00585f
C225 q2 a_23885_950# 0.11526f
C226 VDD GROUP6_0.pmosHV_priv16_0.S 3.05694f
C227 VDD a_25686_7670# 0.04055f
C228 VDDL GROUP22_3.nmosHV_priv28_0.D 2.9825f
C229 a_2186_5524# GROUP16_1.G 0.11294f
C230 a_9279_3200# GROUP22_1.G 0.04187f
C231 GROUP22_0.G a_14718_6684# 0.04859f
C232 GROUP19_2.G GROUP20_2.G 1.00529f
C233 GROUP12_1.nmosHV_priv10_0.S a_4340_4924# 0.04153f
C234 a_27254_1674# GROUP22_3.nmosHV_priv28_0.D 0.0382f
C235 GROUP12_1.nmosHV_priv10_0.S VDDL 3.2571f
C236 VDDL a_4705_4924# 0.65692f
C237 GROUP10_1.pmosHV$1_priv4_0.S GROUP8_0.nmosHV_priv1_0.S 0.05104f
C238 a_40784_4724# VDD 0.45527f
C239 a_17542_1676# GROUP20_0.G 0.03974f
C240 a_17019_6684# GROUP22_0.G 0.17996f
C241 GROUP6_3.pmosHV_priv16_0.S GROUP22_3.G 2.20231f
C242 a_3986_7670# GROUP22_1.G 0.04842f
C243 a_615_950# GROUP22_1.G 0.03816f
C244 q2 a_23521_5524# 0.03816f
C245 a_6814_1676# VDD 0.20554f
C246 GROUP12_1.nmosHV_priv10_0.S q0 1.18243f
C247 GROUP10_3.pmosHV$1_priv4_0.S GROUP22_3.G 1.21908f
C248 GROUP6_1.pmosHV_priv16_0.S GROUP22_1.G 2.20239f
C249 vref_4 a_40784_1676# 0.04526f
C250 a_2185_950# a_2186_1674# 0.01042f
C251 a_7179_1676# GROUP20_1.G 0.03991f
C252 GROUP10_2.pmosHV$1_priv4_0.D GROUP22_2.G 2.36765f
C253 GROUP10_2.pmosHV$1_priv4_0.D a_37409_4924# 0.04169f
C254 VDD a_27987_7670# 0.04038f
C255 a_30145_4724# vin 0.04159f
C256 a_28879_1676# GROUP10_3.pmosHV$1_priv4_0.S 0.16083f
C257 a_30979_3200# GROUP6_3.pmosHV_priv16_0.S 0.30958f
C258 VDDL q2 2.17312f
C259 clk_h GROUP22_0.G 7.05349f
C260 GROUP10_0.pmosHV$1_priv4_0.S GROUP10_0.pmosHV$1_priv4_0.D 0.17341f
C261 GROUP12_3.nmosHV_priv10_0.S a_26405_4924# 0.04169f
C262 vref_2 VDD 1.52873f
C263 VDDL GROUP16_1.pmosHV$2_priv10_0.D 1.47311f
C264 a_17542_5324# GROUP10_0.pmosHV$1_priv4_0.D 0.0397f
C265 GROUP20_2.G clk_h 0.01021f
C266 vin a_18808_4724# 0.05953f
C267 GROUP12_3.nmosHV_priv10_0.S a_23519_6246# 0.04313f
C268 GROUP10_2.pmosHV$1_priv4_0.S a_39883_1676# 0.16083f
C269 GROUP22_1.G a_6287_7670# 0.17776f
C270 vin GROUP8_0.nmosHV_priv1_0.S 2.1015f
C271 GROUP19_0.G GROUP10_0.pmosHV$1_priv4_0.D 1.30224f
C272 GROUP8_1.nmosHV_priv1_0.S GROUP10_0.pmosHV$1_priv4_0.D 1.4116f
C273 GROUP20_0.G clk_h 0.01021f
C274 GROUP16_1.pmosHV$2_priv10_0.D q0 0.42301f
C275 GROUP13_1.pmosHV$2_priv1_0.D GROUP22_0.G 0.11141f
C276 a_8445_1676# GROUP6_1.pmosHV_priv16_0.S 0.29522f
C277 VDDL a_3446_4924# 0.37565f
C278 GROUP10_2.pmosHV$1_priv4_0.D GROUP13_3.pmosHV$2_priv1_0.D 1.88235f
C279 a_22680_950# GROUP22_3.nmosHV_priv28_0.D 0.11639f
C280 clk_h GROUP22_3.nmosHV_priv28_0.D 0.01021f
C281 GROUP8_2.nmosHV_priv1_0.S GROUP6_2.pmosHV_priv16_0.S 0.48035f
C282 a_36694_6684# clk_h 0.13177f
C283 GROUP16_3.pmosHV$2_priv10_0.D a_25146_1674# 0.26836f
C284 a_25690_6684# clk_h 0.13177f
C285 GROUP12_3.nmosHV_priv10_0.S GROUP8_3.nmosHV_priv1_0.S 1.4116f
C286 a_26406_1674# VDDL 0.63505f
C287 GROUP10_1.pmosHV$1_priv4_0.S GROUP20_1.G 1.47006f
C288 GROUP12_1.nmosHV_priv10_0.S clk_h 0.04367f
C289 VDDL a_36150_1674# 0.37565f
C290 vref_1 GROUP20_1.G 0.23445f
C291 a_3446_4924# q0 0.04108f
C292 VDDL GROUP10_0.pmosHV$1_priv4_0.D 3.28613f
C293 GROUP13_1.pmosHV$2_priv1_0.D q1 1.87806f
C294 GROUP12_3.nmosHV_priv10_0.S GROUP15_2.pmosHV$2_priv7_0.D 1.88235f
C295 GROUP19_3.G GROUP15_2.pmosHV$2_priv7_0.D 0.38265f
C296 VDDL GROUP22_2.G 0.49736f
C297 VDDL a_37409_4924# 0.65692f
C298 a_12912_6246# a_12914_5524# 0.01035f
C299 VDD a_39518_1676# 0.20554f
C300 a_39570_4000# GROUP22_2.G 0.04194f
C301 VDD a_42348_3200# 0.75802f
C302 GROUP22_3.nmosHV_priv28_0.D GROUP22_3.G 1.73473f
C303 GROUP22_1.G GROUP16_1.G 0.21217f
C304 GROUP8_3.nmosHV_priv1_0.S a_29780_4724# 0.30815f
C305 a_17542_1676# GROUP10_0.pmosHV$1_priv4_0.D 0.16968f
C306 a_23519_6246# a_23521_5524# 0.01035f
C307 a_36150_1674# GROUP19_2.G 0.04108f
C308 a_15433_4924# VDDL 0.65692f
C309 vref_4 VDD 1.52992f
C310 GROUP16_0.pmosHV$2_priv10_0.D a_14174_1674# 0.26836f
C311 a_25690_6684# GROUP22_3.G 0.04859f
C312 VDD a_17907_5324# 0.20539f
C313 GROUP6_3.pmosHV_priv16_0.S a_30145_4724# 0.33002f
C314 q3 GROUP20_2.G 1.281f
C315 a_28879_1676# GROUP22_3.nmosHV_priv28_0.D 0.03991f
C316 VDD a_6814_5324# 0.20577f
C317 VDDL a_26405_4924# 0.65692f
C318 a_4706_1674# GROUP20_1.G 0.04129f
C319 GROUP20_1.G GROUP8_0.nmosHV_priv1_0.S 0.29318f
C320 GROUP19_2.G GROUP22_2.G 0.21217f
C321 clk_h a_3986_7670# 0.11659f
C322 a_16282_5524# GROUP10_0.pmosHV$1_priv4_0.D 0.03845f
C323 a_26041_1674# GROUP22_3.nmosHV_priv28_0.D 0.04145f
C324 a_7231_4000# GROUP8_0.nmosHV_priv1_0.S 0.10967f
C325 a_16282_1674# GROUP20_0.G 0.0382f
C326 VDDL GROUP16_1.G 2.20382f
C327 GROUP6_0.pmosHV_priv16_0.S GROUP10_0.pmosHV$1_priv4_0.S 0.37529f
C328 vref_2 a_18808_1676# 0.04527f
C329 a_25146_1674# GROUP19_3.G 0.04108f
C330 VDDL GROUP13_3.pmosHV$2_priv1_0.D 1.55536f
C331 a_28514_1676# VDD 0.20554f
C332 a_28931_4000# GROUP22_3.G 0.04346f
C333 q2 GROUP22_3.G 0.06942f
C334 a_5919_1674# GROUP20_1.G 0.04107f
C335 a_1820_950# a_1821_1674# 0.01042f
C336 GROUP10_2.pmosHV$1_priv4_0.D a_33679_6246# 0.10908f
C337 q0 GROUP16_1.G 6.6419f
C338 GROUP8_3.nmosHV_priv1_0.S VDDL 0.04518f
C339 GROUP6_3.pmosHV_priv16_0.S vin 2.07794f
C340 a_8080_4724# GROUP6_1.pmosHV_priv16_0.S 0.01476f
C341 a_18808_1676# VDD 0.52227f
C342 a_23521_1674# GROUP19_3.G 0.03816f
C343 GROUP19_0.G a_13809_4924# 0.26793f
C344 GROUP15_0.pmosHV$2_priv7_0.D GROUP22_1.G 0.11141f
C345 GROUP8_1.nmosHV_priv1_0.S GROUP6_0.pmosHV_priv16_0.S 0.48035f
C346 VDDL GROUP15_2.pmosHV$2_priv7_0.D 1.55536f
C347 a_17594_3198# GROUP22_0.G 0.04048f
C348 clk_h GROUP10_0.pmosHV$1_priv4_0.D 0.04368f
C349 vref_3 GROUP6_3.pmosHV_priv16_0.S 2.03213f
C350 GROUP19_2.G GROUP13_3.pmosHV$2_priv1_0.D 0.38265f
C351 a_20007_3200# GROUP22_0.G 0.04187f
C352 vref_3 GROUP10_3.pmosHV$1_priv4_0.S 2.24937f
C353 a_8445_4724# vin 0.04159f
C354 clk_h GROUP22_2.G 7.07091f
C355 a_13809_4924# VDDL 0.37565f
C356 q1 a_12913_950# 0.11526f
C357 GROUP15_0.pmosHV$2_priv7_0.D a_4340_4924# 0.26717f
C358 VDDL GROUP15_0.pmosHV$2_priv7_0.D 1.55536f
C359 GROUP12_1.nmosHV_priv10_0.S a_975_6246# 0.10908f
C360 GROUP10_2.pmosHV$1_priv4_0.D VDD 0.86252f
C361 GROUP12_3.nmosHV_priv10_0.S VDD 0.8626f
C362 GROUP20_0.G a_12913_950# 0.0389f
C363 a_2186_1674# q0 0.11851f
C364 a_18808_4724# GROUP22_0.G 0.0113f
C365 a_31344_3200# GROUP22_3.G 0.04142f
C366 GROUP22_0.G a_17015_7670# 0.17776f
C367 GROUP13_1.pmosHV$2_priv1_0.D GROUP10_0.pmosHV$1_priv4_0.D 1.88235f
C368 a_39883_1676# GROUP20_2.G 0.03991f
C369 GROUP8_2.nmosHV_priv1_0.S vin 2.10779f
C370 vref_2 GROUP10_0.pmosHV$1_priv4_0.S 2.25866f
C371 GROUP16_0.pmosHV$2_priv10_0.D GROUP19_0.G 1.88074f
C372 GROUP8_2.nmosHV_priv1_0.S a_39883_5324# 0.17614f
C373 VDDL GROUP14_2.pmosHV$2_priv4_0.S 1.47311f
C374 GROUP15_0.pmosHV$2_priv7_0.D q0 1.87806f
C375 GROUP12_1.nmosHV_priv10_0.S GROUP10_1.pmosHV$1_priv4_0.S 0.17341f
C376 a_25146_1674# VDDL 0.37565f
C377 GROUP8_2.nmosHV_priv1_0.S GROUP10_2.pmosHV$1_priv4_0.S 0.05104f
C378 vin GROUP22_0.G 0.57295f
C379 VDD a_9644_3200# 0.75802f
C380 a_34889_950# GROUP20_2.G 0.0389f
C381 GROUP14_2.pmosHV$2_priv4_0.S a_37045_1674# 0.26682f
C382 a_12914_5524# q1 0.038f
C383 GROUP6_2.pmosHV_priv16_0.S a_41983_3200# 0.30958f
C384 a_29780_4724# VDD 0.45527f
C385 VDD GROUP10_0.pmosHV$1_priv4_0.S 1.55016f
C386 GROUP16_0.pmosHV$2_priv10_0.D VDDL 1.47311f
C387 a_15434_1674# VDDL 0.63505f
C388 VDDL a_36150_4924# 0.37565f
C389 a_17542_5324# VDD 0.20577f
C390 GROUP10_2.pmosHV$1_priv4_0.D a_39518_1676# 0.16968f
C391 GROUP6_2.pmosHV_priv16_0.S GROUP22_2.G 2.20226f
C392 a_610_6246# GROUP22_1.G 0.038f
C393 q3 a_36150_1674# 0.01557f
C394 GROUP14_2.pmosHV$2_priv4_0.S GROUP19_2.G 1.88074f
C395 VDD GROUP22_1.G 7.12493f
C396 GROUP10_2.pmosHV$1_priv4_0.S GROUP20_2.G 1.47006f
C397 a_39935_3198# GROUP22_2.G 0.04064f
C398 a_14174_4924# VDDL 0.37565f
C399 a_1820_950# GROUP20_1.G 0.03884f
C400 a_3081_1674# GROUP16_1.G 0.04177f
C401 VDD GROUP8_1.nmosHV_priv1_0.S 1.06001f
C402 GROUP10_0.pmosHV$1_priv4_0.S a_17959_3198# 0.1195f
C403 q3 GROUP22_2.G 0.06942f
C404 VDDL a_25146_4924# 0.37565f
C405 GROUP12_1.nmosHV_priv10_0.S GROUP8_0.nmosHV_priv1_0.S 1.4116f
C406 GROUP19_3.G a_24781_4924# 0.26793f
C407 a_6866_3198# GROUP22_1.G 0.04048f
C408 GROUP6_3.pmosHV_priv16_0.S GROUP10_3.pmosHV$1_priv4_0.S 0.37529f
C409 a_36690_7670# GROUP22_2.G 0.04842f
C410 GROUP20_1.G a_5919_5524# 0.11422f
C411 a_15068_4924# GROUP10_0.pmosHV$1_priv4_0.D 0.04153f
C412 GROUP6_1.pmosHV_priv16_0.S GROUP10_1.pmosHV$1_priv4_0.S 0.37529f
C413 a_13809_1674# q1 0.29089f
C414 vref_1 GROUP6_1.pmosHV_priv16_0.S 2.03213f
C415 GROUP12_1.nmosHV_priv10_0.S vin 0.2308f
C416 vref_3 GROUP22_3.nmosHV_priv28_0.D 0.23652f
C417 a_17959_4000# GROUP8_1.nmosHV_priv1_0.S 0.10967f
C418 a_39518_5324# VDD 0.20577f
C419 GROUP16_3.pmosHV$2_priv10_0.D GROUP19_3.G 1.88074f
C420 VDD VDDL 0.65054f
C421 VDD a_30145_1676# 0.51908f
C422 a_15069_1674# GROUP20_0.G 0.04145f
C423 a_22315_950# GROUP22_3.G 0.03816f
C424 clk_h a_25686_7670# 0.11883f
C425 a_41149_4724# VDD 0.4548f
C426 GROUP8_3.nmosHV_priv1_0.S GROUP22_3.G 1.46927f
C427 GROUP12_3.nmosHV_priv10_0.S a_28514_1676# 0.16968f
C428 VDD a_14714_7670# 0.04055f
C429 a_5919_1674# GROUP12_1.nmosHV_priv10_0.S 0.11078f
C430 GROUP15_2.pmosHV$2_priv7_0.D GROUP22_3.G 0.11141f
C431 GROUP12_3.nmosHV_priv10_0.S a_23884_6246# 0.03865f
C432 a_8445_1676# VDD 0.51908f
C433 GROUP19_3.G a_23884_6246# 0.11641f
C434 a_17542_1676# VDD 0.20554f
C435 a_11708_950# GROUP22_0.G 0.038f
C436 a_23886_1674# GROUP19_3.G 0.038f
C437 GROUP8_1.nmosHV_priv1_0.S a_17907_5324# 0.17614f
C438 q3 GROUP13_3.pmosHV$2_priv1_0.D 1.87806f
C439 a_17594_4000# GROUP22_0.G 0.04194f
C440 a_8080_1676# GROUP10_1.pmosHV$1_priv4_0.S 0.29889f
C441 vref_1 a_8080_1676# 0.04526f
C442 GROUP13_3.pmosHV$2_priv1_0.D a_37044_4924# 0.26717f
C443 GROUP6_1.pmosHV_priv16_0.S GROUP8_0.nmosHV_priv1_0.S 0.48035f
C444 VDD a_14718_6684# 0.20583f
C445 a_25686_7670# GROUP22_3.G 0.04842f
C446 GROUP6_1.pmosHV_priv16_0.S vin 2.078f
C447 a_23886_1674# a_23885_950# 0.01042f
C448 q3 a_34525_5524# 0.03816f
C449 a_18808_1676# GROUP10_0.pmosHV$1_priv4_0.S 0.29889f
C450 vin a_19173_4724# 0.04159f
C451 a_34525_5524# a_34523_6246# 0.01035f
C452 VDDL a_4341_1674# 0.37987f
C453 a_27991_6684# VDD 0.20583f
C454 a_17019_6684# VDD 0.20583f
C455 VDDL a_24781_4924# 0.37565f
C456 GROUP20_0.G a_11708_950# 0.11639f
C457 GROUP12_3.nmosHV_priv10_0.S GROUP19_3.G 1.30224f
C458 a_6291_6684# VDD 0.20583f
C459 a_3990_6684# VDD 0.20583f
C460 a_28931_3198# GROUP22_3.G 0.04064f
C461 GROUP12_1.nmosHV_priv10_0.S GROUP20_1.G 5.67308f
C462 a_2185_950# q0 0.11526f
C463 a_38623_1674# GROUP20_2.G 0.04107f
C464 a_12914_1674# GROUP19_0.G 0.038f
C465 GROUP19_0.G a_14174_1674# 0.04108f
C466 GROUP16_3.pmosHV$2_priv10_0.D VDDL 1.47311f
C467 a_2186_5524# q0 0.038f
C468 a_40784_4724# GROUP6_2.pmosHV_priv16_0.S 0.01476f
C469 GROUP8_2.nmosHV_priv1_0.S a_39935_4000# 0.10967f
C470 GROUP15_2.pmosHV$2_priv7_0.D a_26040_4924# 0.26717f
C471 vref_3 a_29780_1676# 0.04421f
C472 GROUP22_3.G a_27987_7670# 0.17776f
C473 GROUP10_3.pmosHV$1_priv4_0.S GROUP22_3.nmosHV_priv28_0.D 1.47006f
C474 vin GROUP10_0.pmosHV$1_priv4_0.D 0.23151f
C475 VDD clk_h 13.7777f
C476 a_14174_1674# VDDL 0.37565f
C477 a_14174_4924# GROUP13_1.pmosHV$2_priv1_0.D 0.2681f
C478 q3 GROUP14_2.pmosHV$2_priv4_0.S 0.42301f
C479 vin GROUP22_2.G 0.67566f
C480 GROUP8_2.nmosHV_priv1_0.S GROUP20_2.G 0.29318f
C481 a_34890_1674# GROUP19_2.G 0.038f
C482 VDD a_41149_1676# 0.51908f
C483 GROUP10_2.pmosHV$1_priv4_0.S GROUP22_2.G 1.21908f
C484 a_22310_6246# GROUP22_3.G 0.038f
C485 a_1821_1674# GROUP16_1.G 0.03816f
C486 a_8080_4724# VDD 0.45527f
C487 GROUP10_2.pmosHV$1_priv4_0.D a_34888_6246# 0.03865f
C488 a_37410_1674# GROUP20_2.G 0.04129f
C489 GROUP16_1.pmosHV$2_priv10_0.D GROUP20_1.G 1.8762f
C490 q3 a_36150_4924# 0.04108f
C491 GROUP12_1.nmosHV_priv10_0.S a_5919_5524# 0.03816f
C492 q1 GROUP22_0.G 0.06942f
C493 VDD GROUP22_3.G 7.1332f
C494 a_33314_6246# GROUP22_2.G 0.038f
C495 a_3081_4924# GROUP16_1.G 0.26793f
C496 a_9644_3200# GROUP22_1.G 0.04142f
C497 a_38623_5524# GROUP20_2.G 0.11422f
C498 GROUP20_0.G GROUP22_0.G 1.73473f
C499 a_39518_5324# GROUP10_2.pmosHV$1_priv4_0.D 0.0397f
C500 GROUP10_2.pmosHV$1_priv4_0.D VDDL 3.27488f
C501 GROUP12_3.nmosHV_priv10_0.S VDDL 3.26082f
C502 VDD a_28879_1676# 0.20554f
C503 a_27619_1674# GROUP22_3.nmosHV_priv28_0.D 0.04107f
C504 VDDL GROUP19_3.G 2.20382f
C505 a_12912_6246# GROUP10_0.pmosHV$1_priv4_0.D 0.03865f
C506 GROUP8_1.nmosHV_priv1_0.S GROUP10_0.pmosHV$1_priv4_0.S 0.05104f
C507 GROUP6_2.pmosHV_priv16_0.S VDD 3.05694f
C508 a_17907_1676# GROUP20_0.G 0.03991f
C509 a_30979_3200# VDD 0.4513f
C510 a_28514_5324# GROUP22_3.nmosHV_priv28_0.D 0.1654f
C511 GROUP6_0.pmosHV_priv16_0.S a_20007_3200# 0.30958f
C512 GROUP20_0.G q1 1.281f
C513 q2 a_23886_5524# 0.038f
C514 a_980_950# GROUP22_1.G 0.038f
C515 a_7179_1676# VDD 0.20554f
C516 vref_4 a_41149_1676# 0.04159f
C517 GROUP8_3.nmosHV_priv1_0.S vin 2.0905f
C518 GROUP10_2.pmosHV$1_priv4_0.D a_38258_5524# 0.03845f
C519 GROUP10_2.pmosHV$1_priv4_0.D GROUP19_2.G 1.30224f
C520 VDD a_36690_7670# 0.04055f
C521 GROUP6_1.pmosHV_priv16_0.S a_8445_4724# 0.33002f
C522 GROUP16_1.pmosHV$2_priv10_0.D a_3446_1674# 0.26836f
C523 a_29780_1676# GROUP10_3.pmosHV$1_priv4_0.S 0.29889f
C524 a_24781_1674# q2 0.29089f
C525 a_18808_4724# GROUP6_0.pmosHV_priv16_0.S 0.01476f
C526 a_7179_5324# GROUP8_0.nmosHV_priv1_0.S 0.17614f
C527 VDDL GROUP22_1.G 0.44967f
C528 GROUP12_3.nmosHV_priv10_0.S a_27254_5524# 0.03845f
C529 a_11703_6246# GROUP22_0.G 0.0384f
C530 a_33319_950# GROUP22_2.G 0.03816f
C531 GROUP19_0.G VDDL 2.20382f
C532 VDDL GROUP8_1.nmosHV_priv1_0.S 0.05898f
C533 vin GROUP6_0.pmosHV_priv16_0.S 2.0776f
C534 GROUP6_2.pmosHV_priv16_0.S vref_4 2.03213f
C535 GROUP10_2.pmosHV$1_priv4_0.S a_40784_1676# 0.29889f
C536 q0 GROUP22_1.G 0.06942f
C537 GROUP12_1.nmosHV_priv10_0.S a_4705_4924# 0.04169f
C538 VDDL a_4340_4924# 0.3891f
C539 GROUP20_1.G GROUP16_1.G 1.00529f
C540 a_23520_950# GROUP22_3.nmosHV_priv28_0.D 0.03884f
C541 a_40784_4724# vin 0.05466f
C542 GROUP20_0.G a_16647_5524# 0.11422f
C543 GROUP16_3.pmosHV$2_priv10_0.D a_26041_1674# 0.26682f
C544 GROUP10_2.pmosHV$1_priv4_0.D clk_h 0.04366f
C545 VDD GROUP10_1.pmosHV$1_priv4_0.S 1.55016f
C546 vref_1 VDD 1.39199f
C547 a_19173_1676# GROUP6_0.pmosHV_priv16_0.S 0.29522f
C548 GROUP12_3.nmosHV_priv10_0.S clk_h 0.04367f
C549 GROUP19_2.G a_34888_6246# 0.11641f
C550 q2 GROUP22_3.nmosHV_priv28_0.D 1.281f
C551 VDDL a_37045_1674# 0.37987f
C552 VDDL q0 2.17312f
C553 VDD a_20007_3200# 0.4513f
C554 a_30145_4724# VDD 0.4548f
C555 GROUP22_3.nmosHV_priv28_0.D a_27619_5524# 0.11422f
C556 q3 a_34890_1674# 0.11851f
C557 GROUP8_2.nmosHV_priv1_0.S GROUP22_2.G 1.46896f
C558 GROUP22_0.G GROUP10_0.pmosHV$1_priv4_0.D 2.36765f
C559 VDDL GROUP19_2.G 2.20382f
C560 a_6291_6684# GROUP22_1.G 0.17996f
C561 a_3990_6684# GROUP22_1.G 0.04859f
C562 VDD a_39883_1676# 0.20554f
C563 a_39935_4000# GROUP22_2.G 0.04346f
C564 GROUP8_3.nmosHV_priv1_0.S GROUP6_3.pmosHV_priv16_0.S 0.48035f
C565 a_1819_6246# a_1821_5524# 0.01035f
C566 GROUP16_0.pmosHV$2_priv10_0.D a_15069_1674# 0.26682f
C567 GROUP12_3.nmosHV_priv10_0.S GROUP22_3.G 2.36765f
C568 VDD a_18808_4724# 0.45527f
C569 GROUP8_3.nmosHV_priv1_0.S GROUP10_3.pmosHV$1_priv4_0.S 0.05104f
C570 VDD a_17015_7670# 0.04038f
C571 GROUP19_3.G GROUP22_3.G 0.21217f
C572 q1 GROUP10_0.pmosHV$1_priv4_0.D 1.18243f
C573 VDD GROUP8_0.nmosHV_priv1_0.S 1.05968f
C574 a_3446_1674# GROUP16_1.G 0.04108f
C575 a_7231_3198# GROUP22_1.G 0.04064f
C576 a_5554_1674# GROUP20_1.G 0.0382f
C577 GROUP20_2.G GROUP22_2.G 1.73473f
C578 clk_h GROUP22_1.G 7.06173f
C579 GROUP20_0.G GROUP10_0.pmosHV$1_priv4_0.D 5.67295f
C580 GROUP6_1.pmosHV_priv16_0.S a_9279_3200# 0.30958f
C581 a_26406_1674# GROUP22_3.nmosHV_priv28_0.D 0.04129f
C582 VDD vin 4.74581f
C583 a_39883_5324# VDD 0.20539f
C584 a_16647_1674# GROUP20_0.G 0.04107f
C585 vref_2 a_19173_1676# 0.04159f
C586 a_29780_4724# GROUP22_3.G 0.0113f
C587 GROUP10_2.pmosHV$1_priv4_0.S VDD 1.55016f
C588 vref_3 VDD 1.52289f
C589 a_34890_5524# a_34888_6246# 0.01035f
C590 q3 GROUP10_2.pmosHV$1_priv4_0.D 1.18243f
C591 a_28566_3198# GROUP22_3.G 0.04048f
C592 a_8080_4724# GROUP22_1.G 0.01129f
C593 a_36694_6684# GROUP22_2.G 0.04859f
C594 GROUP10_2.pmosHV$1_priv4_0.D a_37044_4924# 0.04153f
C595 a_6814_1676# GROUP20_1.G 0.03974f
C596 VDDL clk_h 3.54711f
C597 GROUP10_2.pmosHV$1_priv4_0.D a_34523_6246# 0.04313f
C598 GROUP12_1.nmosHV_priv10_0.S a_2184_6246# 0.03865f
C599 a_19173_1676# VDD 0.51908f
C600 GROUP19_0.G GROUP13_1.pmosHV$2_priv1_0.D 0.38265f
C601 clk_h a_14714_7670# 0.12182f
C602 a_12914_1674# a_12913_950# 0.01042f
C603 a_28931_3198# GROUP10_3.pmosHV$1_priv4_0.S 0.1195f
C604 a_20372_3200# GROUP22_0.G 0.04142f
C605 GROUP12_3.nmosHV_priv10_0.S a_26040_4924# 0.04153f
C606 vin VSS 24.05952f
C607 clk_h VSS 51.79449f
C608 VDDL VSS 19.25112f
C609 VDD VSS 86.82382f
C610 a_34889_950# VSS 0.15444f ; **FLOATING
C611 a_34524_950# VSS 0.26924f ; **FLOATING
C612 a_33684_950# VSS 0.15979f ; **FLOATING
C613 a_33319_950# VSS 0.26503f ; **FLOATING
C614 a_23885_950# VSS 0.15444f ; **FLOATING
C615 a_23520_950# VSS 0.26924f ; **FLOATING
C616 a_22680_950# VSS 0.15979f ; **FLOATING
C617 a_22315_950# VSS 0.26503f ; **FLOATING
C618 a_12913_950# VSS 0.15444f ; **FLOATING
C619 a_12548_950# VSS 0.26924f ; **FLOATING
C620 a_11708_950# VSS 0.15979f ; **FLOATING
C621 a_11343_950# VSS 0.26503f ; **FLOATING
C622 a_2185_950# VSS 0.15444f ; **FLOATING
C623 a_1820_950# VSS 0.26924f ; **FLOATING
C624 a_980_950# VSS 0.15979f ; **FLOATING
C625 a_615_950# VSS 0.26503f ; **FLOATING
C626 a_41149_1676# VSS 0.01388f ; **FLOATING
C627 a_40784_1676# VSS 0.01388f ; **FLOATING
C628 a_39883_1676# VSS 0.05174f ; **FLOATING
C629 a_39518_1676# VSS 0.03852f ; **FLOATING
C630 a_38623_1674# VSS 0.16029f ; **FLOATING
C631 a_38258_1674# VSS 0.26898f ; **FLOATING
C632 a_37410_1674# VSS 0.01974f ; **FLOATING
C633 a_37045_1674# VSS 0.0166f ; **FLOATING
C634 a_36150_1674# VSS 0.01403f ; **FLOATING
C635 a_35785_1674# VSS 0.01403f ; **FLOATING
C636 a_34890_1674# VSS 0.15472f ; **FLOATING
C637 a_34525_1674# VSS 0.26584f ; **FLOATING
C638 a_30145_1676# VSS 0.01388f ; **FLOATING
C639 a_29780_1676# VSS 0.01388f ; **FLOATING
C640 a_28879_1676# VSS 0.05174f ; **FLOATING
C641 a_28514_1676# VSS 0.03852f ; **FLOATING
C642 a_27619_1674# VSS 0.16029f ; **FLOATING
C643 a_27254_1674# VSS 0.26898f ; **FLOATING
C644 a_26406_1674# VSS 0.01974f ; **FLOATING
C645 a_26041_1674# VSS 0.0166f ; **FLOATING
C646 a_25146_1674# VSS 0.01403f ; **FLOATING
C647 a_24781_1674# VSS 0.01403f ; **FLOATING
C648 a_23886_1674# VSS 0.15472f ; **FLOATING
C649 a_23521_1674# VSS 0.26584f ; **FLOATING
C650 a_19173_1676# VSS 0.01388f ; **FLOATING
C651 a_18808_1676# VSS 0.01388f ; **FLOATING
C652 a_17907_1676# VSS 0.05174f ; **FLOATING
C653 a_17542_1676# VSS 0.03852f ; **FLOATING
C654 a_16647_1674# VSS 0.16029f ; **FLOATING
C655 a_16282_1674# VSS 0.26898f ; **FLOATING
C656 a_15434_1674# VSS 0.01974f ; **FLOATING
C657 a_15069_1674# VSS 0.0166f ; **FLOATING
C658 a_14174_1674# VSS 0.01403f ; **FLOATING
C659 a_13809_1674# VSS 0.01403f ; **FLOATING
C660 a_12914_1674# VSS 0.15472f ; **FLOATING
C661 a_12549_1674# VSS 0.26584f ; **FLOATING
C662 a_8445_1676# VSS 0.01388f ; **FLOATING
C663 a_8080_1676# VSS 0.01388f ; **FLOATING
C664 a_7179_1676# VSS 0.05174f ; **FLOATING
C665 a_6814_1676# VSS 0.03852f ; **FLOATING
C666 a_5919_1674# VSS 0.16029f ; **FLOATING
C667 a_5554_1674# VSS 0.26898f ; **FLOATING
C668 a_4706_1674# VSS 0.01974f ; **FLOATING
C669 a_4341_1674# VSS 0.0166f ; **FLOATING
C670 a_3446_1674# VSS 0.01403f ; **FLOATING
C671 GROUP16_1.pmosHV$2_priv10_0.D VSS 0.06085f
C672 a_3081_1674# VSS 0.01403f ; **FLOATING
C673 a_2186_1674# VSS 0.15472f ; **FLOATING
C674 a_1821_1674# VSS 0.26584f ; **FLOATING
C675 a_42348_3200# VSS 0.02594f ; **FLOATING
C676 a_41983_3200# VSS 0.02594f ; **FLOATING
C677 a_39935_3198# VSS 0.14987f ; **FLOATING
C678 a_39570_3198# VSS 0.26348f ; **FLOATING
C679 a_39935_4000# VSS 0.15063f ; **FLOATING
C680 a_39570_4000# VSS 0.25725f ; **FLOATING
C681 a_31344_3200# VSS 0.02594f ; **FLOATING
C682 a_30979_3200# VSS 0.02594f ; **FLOATING
C683 a_28931_3198# VSS 0.14987f ; **FLOATING
C684 GROUP10_3.pmosHV$1_priv4_0.S VSS 1.01122f
C685 a_28566_3198# VSS 0.26348f ; **FLOATING
C686 a_28931_4000# VSS 0.15063f ; **FLOATING
C687 a_28566_4000# VSS 0.25725f ; **FLOATING
C688 a_20372_3200# VSS 0.02594f ; **FLOATING
C689 a_20007_3200# VSS 0.02594f ; **FLOATING
C690 a_17959_3198# VSS 0.14987f ; **FLOATING
C691 a_17594_3198# VSS 0.26348f ; **FLOATING
C692 a_17959_4000# VSS 0.15063f ; **FLOATING
C693 a_17594_4000# VSS 0.25725f ; **FLOATING
C694 a_9644_3200# VSS 0.02594f ; **FLOATING
C695 a_9279_3200# VSS 0.02594f ; **FLOATING
C696 a_7231_3198# VSS 0.14987f ; **FLOATING
C697 GROUP10_1.pmosHV$1_priv4_0.S VSS 0.12795f
C698 a_6866_3198# VSS 0.26348f ; **FLOATING
C699 a_7231_4000# VSS 0.15063f ; **FLOATING
C700 a_6866_4000# VSS 0.25725f ; **FLOATING
C701 a_41149_4724# VSS 0.01398f ; **FLOATING
C702 a_40784_4724# VSS 0.01398f ; **FLOATING
C703 a_39883_5324# VSS 0.02553f ; **FLOATING
C704 a_39518_5324# VSS 0.02542f ; **FLOATING
C705 a_38623_5524# VSS 0.15875f ; **FLOATING
C706 a_38258_5524# VSS 0.26467f ; **FLOATING
C707 a_37409_4924# VSS 0.019f ; **FLOATING
C708 a_37044_4924# VSS 0.01862f ; **FLOATING
C709 a_36150_4924# VSS 0.01442f ; **FLOATING
C710 GROUP13_3.pmosHV$2_priv1_0.D VSS 0.05958f
C711 a_35785_4924# VSS 0.01455f ; **FLOATING
C712 a_34890_5524# VSS 0.15456f ; **FLOATING
C713 a_34525_5524# VSS 0.26859f ; **FLOATING
C714 a_30145_4724# VSS 0.01398f ; **FLOATING
C715 a_29780_4724# VSS 0.01398f ; **FLOATING
C716 a_28879_5324# VSS 0.02553f ; **FLOATING
C717 a_28514_5324# VSS 0.02542f ; **FLOATING
C718 a_27619_5524# VSS 0.15875f ; **FLOATING
C719 GROUP22_3.nmosHV_priv28_0.D VSS 0.12253f
C720 a_27254_5524# VSS 0.26467f ; **FLOATING
C721 a_26405_4924# VSS 0.019f ; **FLOATING
C722 a_26040_4924# VSS 0.01862f ; **FLOATING
C723 a_25146_4924# VSS 0.01442f ; **FLOATING
C724 a_24781_4924# VSS 0.01455f ; **FLOATING
C725 a_23886_5524# VSS 0.15456f ; **FLOATING
C726 a_23521_5524# VSS 0.26859f ; **FLOATING
C727 a_19173_4724# VSS 0.01398f ; **FLOATING
C728 a_18808_4724# VSS 0.01398f ; **FLOATING
C729 a_17907_5324# VSS 0.02553f ; **FLOATING
C730 GROUP8_1.nmosHV_priv1_0.S VSS 0.12279f
C731 a_17542_5324# VSS 0.02542f ; **FLOATING
C732 a_16647_5524# VSS 0.15875f ; **FLOATING
C733 a_16282_5524# VSS 0.26467f ; **FLOATING
C734 a_15433_4924# VSS 0.019f ; **FLOATING
C735 a_15068_4924# VSS 0.01862f ; **FLOATING
C736 a_14174_4924# VSS 0.01442f ; **FLOATING
C737 a_13809_4924# VSS 0.01455f ; **FLOATING
C738 a_12914_5524# VSS 0.15456f ; **FLOATING
C739 a_12549_5524# VSS 0.26859f ; **FLOATING
C740 a_8445_4724# VSS 0.01398f ; **FLOATING
C741 GROUP6_1.pmosHV_priv16_0.S VSS 1.09358f
C742 a_8080_4724# VSS 0.01398f ; **FLOATING
C743 a_7179_5324# VSS 0.02553f ; **FLOATING
C744 a_6814_5324# VSS 0.02542f ; **FLOATING
C745 a_5919_5524# VSS 0.15875f ; **FLOATING
C746 a_5554_5524# VSS 0.26467f ; **FLOATING
C747 a_4705_4924# VSS 0.019f ; **FLOATING
C748 a_4340_4924# VSS 0.01862f ; **FLOATING
C749 a_3446_4924# VSS 0.01442f ; **FLOATING
C750 a_3081_4924# VSS 0.01455f ; **FLOATING
C751 a_2186_5524# VSS 0.15456f ; **FLOATING
C752 a_1821_5524# VSS 0.26859f ; **FLOATING
C753 a_34888_6246# VSS 0.15174f ; **FLOATING
C754 a_38995_6684# VSS 0.06267f ; **FLOATING
C755 a_34523_6246# VSS 0.25822f ; **FLOATING
C756 a_33679_6246# VSS 0.15567f ; **FLOATING
C757 a_33314_6246# VSS 0.2554f ; **FLOATING
C758 a_23884_6246# VSS 0.15174f ; **FLOATING
C759 a_36694_6684# VSS 0.06183f ; **FLOATING
C760 a_27991_6684# VSS 0.06267f ; **FLOATING
C761 a_23519_6246# VSS 0.25822f ; **FLOATING
C762 a_22675_6246# VSS 0.15567f ; **FLOATING
C763 a_22310_6246# VSS 0.2554f ; **FLOATING
C764 a_12912_6246# VSS 0.15174f ; **FLOATING
C765 GROUP12_3.nmosHV_priv10_0.S VSS 0.11879f
C766 a_25690_6684# VSS 0.06183f ; **FLOATING
C767 a_17019_6684# VSS 0.06267f ; **FLOATING
C768 a_12547_6246# VSS 0.25822f ; **FLOATING
C769 a_11703_6246# VSS 0.15567f ; **FLOATING
C770 a_11338_6246# VSS 0.2554f ; **FLOATING
C771 a_2184_6246# VSS 0.15174f ; **FLOATING
C772 a_14718_6684# VSS 0.06183f ; **FLOATING
C773 a_6291_6684# VSS 0.06267f ; **FLOATING
C774 a_1819_6246# VSS 0.25822f ; **FLOATING
C775 a_975_6246# VSS 0.15567f ; **FLOATING
C776 a_610_6246# VSS 0.2554f ; **FLOATING
C777 GROUP12_1.nmosHV_priv10_0.S VSS 0.0295f
C778 a_3990_6684# VSS 0.06183f ; **FLOATING
C779 a_38991_7670# VSS 0.2287f ; **FLOATING
C780 GROUP22_2.G VSS 25.34555f
C781 a_36690_7670# VSS 0.2287f ; **FLOATING
C782 a_27987_7670# VSS 0.2287f ; **FLOATING
C783 GROUP22_3.G VSS 25.36143f
C784 a_25686_7670# VSS 0.2287f ; **FLOATING
C785 a_17015_7670# VSS 0.2287f ; **FLOATING
C786 GROUP22_0.G VSS 25.36816f
C787 a_14714_7670# VSS 0.2287f ; **FLOATING
C788 a_6287_7670# VSS 0.2287f ; **FLOATING
C789 GROUP22_1.G VSS 25.61167f
C790 a_3986_7670# VSS 0.2287f ; **FLOATING
C791 GROUP22_1.G.n0 VSS 2.27612f
C792 GROUP22_1.G.n1 VSS 0.06543f
C793 GROUP22_1.G.n2 VSS 0.33065f
C794 GROUP22_1.G.n3 VSS 0.10162f
C795 GROUP22_1.G.n4 VSS 0.08727f
C796 GROUP22_1.G.n5 VSS 0.10279f
C797 GROUP22_1.G.n6 VSS 0.2954f
C798 GROUP22_1.G.n7 VSS 2.49438f
C799 GROUP22_1.G.n8 VSS 0.12157f
C800 GROUP22_1.G.n9 VSS 0.1733f
C801 GROUP22_1.G.n10 VSS 0.34999f
C802 GROUP22_1.G.n11 VSS 0.18488f
C803 GROUP22_1.G.n12 VSS 0.34999f
C804 GROUP22_1.G.n13 VSS 0.18488f
C805 GROUP22_1.G.n14 VSS 0.91945f
C806 GROUP22_1.G.n15 VSS 0.85772f
C807 GROUP22_1.G.n17 VSS 2.41677f
C808 GROUP22_1.G.n18 VSS 3.29139f
C809 GROUP22_1.G.t5 VSS 0.23629f
C810 GROUP22_1.G.t4 VSS 0.23364f
C811 GROUP22_1.G.t19 VSS 0.12502f
C812 GROUP22_1.G.n19 VSS 0.07048f
C813 GROUP22_1.G.t18 VSS 0.18011f
C814 GROUP22_1.G.t17 VSS 0.18011f
C815 GROUP22_1.G.t16 VSS 0.18011f
C816 GROUP22_1.G.t15 VSS 0.18011f
C817 GROUP22_1.G.t14 VSS 0.18011f
C818 GROUP22_1.G.n20 VSS 0.10279f
C819 GROUP22_1.G.t13 VSS 0.16644f
C820 GROUP22_1.G.n21 VSS 0.06411f
C821 GROUP22_1.G.n22 VSS 0.04859f
C822 GROUP22_1.G.n23 VSS 0.08727f
C823 GROUP22_1.G.n24 VSS 0.08727f
C824 GROUP22_1.G.n25 VSS 0.10279f
C825 GROUP22_1.G.n26 VSS 0.10279f
C826 GROUP22_1.G.n27 VSS 0.10279f
C827 GROUP22_1.G.t11 VSS 0.28526f
C828 GROUP22_1.G.t10 VSS 0.28526f
C829 GROUP22_1.G.n28 VSS 0.26289f
C830 GROUP22_1.G.n29 VSS 0.08727f
C831 GROUP22_1.G.t9 VSS 0.28526f
C832 GROUP22_1.G.t8 VSS 0.28526f
C833 GROUP22_1.G.t7 VSS 0.28526f
C834 GROUP22_1.G.t6 VSS 0.23125f
C835 GROUP22_1.G.n30 VSS 0.06411f
C836 GROUP22_1.G.n31 VSS 0.04859f
C837 GROUP22_1.G.n32 VSS 0.08727f
C838 GROUP22_1.G.n33 VSS 0.10279f
C839 GROUP22_1.G.n34 VSS 0.10279f
C840 GROUP22_1.G.n35 VSS 0.10279f
C841 GROUP22_1.G.n36 VSS 0.08727f
C842 GROUP22_1.G.n37 VSS 0.08727f
C843 GROUP22_1.G.t2 VSS 0.23629f
C844 GROUP22_1.G.t1 VSS 0.23364f
C845 GROUP22_1.G.t12 VSS 0.1776f
C846 GROUP22_1.G.n38 VSS 0.07048f
C847 GROUP22_1.G.n39 VSS 2.27235f
C848 GROUP22_0.G.n0 VSS 2.28863f
C849 GROUP22_0.G.n1 VSS 0.06579f
C850 GROUP22_0.G.n2 VSS 0.33247f
C851 GROUP22_0.G.n3 VSS 0.10218f
C852 GROUP22_0.G.n4 VSS 0.08775f
C853 GROUP22_0.G.n5 VSS 0.10335f
C854 GROUP22_0.G.n6 VSS 0.29703f
C855 GROUP22_0.G.n7 VSS 2.50809f
C856 GROUP22_0.G.n8 VSS 0.12224f
C857 GROUP22_0.G.n9 VSS 0.17426f
C858 GROUP22_0.G.n10 VSS 0.35192f
C859 GROUP22_0.G.n11 VSS 0.18589f
C860 GROUP22_0.G.n12 VSS 0.35192f
C861 GROUP22_0.G.n13 VSS 0.18589f
C862 GROUP22_0.G.n14 VSS 0.9245f
C863 GROUP22_0.G.n15 VSS 0.86244f
C864 GROUP22_0.G.n17 VSS 2.43006f
C865 GROUP22_0.G.n18 VSS 3.30948f
C866 GROUP22_0.G.t19 VSS 0.23759f
C867 GROUP22_0.G.t18 VSS 0.23492f
C868 GROUP22_0.G.t13 VSS 0.12571f
C869 GROUP22_0.G.n19 VSS 0.07087f
C870 GROUP22_0.G.t12 VSS 0.1811f
C871 GROUP22_0.G.t11 VSS 0.1811f
C872 GROUP22_0.G.t10 VSS 0.1811f
C873 GROUP22_0.G.t9 VSS 0.1811f
C874 GROUP22_0.G.t8 VSS 0.1811f
C875 GROUP22_0.G.n20 VSS 0.10335f
C876 GROUP22_0.G.t7 VSS 0.16735f
C877 GROUP22_0.G.n21 VSS 0.06446f
C878 GROUP22_0.G.n22 VSS 0.04886f
C879 GROUP22_0.G.n23 VSS 0.08775f
C880 GROUP22_0.G.n24 VSS 0.08775f
C881 GROUP22_0.G.n25 VSS 0.10335f
C882 GROUP22_0.G.n26 VSS 0.10335f
C883 GROUP22_0.G.n27 VSS 0.10335f
C884 GROUP22_0.G.t5 VSS 0.28625f
C885 GROUP22_0.G.t4 VSS 0.28625f
C886 GROUP22_0.G.n28 VSS 0.26434f
C887 GROUP22_0.G.n29 VSS 0.08775f
C888 GROUP22_0.G.t3 VSS 0.28625f
C889 GROUP22_0.G.t2 VSS 0.28625f
C890 GROUP22_0.G.t1 VSS 0.28625f
C891 GROUP22_0.G.t0 VSS 0.21993f
C892 GROUP22_0.G.n30 VSS 0.06446f
C893 GROUP22_0.G.n31 VSS 0.04886f
C894 GROUP22_0.G.n32 VSS 0.08775f
C895 GROUP22_0.G.n33 VSS 0.10335f
C896 GROUP22_0.G.n34 VSS 0.10335f
C897 GROUP22_0.G.n35 VSS 0.10335f
C898 GROUP22_0.G.n36 VSS 0.08775f
C899 GROUP22_0.G.n37 VSS 0.08775f
C900 GROUP22_0.G.t16 VSS 0.23759f
C901 GROUP22_0.G.t15 VSS 0.23492f
C902 GROUP22_0.G.t6 VSS 0.17829f
C903 GROUP22_0.G.n38 VSS 0.07086f
C904 GROUP22_0.G.n39 VSS 2.28483f
C905 GROUP22_3.G.n0 VSS 2.29169f
C906 GROUP22_3.G.n1 VSS 0.06588f
C907 GROUP22_3.G.n2 VSS 0.33291f
C908 GROUP22_3.G.n3 VSS 0.10231f
C909 GROUP22_3.G.n4 VSS 0.08787f
C910 GROUP22_3.G.n5 VSS 0.10349f
C911 GROUP22_3.G.n6 VSS 0.29742f
C912 GROUP22_3.G.n7 VSS 2.51144f
C913 GROUP22_3.G.n8 VSS 0.1224f
C914 GROUP22_3.G.n9 VSS 0.17449f
C915 GROUP22_3.G.n10 VSS 0.35239f
C916 GROUP22_3.G.n11 VSS 0.18614f
C917 GROUP22_3.G.n12 VSS 0.35239f
C918 GROUP22_3.G.n13 VSS 0.18614f
C919 GROUP22_3.G.n14 VSS 0.92573f
C920 GROUP22_3.G.n15 VSS 0.86359f
C921 GROUP22_3.G.n17 VSS 2.4333f
C922 GROUP22_3.G.n18 VSS 3.3139f
C923 GROUP22_3.G.t19 VSS 0.23791f
C924 GROUP22_3.G.t18 VSS 0.23524f
C925 GROUP22_3.G.t13 VSS 0.12587f
C926 GROUP22_3.G.n19 VSS 0.07096f
C927 GROUP22_3.G.t12 VSS 0.18134f
C928 GROUP22_3.G.t11 VSS 0.18134f
C929 GROUP22_3.G.t10 VSS 0.18134f
C930 GROUP22_3.G.t9 VSS 0.18134f
C931 GROUP22_3.G.t8 VSS 0.18134f
C932 GROUP22_3.G.n20 VSS 0.10349f
C933 GROUP22_3.G.t7 VSS 0.16757f
C934 GROUP22_3.G.n21 VSS 0.06455f
C935 GROUP22_3.G.n22 VSS 0.04893f
C936 GROUP22_3.G.n23 VSS 0.08787f
C937 GROUP22_3.G.n24 VSS 0.08787f
C938 GROUP22_3.G.n25 VSS 0.10349f
C939 GROUP22_3.G.n26 VSS 0.10349f
C940 GROUP22_3.G.n27 VSS 0.10349f
C941 GROUP22_3.G.t5 VSS 0.28649f
C942 GROUP22_3.G.t4 VSS 0.28649f
C943 GROUP22_3.G.n28 VSS 0.26469f
C944 GROUP22_3.G.n29 VSS 0.08787f
C945 GROUP22_3.G.t3 VSS 0.28649f
C946 GROUP22_3.G.t2 VSS 0.28649f
C947 GROUP22_3.G.t1 VSS 0.28649f
C948 GROUP22_3.G.t0 VSS 0.22015f
C949 GROUP22_3.G.n30 VSS 0.06455f
C950 GROUP22_3.G.n31 VSS 0.04893f
C951 GROUP22_3.G.n32 VSS 0.08787f
C952 GROUP22_3.G.n33 VSS 0.10349f
C953 GROUP22_3.G.n34 VSS 0.10349f
C954 GROUP22_3.G.n35 VSS 0.10349f
C955 GROUP22_3.G.n36 VSS 0.08787f
C956 GROUP22_3.G.n37 VSS 0.08787f
C957 GROUP22_3.G.t16 VSS 0.23791f
C958 GROUP22_3.G.t15 VSS 0.23524f
C959 GROUP22_3.G.t6 VSS 0.17846f
C960 GROUP22_3.G.n38 VSS 0.07096f
C961 GROUP22_3.G.n39 VSS 2.28789f
C962 GROUP22_2.G.n0 VSS 2.29895f
C963 GROUP22_2.G.n1 VSS 0.06609f
C964 GROUP22_2.G.n2 VSS 0.33397f
C965 GROUP22_2.G.n3 VSS 0.10264f
C966 GROUP22_2.G.n4 VSS 0.08815f
C967 GROUP22_2.G.n5 VSS 0.10382f
C968 GROUP22_2.G.n6 VSS 0.29837f
C969 GROUP22_2.G.n7 VSS 2.5194f
C970 GROUP22_2.G.n8 VSS 0.12279f
C971 GROUP22_2.G.n9 VSS 0.17504f
C972 GROUP22_2.G.n10 VSS 0.3535f
C973 GROUP22_2.G.n11 VSS 0.18673f
C974 GROUP22_2.G.n12 VSS 0.3535f
C975 GROUP22_2.G.n13 VSS 0.18673f
C976 GROUP22_2.G.n14 VSS 0.92867f
C977 GROUP22_2.G.n15 VSS 0.86633f
C978 GROUP22_2.G.n17 VSS 2.44102f
C979 GROUP22_2.G.n18 VSS 3.32441f
C980 GROUP22_2.G.t12 VSS 0.23866f
C981 GROUP22_2.G.t11 VSS 0.23598f
C982 GROUP22_2.G.t19 VSS 0.12627f
C983 GROUP22_2.G.n19 VSS 0.07119f
C984 GROUP22_2.G.t18 VSS 0.18192f
C985 GROUP22_2.G.t17 VSS 0.18192f
C986 GROUP22_2.G.t16 VSS 0.18192f
C987 GROUP22_2.G.t15 VSS 0.18192f
C988 GROUP22_2.G.t14 VSS 0.18192f
C989 GROUP22_2.G.n20 VSS 0.10382f
C990 GROUP22_2.G.t13 VSS 0.1681f
C991 GROUP22_2.G.n21 VSS 0.06475f
C992 GROUP22_2.G.n22 VSS 0.04908f
C993 GROUP22_2.G.n23 VSS 0.08815f
C994 GROUP22_2.G.n24 VSS 0.08815f
C995 GROUP22_2.G.n25 VSS 0.10382f
C996 GROUP22_2.G.n26 VSS 0.10382f
C997 GROUP22_2.G.n27 VSS 0.10382f
C998 GROUP22_2.G.t5 VSS 0.28707f
C999 GROUP22_2.G.t4 VSS 0.28707f
C1000 GROUP22_2.G.n28 VSS 0.26553f
C1001 GROUP22_2.G.n29 VSS 0.08815f
C1002 GROUP22_2.G.t3 VSS 0.28707f
C1003 GROUP22_2.G.t2 VSS 0.28707f
C1004 GROUP22_2.G.t1 VSS 0.28707f
C1005 GROUP22_2.G.t0 VSS 0.22068f
C1006 GROUP22_2.G.n30 VSS 0.06475f
C1007 GROUP22_2.G.n31 VSS 0.04908f
C1008 GROUP22_2.G.n32 VSS 0.08815f
C1009 GROUP22_2.G.n33 VSS 0.10382f
C1010 GROUP22_2.G.n34 VSS 0.10382f
C1011 GROUP22_2.G.n35 VSS 0.10382f
C1012 GROUP22_2.G.n36 VSS 0.08815f
C1013 GROUP22_2.G.n37 VSS 0.08815f
C1014 GROUP22_2.G.t9 VSS 0.23866f
C1015 GROUP22_2.G.t8 VSS 0.23598f
C1016 GROUP22_2.G.t6 VSS 0.17886f
C1017 GROUP22_2.G.n38 VSS 0.07118f
C1018 GROUP22_2.G.n39 VSS 2.29514f
C1019 VSS.t68 VSS 0.0295f
C1020 VSS.t14 VSS 0.05899f
C1021 VSS.t286 VSS 0.11863f
C1022 VSS.t83 VSS 0.11879f
C1023 VSS.t299 VSS 0.12924f
C1024 VSS.t300 VSS 0.12334f
C1025 VSS.t302 VSS 0.11917f
C1026 VSS.t288 VSS 0.12292f
C1027 VSS.t262 VSS 0.12883f
C1028 VSS.t11 VSS 0.12295f
C1029 VSS.t311 VSS 5.32845f
C1030 VSS.t90 VSS 0.12253f
C1031 VSS.t279 VSS 0.12866f
C1032 VSS.t5 VSS 0.12279f
C1033 VSS.t93 VSS 2.59345f
C1034 VSS.t80 VSS 5.1869f
C1035 VSS.t254 VSS 0.12236f
C1036 VSS.t292 VSS 0.12795f
C1037 VSS.t306 VSS 0.12212f
C1038 VSS.t290 VSS 0.11799f
C1039 VSS.t71 VSS 5.34675f
C1040 VSS.t296 VSS 0.1217f
C1041 VDD.n0 VSS 0.06959f
C1042 VDD.n1 VSS 0.08943f
C1043 VDD.n2 VSS 0.06273f
C1044 VDD.n3 VSS 0.08022f
C1045 VDD.n4 VSS 0.05024f
C1046 VDD.n5 VSS 0.07086f
C1047 VDD.n6 VSS 0.11519f
C1048 VDD.n7 VSS 0.09459f
C1049 VDD.n8 VSS 0.03961f
C1050 VDD.n9 VSS 0.04756f
C1051 VDD.n10 VSS 0.0494f
C1052 VDD.n11 VSS 0.06304f
C1053 VDD.n12 VSS 0.04526f
C1054 VDD.n13 VSS 0.05766f
C1055 VDD.n14 VSS 0.01391f
C1056 VDD.n15 VSS 0.03795f
C1057 VDD.n16 VSS 0.04086f
C1058 VDD.n17 VSS 0.0349f
C1059 VDD.n18 VSS 0.01386f
C1060 VDD.n19 VSS 0.03219f
C1061 VDD.n20 VSS 0.04086f
C1062 VDD.t6 VSS 0.1751f
C1063 VDD.n21 VSS 0.05161f
C1064 VDD.n22 VSS 0.01772f
C1065 VDD.n23 VSS 0.01772f
C1066 VDD.n24 VSS 0.01772f
C1067 VDD.n25 VSS 0.01772f
C1068 VDD.n26 VSS 0.08903f
C1069 VDD.n27 VSS 0.08903f
C1070 VDD.n28 VSS 0.01772f
C1071 VDD.n29 VSS 0.01772f
C1072 VDD.n30 VSS 0.01772f
C1073 VDD.n31 VSS 0.01772f
C1074 VDD.n32 VSS 0.01772f
C1075 VDD.n33 VSS 0.01772f
C1076 VDD.n34 VSS 0.01772f
C1077 VDD.n35 VSS 0.01772f
C1078 VDD.n36 VSS 0.01772f
C1079 VDD.n37 VSS 0.01772f
C1080 VDD.n38 VSS 0.01772f
C1081 VDD.n39 VSS 0.01772f
C1082 VDD.n40 VSS 0.01772f
C1083 VDD.n41 VSS 0.01772f
C1084 VDD.n42 VSS 0.05161f
C1085 VDD.n43 VSS 0.05161f
C1086 VDD.n44 VSS 0.01772f
C1087 VDD.n45 VSS 0.01772f
C1088 VDD.n46 VSS 0.01772f
C1089 VDD.n47 VSS 0.01772f
C1090 VDD.n48 VSS 0.08903f
C1091 VDD.n49 VSS 0.02447f
C1092 VDD.n50 VSS 0.08903f
C1093 VDD.n51 VSS 0.01772f
C1094 VDD.n52 VSS 0.01772f
C1095 VDD.n53 VSS 0.01772f
C1096 VDD.n54 VSS 0.01772f
C1097 VDD.n55 VSS 0.01772f
C1098 VDD.n56 VSS 0.01772f
C1099 VDD.n57 VSS 0.01772f
C1100 VDD.n58 VSS 0.01772f
C1101 VDD.n59 VSS 0.01772f
C1102 VDD.n60 VSS 0.01772f
C1103 VDD.n61 VSS 0.01772f
C1104 VDD.n62 VSS 0.01772f
C1105 VDD.n63 VSS 0.01772f
C1106 VDD.n64 VSS 0.01772f
C1107 VDD.n65 VSS 0.05161f
C1108 VDD.t9 VSS 0.1752f
C1109 VDD.t10 VSS 0.1752f
C1110 VDD.n66 VSS 0.03443f
C1111 VDD.t17 VSS 0.41135f
C1112 VDD.n67 VSS 0.03505f
C1113 VDD.n68 VSS 1.01293f
C1114 VDD.t1 VSS 15.2233f
C1115 VDD.n69 VSS 1.94377f
C1116 VDD.n70 VSS 0.05161f
C1117 VDD.n71 VSS 0.01772f
C1118 VDD.n72 VSS 0.01772f
C1119 VDD.n73 VSS 0.01772f
C1120 VDD.n74 VSS 0.01772f
C1121 VDD.n75 VSS 0.08903f
C1122 VDD.n76 VSS 0.02447f
C1123 VDD.n77 VSS 0.08903f
C1124 VDD.n78 VSS 0.01772f
C1125 VDD.n79 VSS 0.01772f
C1126 VDD.n80 VSS 0.01772f
C1127 VDD.n81 VSS 0.01772f
C1128 VDD.n82 VSS 0.01772f
C1129 VDD.n83 VSS 0.01772f
C1130 VDD.n84 VSS 0.01772f
C1131 VDD.n85 VSS 0.01772f
C1132 VDD.n86 VSS 0.01772f
C1133 VDD.n87 VSS 0.01772f
C1134 VDD.n88 VSS 0.01772f
C1135 VDD.n89 VSS 0.01772f
C1136 VDD.n90 VSS 0.01772f
C1137 VDD.n91 VSS 0.01772f
C1138 VDD.n92 VSS 0.05161f
C1139 VDD.t12 VSS 0.17514f
C1140 VDD.t13 VSS 0.17514f
C1141 VDD.n93 VSS 0.07669f
C1142 VDD.t19 VSS 0.41175f
C1143 VDD.n94 VSS 0.03505f
C1144 VDD.n95 VSS 1.01293f
C1145 VDD.t2 VSS 15.2233f
C1146 VDD.n96 VSS 1.94377f
C1147 VDD.n97 VSS 0.05161f
C1148 VDD.n98 VSS 0.01772f
C1149 VDD.n99 VSS 0.01772f
C1150 VDD.n100 VSS 0.01772f
C1151 VDD.n101 VSS 0.01772f
C1152 VDD.n102 VSS 0.08903f
C1153 VDD.n103 VSS 0.02447f
C1154 VDD.n104 VSS 0.08903f
C1155 VDD.n105 VSS 0.01772f
C1156 VDD.n106 VSS 0.01772f
C1157 VDD.n107 VSS 0.01772f
C1158 VDD.n108 VSS 0.01772f
C1159 VDD.n109 VSS 0.01772f
C1160 VDD.n110 VSS 0.01772f
C1161 VDD.n111 VSS 0.01772f
C1162 VDD.n112 VSS 0.01772f
C1163 VDD.n113 VSS 0.01772f
C1164 VDD.n114 VSS 0.01772f
C1165 VDD.n115 VSS 0.01772f
C1166 VDD.n116 VSS 0.01772f
C1167 VDD.n117 VSS 0.01772f
C1168 VDD.n118 VSS 0.01772f
C1169 VDD.n119 VSS 0.05161f
C1170 VDD.n120 VSS 0.04576f
C1171 VDD.t15 VSS 0.1751f
C1172 VDD.t16 VSS 0.1751f
C1173 VDD.n121 VSS 0.02705f
C1174 VDD.t18 VSS 0.41268f
C1175 VDD.n122 VSS 0.03505f
C1176 VDD.n123 VSS 1.01293f
C1177 VDD.t3 VSS 15.2233f
C1178 VDD.n124 VSS 3.50625f
C1179 VDD.n125 VSS 3.61111f
C1180 VDD.n126 VSS 3.5726f
C1181 VDD.t0 VSS 15.2233f
C1182 VDD.n127 VSS 3.46757f
C1183 VDD.n128 VSS 0.03535f
C1184 VDD.t7 VSS 0.1751f
C1185 VDD.n129 VSS 0.03443f
C1186 VDD.t4 VSS 0.40974f
C1187 VDD.n130 VSS 0.03505f
C1188 VDD.n131 VSS 1.01293f
C1189 VDDL.n0 VSS 0.02031f
C1190 VDDL.n1 VSS 0.05097f
C1191 VDDL.n2 VSS 0.02717f
C1192 VDDL.n3 VSS 0.0235f
C1193 VDDL.n4 VSS 0.02258f
C1194 VDDL.n5 VSS 0.01289f
C1195 VDDL.n6 VSS 0.05305f
C1196 VDDL.n7 VSS 0.01301f
C1197 VDDL.n8 VSS 0.03241f
C1198 VDDL.n9 VSS 0.01301f
C1199 VDDL.n10 VSS 0.02717f
C1200 VDDL.n11 VSS 0.0235f
C1201 VDDL.n12 VSS 0.03241f
C1202 VDDL.n13 VSS 0.01301f
C1203 VDDL.n14 VSS 0.02877f
C1204 VDDL.n15 VSS 0.0235f
C1205 VDDL.n16 VSS 0.02512f
C1206 VDDL.n17 VSS 0.05097f
C1207 VDDL.n18 VSS 0.0581f
C1208 VDDL.n19 VSS 0.01942f
C1209 VDDL.n20 VSS 0.03241f
C1210 VDDL.n21 VSS 0.01301f
C1211 VDDL.n22 VSS 0.03125f
C1212 VDDL.n23 VSS 0.03241f
C1213 VDDL.n24 VSS 0.01301f
C1214 VDDL.n25 VSS 0.05305f
C1215 VDDL.n26 VSS 0.01301f
C1216 VDDL.n27 VSS 0.03745f
C1217 VDDL.n28 VSS 0.02099f
C1218 VDDL.n29 VSS 0.0581f
C1219 VDDL.n30 VSS 0.01942f
C1220 VDDL.n31 VSS 0.03125f
C1221 VDDL.n32 VSS 0.02968f
C1222 VDDL.n33 VSS 0.03241f
C1223 VDDL.n34 VSS 0.01301f
C1224 VDDL.n35 VSS 0.05305f
C1225 VDDL.n36 VSS 0.01301f
C1226 VDDL.n37 VSS 0.40651f
C1227 VDDL.n38 VSS 0.40676f
C1228 VDDL.n39 VSS 0.40727f
C1229 VDDL.n40 VSS 0.40753f
C1230 VDDL.n41 VSS 0.0263f
C1231 VDDL.n42 VSS 0.01966f
C1232 VDDL.t27 VSS 0.12981f
C1233 VDDL.n43 VSS 0.02291f
C1234 VDDL.t28 VSS 0.12981f
C1235 VDDL.n44 VSS 0.0247f
C1236 VDDL.t34 VSS 5.45118f
C1237 VDDL.t14 VSS 14.3827f
C1238 VDDL.n45 VSS 0.02291f
C1239 VDDL.n46 VSS 0.0263f
C1240 VDDL.t15 VSS 0.12978f
C1241 VDDL.n47 VSS 0.03135f
C1242 VDDL.t16 VSS 0.12978f
C1243 VDDL.n48 VSS 0.0247f
C1244 VDDL.t33 VSS 0.17009f
C1245 VDDL.n49 VSS 0.0263f
C1246 VDDL.n50 VSS 0.01966f
C1247 VDDL.n51 VSS 0.01966f
C1248 VDDL.n52 VSS 0.01966f
C1249 VDDL.t24 VSS 0.12978f
C1250 VDDL.n53 VSS 0.0263f
C1251 VDDL.n54 VSS 0.01966f
C1252 VDDL.t25 VSS 0.12978f
C1253 VDDL.n55 VSS 0.0247f
C1254 VDDL.t35 VSS 0.08162f
C1255 VDDL.n56 VSS 0.04161f
C1256 VDDL.t10 VSS 13.6462f
C1257 VDDL.n57 VSS 0.73643f
C1258 VDDL.n58 VSS 0.01966f
C1259 VDDL.n59 VSS 0.02291f
C1260 VDDL.n60 VSS 0.0263f
C1261 VDDL.n61 VSS 0.01966f
C1262 VDDL.t11 VSS 0.12978f
C1263 VDDL.t12 VSS 0.12978f
C1264 VDDL.n62 VSS 0.0247f
C1265 VDDL.t32 VSS 5.26937f
C1266 VDDL.n63 VSS 0.02888f
C1267 VDDL.n64 VSS 0.0263f
C1268 VDDL.n65 VSS 0.01966f
C1269 VDDL.n66 VSS 0.01966f
C1270 VDDL.n67 VSS 0.0263f
C1271 VDDL.t21 VSS 0.12978f
C1272 VDDL.n68 VSS 0.01966f
C1273 VDDL.n69 VSS 0.01966f
C1274 VDDL.t22 VSS 0.12978f
C1275 VDDL.n70 VSS 0.0247f
C1276 VDDL.t31 VSS 5.40872f
C1277 VDDL.n71 VSS 0.04161f
C1278 VDDL.t0 VSS 13.6462f
C1279 VDDL.n72 VSS 0.73643f
C1280 VDDL.n73 VSS 0.02291f
C1281 VDDL.t7 VSS 0.12978f
C1282 VDDL.n74 VSS 0.02291f
C1283 VDDL.t8 VSS 0.12978f
C1284 VDDL.n75 VSS 0.0247f
C1285 VDDL.t30 VSS 0.08162f
C1286 VDDL.n76 VSS 0.02888f
C1287 VDDL.n78 VSS 0.02607f
C1288 VDDL.n79 VSS 0.02291f
C1289 VDDL.n80 VSS 0.02642f
C1290 VDDL.t18 VSS 0.12981f
C1291 VDDL.t19 VSS 0.12981f
C1292 VDDL.n81 VSS 0.0247f
C1293 VDDL.t29 VSS 0.14247f
C1294 VDDL.n82 VSS 0.04161f
C1295 VDDL.t1 VSS 13.6462f
C1296 VDDL.n83 VSS 0.73643f
C1297 VDDL.n84 VSS 0.02258f
C1298 VDDL.n87 VSS 0.01966f
C1299 VDDL.n88 VSS 0.01966f
C1300 VDDL.n89 VSS 0.01966f
C1301 VDDL.n90 VSS 0.01966f
C1302 VDDL.n91 VSS 0.01966f
C1303 VDDL.n92 VSS 0.01966f
C1304 VDDL.t4 VSS 0.12978f
C1305 VDDL.n93 VSS 0.01966f
C1306 VDDL.n94 VSS 0.01966f
C1307 VDDL.t5 VSS 0.12978f
C1308 VDDL.n95 VSS 0.04323f
C1309 VDDL.n96 VSS 0.0247f
C1310 VDDL.t2 VSS 0.08162f
C1311 VDDL.n97 VSS 0.02888f
C1312 VDDL.n98 VSS 6.11246f
C1313 VDDL.n99 VSS 6.15843f
C1314 clk_h.n0 VSS 0.22532f
C1315 clk_h.n1 VSS 0.15149f
C1316 clk_h.n2 VSS 0.22532f
C1317 clk_h.n3 VSS 0.15149f
C1318 clk_h.n4 VSS 0.22532f
C1319 clk_h.n5 VSS 0.15149f
C1320 clk_h.n6 VSS 0.22532f
C1321 clk_h.n7 VSS 0.15149f
C1322 clk_h.n8 VSS 0.22532f
C1323 clk_h.n9 VSS 0.15149f
C1324 clk_h.n10 VSS 0.22532f
C1325 clk_h.n11 VSS 0.15149f
C1326 clk_h.n12 VSS 0.22532f
C1327 clk_h.n13 VSS 0.15149f
C1328 clk_h.n14 VSS 0.22532f
C1329 clk_h.n15 VSS 0.15149f
C1330 clk_h.t11 VSS 0.16146f
C1331 clk_h.t23 VSS 0.16146f
C1332 clk_h.t8 VSS 0.16146f
C1333 clk_h.t20 VSS 0.16146f
C1334 clk_h.t5 VSS 0.16146f
C1335 clk_h.t17 VSS 0.16146f
C1336 clk_h.t2 VSS 0.16146f
C1337 clk_h.t14 VSS 0.16146f
C1338 clk_h.n16 VSS 0.07633f
C1339 clk_h.n17 VSS 0.07633f
C1340 clk_h.n18 VSS 0.07633f
C1341 clk_h.n19 VSS 0.07633f
C1342 clk_h.t0 VSS 0.22975f
C1343 clk_h.n20 VSS 0.0708f
C1344 clk_h.t37 VSS 0.2011f
C1345 clk_h.t9 VSS 0.16493f
C1346 clk_h.n21 VSS 0.0573f
C1347 clk_h.n22 VSS 0.06037f
C1348 clk_h.n23 VSS 0.14271f
C1349 clk_h.n24 VSS 0.06037f
C1350 clk_h.t56 VSS 0.22975f
C1351 clk_h.n25 VSS 0.04537f
C1352 clk_h.t39 VSS 0.22975f
C1353 clk_h.n26 VSS 0.04424f
C1354 clk_h.n27 VSS 0.06037f
C1355 clk_h.n28 VSS 0.0711f
C1356 clk_h.t41 VSS 0.22975f
C1357 clk_h.n29 VSS 0.0711f
C1358 clk_h.t34 VSS 0.22975f
C1359 clk_h.n30 VSS 0.0711f
C1360 clk_h.n31 VSS 0.06037f
C1361 clk_h.n32 VSS 0.14271f
C1362 clk_h.n33 VSS 0.04424f
C1363 clk_h.t70 VSS 0.1246f
C1364 clk_h.n34 VSS 0.07079f
C1365 clk_h.t71 VSS 0.09595f
C1366 clk_h.t21 VSS 0.16493f
C1367 clk_h.n35 VSS 0.0573f
C1368 clk_h.n36 VSS 0.06037f
C1369 clk_h.n37 VSS 0.14271f
C1370 clk_h.n38 VSS 0.06037f
C1371 clk_h.t30 VSS 0.1246f
C1372 clk_h.n39 VSS 0.04537f
C1373 clk_h.t53 VSS 0.1246f
C1374 clk_h.n40 VSS 0.04424f
C1375 clk_h.n41 VSS 0.06037f
C1376 clk_h.n42 VSS 0.0711f
C1377 clk_h.t54 VSS 0.1246f
C1378 clk_h.n43 VSS 0.0711f
C1379 clk_h.t55 VSS 0.1246f
C1380 clk_h.n44 VSS 0.0711f
C1381 clk_h.n45 VSS 0.06037f
C1382 clk_h.n46 VSS 0.14271f
C1383 clk_h.n47 VSS 0.04424f
C1384 clk_h.n48 VSS 0.13004f
C1385 clk_h.t26 VSS 0.22975f
C1386 clk_h.n49 VSS 0.0708f
C1387 clk_h.t38 VSS 0.2011f
C1388 clk_h.t12 VSS 0.16493f
C1389 clk_h.n50 VSS 0.0573f
C1390 clk_h.n51 VSS 0.06037f
C1391 clk_h.n52 VSS 0.14271f
C1392 clk_h.n53 VSS 0.06037f
C1393 clk_h.t57 VSS 0.22975f
C1394 clk_h.n54 VSS 0.04537f
C1395 clk_h.t68 VSS 0.22975f
C1396 clk_h.n55 VSS 0.04424f
C1397 clk_h.n56 VSS 0.06037f
C1398 clk_h.n57 VSS 0.0711f
C1399 clk_h.t49 VSS 0.22975f
C1400 clk_h.n58 VSS 0.0711f
C1401 clk_h.t36 VSS 0.22975f
C1402 clk_h.n59 VSS 0.0711f
C1403 clk_h.n60 VSS 0.06037f
C1404 clk_h.n61 VSS 0.14271f
C1405 clk_h.n62 VSS 0.04424f
C1406 clk_h.t28 VSS 0.1246f
C1407 clk_h.n63 VSS 0.07079f
C1408 clk_h.t29 VSS 0.09595f
C1409 clk_h.t24 VSS 0.16493f
C1410 clk_h.n64 VSS 0.0573f
C1411 clk_h.n65 VSS 0.06037f
C1412 clk_h.n66 VSS 0.14271f
C1413 clk_h.n67 VSS 0.06037f
C1414 clk_h.t43 VSS 0.1246f
C1415 clk_h.n68 VSS 0.04537f
C1416 clk_h.t44 VSS 0.1246f
C1417 clk_h.n69 VSS 0.04424f
C1418 clk_h.n70 VSS 0.06037f
C1419 clk_h.n71 VSS 0.0711f
C1420 clk_h.t45 VSS 0.1246f
C1421 clk_h.n72 VSS 0.0711f
C1422 clk_h.t27 VSS 0.1246f
C1423 clk_h.n73 VSS 0.0711f
C1424 clk_h.n74 VSS 0.06037f
C1425 clk_h.n75 VSS 0.14271f
C1426 clk_h.n76 VSS 0.04424f
C1427 clk_h.n77 VSS 0.13004f
C1428 clk_h.n78 VSS 6.31601f
C1429 clk_h.t62 VSS 0.22975f
C1430 clk_h.n79 VSS 0.0708f
C1431 clk_h.t48 VSS 0.2011f
C1432 clk_h.t6 VSS 0.16493f
C1433 clk_h.n80 VSS 0.0573f
C1434 clk_h.n81 VSS 0.06037f
C1435 clk_h.n82 VSS 0.14271f
C1436 clk_h.n83 VSS 0.06037f
C1437 clk_h.t65 VSS 0.22975f
C1438 clk_h.n84 VSS 0.04537f
C1439 clk_h.t58 VSS 0.22975f
C1440 clk_h.n85 VSS 0.04424f
C1441 clk_h.n86 VSS 0.06037f
C1442 clk_h.n87 VSS 0.0711f
C1443 clk_h.t25 VSS 0.22975f
C1444 clk_h.n88 VSS 0.0711f
C1445 clk_h.t69 VSS 0.22975f
C1446 clk_h.n89 VSS 0.0711f
C1447 clk_h.n90 VSS 0.06037f
C1448 clk_h.n91 VSS 0.14271f
C1449 clk_h.n92 VSS 0.04424f
C1450 clk_h.t33 VSS 0.1246f
C1451 clk_h.n93 VSS 0.07079f
C1452 clk_h.t66 VSS 0.09595f
C1453 clk_h.t18 VSS 0.16493f
C1454 clk_h.n94 VSS 0.0573f
C1455 clk_h.n95 VSS 0.06037f
C1456 clk_h.n96 VSS 0.14271f
C1457 clk_h.n97 VSS 0.06037f
C1458 clk_h.t46 VSS 0.1246f
C1459 clk_h.n98 VSS 0.04537f
C1460 clk_h.t47 VSS 0.1246f
C1461 clk_h.n99 VSS 0.04424f
C1462 clk_h.n100 VSS 0.06037f
C1463 clk_h.n101 VSS 0.0711f
C1464 clk_h.t31 VSS 0.1246f
C1465 clk_h.n102 VSS 0.0711f
C1466 clk_h.t32 VSS 0.1246f
C1467 clk_h.n103 VSS 0.0711f
C1468 clk_h.n104 VSS 0.06037f
C1469 clk_h.n105 VSS 0.14271f
C1470 clk_h.n106 VSS 0.04424f
C1471 clk_h.n107 VSS 0.13004f
C1472 clk_h.t40 VSS 0.22975f
C1473 clk_h.n108 VSS 0.0708f
C1474 clk_h.n109 VSS 0.06037f
C1475 clk_h.n110 VSS 0.14271f
C1476 clk_h.n111 VSS 0.06037f
C1477 clk_h.t61 VSS 0.22975f
C1478 clk_h.n112 VSS 0.04537f
C1479 clk_h.t60 VSS 0.22975f
C1480 clk_h.n113 VSS 0.04424f
C1481 clk_h.n114 VSS 0.06037f
C1482 clk_h.n115 VSS 0.0711f
C1483 clk_h.t42 VSS 0.22975f
C1484 clk_h.n116 VSS 0.0711f
C1485 clk_h.t59 VSS 0.22975f
C1486 clk_h.n117 VSS 0.0711f
C1487 clk_h.n118 VSS 0.06037f
C1488 clk_h.n119 VSS 0.14271f
C1489 clk_h.n120 VSS 0.04424f
C1490 clk_h.t35 VSS 0.21333f
C1491 clk_h.t3 VSS 0.16493f
C1492 clk_h.n121 VSS 0.0573f
C1493 clk_h.t63 VSS 0.1246f
C1494 clk_h.n122 VSS 0.07079f
C1495 clk_h.t64 VSS 0.09595f
C1496 clk_h.t15 VSS 0.16493f
C1497 clk_h.n123 VSS 0.0573f
C1498 clk_h.n124 VSS 0.06037f
C1499 clk_h.n125 VSS 0.14271f
C1500 clk_h.n126 VSS 0.06037f
C1501 clk_h.t67 VSS 0.1246f
C1502 clk_h.n127 VSS 0.04537f
C1503 clk_h.t50 VSS 0.1246f
C1504 clk_h.n128 VSS 0.04424f
C1505 clk_h.n129 VSS 0.06037f
C1506 clk_h.n130 VSS 0.0711f
C1507 clk_h.t51 VSS 0.1246f
C1508 clk_h.n131 VSS 0.0711f
C1509 clk_h.t52 VSS 0.1246f
C1510 clk_h.n132 VSS 0.0711f
C1511 clk_h.n133 VSS 0.06037f
C1512 clk_h.n134 VSS 0.14271f
C1513 clk_h.n135 VSS 0.04424f
C1514 clk_h.n136 VSS 0.13004f
C1515 clk_h.n137 VSS 7.17927f
C1516 vin.n0 VSS 0.33954f
C1517 vin.n1 VSS 0.34215f
C1518 vin.n2 VSS 0.34197f
C1519 vin.n3 VSS 0.34682f
C1520 vin.n4 VSS 11.0217f
C1521 vin.n5 VSS 11.0708f
.ends
