* Extracted by KLayout with SG13CMOS5L LVS runset on : 27/09/2026 19:41

.SUBCKT ook_analog_system ACC_CAP Cap_M1 Cap_M11 Cap_M2 Cap_M21 VAPWR VGND VPWR
+ clk_fb clk_ref dac_out lnaf opm q0 q1 q2 q3 rst_ni rx_in tx_out vcl
+ vctrl_b_in vctrl_b_out vctrl_in vctrl_out vref0 vref1 vref2 vref3
X$613 VPWR \$2947 VGND \$2507 \$2626 \$3195 \$2773 sg13cmos5l_nand4_1
X$617 VPWR VGND \$2510 \$2506 \$2445 \$2507 \$2459 sg13cmos5l_or4_1
X$621 VGND \$3591 VPWR \$3469 \$2972 sg13cmos5l_xor2_1
X$622 VGND \$3556 VPWR \$3070 \$3372 sg13cmos5l_xor2_1
X$623 VGND \$1563 VPWR \$1544 \$504 sg13cmos5l_xor2_1
X$624 VGND \$1934 VPWR \$1932 \$1972 sg13cmos5l_xor2_1
X$625 VGND \$3756 VPWR \$4036 \$4037 sg13cmos5l_xor2_1
X$626 VGND \$1770 VPWR \$1774 \$1931 sg13cmos5l_xor2_1
X$627 VGND \$3565 VPWR \$3675 \$2623 sg13cmos5l_xor2_1
X$628 VGND \$3522 VPWR \$3104 \$2967 sg13cmos5l_xor2_1
X$629 VGND \$2853 VPWR \$2727 \$2624 sg13cmos5l_xor2_1
X$630 VGND \$3097 VPWR \$3095 \$3096 sg13cmos5l_xor2_1
X$631 VGND \$4015 VPWR \$3153 \$3909 sg13cmos5l_xor2_1
X$632 VGND \$3561 VPWR \$3241 \$2952 sg13cmos5l_xor2_1
X$633 VGND \$3774 VPWR \$3556 \$3555 sg13cmos5l_xor2_1
X$634 VGND \$2567 VPWR \$2571 \$2626 sg13cmos5l_xor2_1
X$635 VGND \$3554 VPWR \$3659 \$2432 sg13cmos5l_xor2_1
X$636 VGND \$3810 VPWR \$2952 \$3605 sg13cmos5l_xor2_1
X$637 VGND \$3577 VPWR \$3471 \$3047 sg13cmos5l_xor2_1
X$638 VGND \$2850 VPWR \$2714 \$3021 sg13cmos5l_xor2_1
X$639 VGND \$3278 VPWR \$2678 \$2967 sg13cmos5l_xor2_1
X$640 VGND \$2703 VPWR \$2550 \$2312 sg13cmos5l_xor2_1
X$641 VGND \$4037 VPWR \$2972 \$3923 sg13cmos5l_xor2_1
X$642 VGND \$2102 VPWR \$2173 \$1728 sg13cmos5l_xor2_1
X$710 VPWR VGND \$3936 \$2746 \$3768 sg13cmos5l_xnor2_1
X$711 VPWR VGND \$3559 \$3671 \$2952 sg13cmos5l_xnor2_1
X$712 VPWR VGND \$3914 \$2673 \$3912 sg13cmos5l_xnor2_1
X$713 VPWR VGND \$2546 \$2040 \$2473 sg13cmos5l_xnor2_1
X$714 VPWR VGND \$2219 \$2139 \$2224 sg13cmos5l_xnor2_1
X$715 VPWR VGND \$2322 \$2223 \$2224 sg13cmos5l_xnor2_1
X$716 VPWR VGND \$1823 \$1824 \$1859 sg13cmos5l_xnor2_1
X$717 VPWR VGND \$2550 \$685 \$2437 sg13cmos5l_xnor2_1
X$718 VPWR VGND \$2768 \$2674 \$2773 sg13cmos5l_xnor2_1
X$719 VPWR VGND \$2725 \$2567 \$2564 sg13cmos5l_xnor2_1
X$720 VPWR VGND \$3431 \$3174 \$2971 sg13cmos5l_xnor2_1
X$721 VPWR VGND \$3730 \$2623 \$3899 sg13cmos5l_xnor2_1
X$722 VPWR VGND \$504 \$995 \$917 sg13cmos5l_xnor2_1
X$723 VPWR VGND \$2844 \$2052 \$3070 sg13cmos5l_xnor2_1
X$724 VPWR VGND \$3933 \$3935 \$3929 sg13cmos5l_xnor2_1
X$725 VPWR VGND \$2727 \$2629 \$3153 sg13cmos5l_xnor2_1
X$726 VPWR VGND \$3397 \$3445 \$3195 sg13cmos5l_xnor2_1
X$727 VPWR VGND \$3620 \$3510 \$3259 sg13cmos5l_xnor2_1
X$728 VPWR VGND \$1486 \$1688 \$346 sg13cmos5l_xnor2_1
X$729 VPWR VGND \$3994 \$4033 \$4030 sg13cmos5l_xnor2_1
X$730 VPWR VGND \$2661 \$2819 \$2567 sg13cmos5l_xnor2_1
X$731 VPWR VGND \$3818 \$3776 \$3816 sg13cmos5l_xnor2_1
X$732 VPWR VGND \$1869 \$1873 \$1871 sg13cmos5l_xnor2_1
X$733 VPWR VGND \$1903 \$1936 \$259 sg13cmos5l_xnor2_1
X$734 VPWR VGND \$3848 \$3547 \$3639 sg13cmos5l_xnor2_1
X$735 VPWR VGND \$2714 \$2951 \$2947 sg13cmos5l_xnor2_1
X$736 VPWR VGND \$3156 \$2768 \$2829 sg13cmos5l_xnor2_1
X$737 VPWR VGND \$3287 \$3288 \$3096 sg13cmos5l_xnor2_1
X$738 VPWR VGND \$3659 \$2562 \$3604 sg13cmos5l_xnor2_1
X$739 VPWR VGND \$2430 \$2274 \$2216 sg13cmos5l_xnor2_1
X$740 VPWR VGND \$3071 \$2844 \$2710 sg13cmos5l_xnor2_1
X$741 VPWR VGND \$2460 \$685 \$2075 sg13cmos5l_xnor2_1
X$742 VPWR VGND \$3639 \$3474 \$2542 sg13cmos5l_xnor2_1
X$785 VPWR VGND \$1071 \$224 \$555 \$502 sg13cmos5l_or3_1
X$786 VPWR VGND \$3510 \$3153 \$2673 \$3471 sg13cmos5l_or3_1
X$804 VGND VPWR \$756 \$710 \$225 \$52 sg13cmos5l_nand3_1
X$805 VGND VPWR \$2637 \$2681 \$2678 \$2746 sg13cmos5l_nand3_1
X$806 VGND VPWR \$3232 \$3229 \$2481 \$3008 sg13cmos5l_nand3_1
X$807 VGND VPWR \$2964 \$2768 \$2823 \$2959 sg13cmos5l_nand3_1
X$808 VGND VPWR \$1802 \$861 \$1624 \$1739 sg13cmos5l_nand3_1
X$809 VGND VPWR \$2672 \$2532 \$2560 \$2673 sg13cmos5l_nand3_1
X$810 VPWR \$2241 VGND \$2506 \$2669 \$2746 \$2681 sg13cmos5l_nand4_1
X$811 VGND VPWR \$2899 \$2844 \$2595 \$2437 sg13cmos5l_nand3_1
X$812 VGND VPWR \$2250 \$2347 \$2353 \$2352 sg13cmos5l_nand3_1
X$813 VGND VPWR \$2907 \$1790 \$2560 \$2952 sg13cmos5l_nand3_1
X$814 VGND VPWR \$629 \$850 \$346 \$603 sg13cmos5l_nand3_1
X$815 VGND VPWR \$274 \$555 \$346 \$224 sg13cmos5l_nand3_1
X$816 VGND VPWR \$2728 \$2727 \$2665 \$2667 sg13cmos5l_nand3_1
X$817 VGND VPWR \$2568 \$2240 \$2094 \$2623 sg13cmos5l_nand3_1
X$818 VGND VPWR \$1433 \$1321 \$1205 \$1358 sg13cmos5l_nand3_1
X$819 VGND VPWR \$2657 \$2714 \$2713 \$2715 sg13cmos5l_nand3_1
X$820 VGND VPWR \$3445 \$2623 \$3241 \$2947 sg13cmos5l_nand3_1
X$824 VPWR VGND \$3430 \$3347 \$3435 \$3211 sg13cmos5l_a21o_1
X$825 VPWR VGND \$2719 \$2720 \$2616 \$2661 sg13cmos5l_a21o_1
X$826 VPWR VGND \$2710 \$2437 \$2040 \$1984 sg13cmos5l_a21o_1
X$827 VPWR VGND \$1960 \$1546 \$1559 \$125 sg13cmos5l_a21o_1
X$828 VPWR VGND \$3564 \$2230 \$3445 \$3313 sg13cmos5l_a21o_1
X$829 VPWR VGND \$2000 \$1917 \$861 \$1624 sg13cmos5l_a21o_1
X$830 VPWR VGND \$2233 \$2281 \$2051 \$1662 sg13cmos5l_a21o_1
X$831 VPWR VGND \$2353 \$2463 \$2462 \$2461 sg13cmos5l_a21o_1
X$832 VPWR VGND \$1999 \$1559 \$1811 \$2084 sg13cmos5l_a21o_1
X$833 VPWR VGND \$3929 \$4038 \$4037 \$4036 sg13cmos5l_a21o_1
X$834 VPWR VGND \$2022 \$2165 \$2096 \$2228 sg13cmos5l_a21o_1
X$835 VPWR VGND \$2713 \$2844 \$2437 \$2595 sg13cmos5l_a21o_1
X$836 VPWR VGND \$3313 \$2623 \$2947 \$3241 sg13cmos5l_a21o_1
X$837 VPWR VGND \$2823 \$2727 \$2667 \$2665 sg13cmos5l_a21o_1
X$838 VPWR VGND \$588 \$661 \$612 \$412 sg13cmos5l_a21o_1
X$839 VPWR VGND \$2220 \$2225 \$2096 \$2325 sg13cmos5l_a21o_1
X$840 VPWR VGND \$225 \$504 \$501 \$502 sg13cmos5l_a21o_1
X$841 VPWR VGND \$3693 \$3929 \$3768 \$2746 sg13cmos5l_a21o_1
X$855 VPWR VGND \$2182 \$1993 \$1961 \$2061 sg13cmos5l_nand3b_1
X$856 VPWR VGND \$1905 \$1624 \$2192 \$2064 sg13cmos5l_nand3b_1
X$857 VPWR VGND \$443 \$1071 \$555 \$850 sg13cmos5l_nand3b_1
X$873 VGND \$1654 \$1444 VPWR sg13cmos5l_buf_8
X$874 VGND \$1694 \$1652 VPWR sg13cmos5l_buf_8
X$875 VGND clk_ref \$578 VPWR sg13cmos5l_buf_8
X$876 VGND \$1210 \$1257 VPWR sg13cmos5l_buf_8
X$877 VGND \$1124 \$1696 VPWR sg13cmos5l_buf_8
X$878 VGND \$1165 \$1690 VPWR sg13cmos5l_buf_8
X$879 VGND \$578 \$3494 VPWR sg13cmos5l_buf_8
X$880 VGND \$578 \$2077 VPWR sg13cmos5l_buf_8
X$881 VGND \$1654 \$1885 VPWR sg13cmos5l_buf_8
X$882 VGND \$1306 \$1694 VPWR sg13cmos5l_buf_8
X$883 VGND \$1417 \$539 VPWR sg13cmos5l_buf_8
X$884 VGND \$1601 \$1124 VPWR sg13cmos5l_buf_8
X$885 VGND \$578 \$1969 VPWR sg13cmos5l_buf_8
X$886 VGND \$1706 \$1654 VPWR sg13cmos5l_buf_8
X$887 VGND \$1659 VPWR \$1546 \$995 sg13cmos5l_xor2_1
X$888 VGND \$578 \$76 VPWR sg13cmos5l_buf_8
X$889 VGND \$1165 \$675 VPWR sg13cmos5l_buf_8
X$890 VGND \$1124 \$526 VPWR sg13cmos5l_buf_8
X$891 VGND \$1304 \$1210 VPWR sg13cmos5l_buf_8
X$892 VGND \$1306 \$1212 VPWR sg13cmos5l_buf_8
X$893 VGND \$578 \$1567 VPWR sg13cmos5l_buf_8
X$894 VGND \$578 \$1175 VPWR sg13cmos5l_buf_8
X$895 VGND \$578 \$3527 VPWR sg13cmos5l_buf_8
X$896 VGND \$1212 \$1165 VPWR sg13cmos5l_buf_8
X$897 VGND \$1258 \$1601 VPWR sg13cmos5l_buf_8
X$898 VGND \$1258 \$1417 VPWR sg13cmos5l_buf_8
X$899 VGND \$1304 \$1706 VPWR sg13cmos5l_buf_8
X$900 VPWR VGND \$2972 \$2967 \$2736 \$2963 \$2864 sg13cmos5l_nor4_1
X$901 VPWR VGND \$917 \$603 \$995 \$1071 \$291 sg13cmos5l_nor4_1
X$902 VPWR VGND \$3070 \$2562 \$2952 \$2703 \$3675 sg13cmos5l_nor4_1
X$903 VPWR VGND \$2972 \$3047 \$2746 \$3471 \$2680 sg13cmos5l_nor4_1
X$904 VPWR VGND \$2510 \$2445 \$2507 \$2506 \$2230 sg13cmos5l_nor4_1
X$905 VPWR VGND \$719 \$1206 \$912 \$1046 \$1074 sg13cmos5l_nor4_1
X$906 VPWR VGND \$935 \$1455 \$1363 \$719 \$1321 sg13cmos5l_nor4_1
X$907 VPWR VGND \$1769 \$1928 \$1774 \$2094 \$2312 sg13cmos5l_nor4_1
X$908 VPWR VGND \$685 \$352 \$465 \$579 \$744 sg13cmos5l_nor4_1
X$909 VGND \$954 \$224 \$91 \$348 VPWR sg13cmos5l_mux2_1
X$910 VGND \$2687 \$2192 \$2243 \$2686 VPWR sg13cmos5l_mux2_1
X$911 VGND \$2840 \$2192 \$2426 \$2680 VPWR sg13cmos5l_mux2_1
X$912 VGND \$2700 \$1984 \$2546 \$2437 VPWR sg13cmos5l_mux2_1
X$913 VGND \$936 \$612 \$1228 \$661 VPWR sg13cmos5l_mux2_1
X$914 VGND \$2595 \$2312 \$2550 \$2546 VPWR sg13cmos5l_mux2_1
X$915 \$408 VGND VPWR \$412 \$97 \$950 \$194 sg13cmos5l_a22oi_1
X$916 \$3066 VGND VPWR \$2426 \$2981 \$2982 \$2241 sg13cmos5l_a22oi_1
X$917 \$851 VGND VPWR \$852 \$1071 \$1058 \$847 sg13cmos5l_a22oi_1
X$918 \$1935 VGND VPWR \$2004 \$2022 \$1976 \$1977 sg13cmos5l_a22oi_1
X$919 \$195 VGND VPWR \$847 \$995 \$661 \$612 sg13cmos5l_a22oi_1
X$920 \$774 VGND VPWR \$840 \$396 \$442 \$17 sg13cmos5l_a22oi_1
X$921 \$518 VGND VPWR \$661 \$612 \$965 \$850 sg13cmos5l_a22oi_1
X$922 \$2981 VGND VPWR \$3101 \$2542 \$2243 \$2926 sg13cmos5l_a22oi_1
X$923 \$583 VGND VPWR \$195 \$659 \$582 \$404 sg13cmos5l_a22oi_1
X$924 \$2585 VGND VPWR \$2687 \$2305 \$2647 \$2197 sg13cmos5l_a22oi_1
X$925 \$2213 VGND VPWR \$1999 \$2220 \$2308 \$2224 sg13cmos5l_a22oi_1
X$926 \$878 VGND VPWR \$412 \$880 \$950 \$949 sg13cmos5l_a22oi_1
X$927 \$496 VGND VPWR \$588 \$396 \$718 \$17 sg13cmos5l_a22oi_1
X$928 VPWR VGND \$719 \$561 \$788 \$859 sg13cmos5l_or3_1
X$929 \$516 VGND VPWR \$291 \$16 \$556 \$174 sg13cmos5l_a22oi_1
X$1082 \$2861 \$3751 \$3625 VPWR VGND sg13cmos5l_or2_1
X$1083 \$2084 \$2461 \$2576 VPWR VGND sg13cmos5l_or2_1
X$1084 \$3008 \$3077 \$2052 VPWR VGND sg13cmos5l_or2_1
X$1085 \$2437 \$2481 \$1984 VPWR VGND sg13cmos5l_or2_1
X$1086 \$917 \$1228 \$995 VPWR VGND sg13cmos5l_or2_1
X$1087 \$935 \$1206 \$1299 VPWR VGND sg13cmos5l_or2_1
X$1088 \$2311 \$2309 \$2134 VPWR VGND sg13cmos5l_or2_1
X$1089 \$17 \$399 \$588 VPWR VGND sg13cmos5l_or2_1
X$1090 \$2004 \$3584 \$3649 VPWR VGND sg13cmos5l_or2_1
X$1091 \$1011 \$793 \$852 VPWR VGND sg13cmos5l_or2_1
X$1092 \$259 \$2034 \$443 VPWR VGND sg13cmos5l_or2_1
X$1093 \$352 \$573 \$465 VPWR VGND sg13cmos5l_or2_1
X$1094 VGND VPWR \$3974 \$3731 \$4109 sg13cmos5l_nor2b_1
X$1095 VGND VPWR \$3979 \$4018 \$3913 sg13cmos5l_nor2b_1
X$1096 VGND VPWR \$2810 \$2716 \$2657 sg13cmos5l_nor2b_1
X$1097 VGND VPWR \$3160 \$2963 \$2964 sg13cmos5l_nor2b_1
X$1098 VGND VPWR \$3437 \$3671 \$3967 sg13cmos5l_nor2b_1
X$1099 VGND VPWR \$1058 \$850 \$917 sg13cmos5l_nor2b_1
X$1100 VGND VPWR \$4033 \$3992 \$3990 sg13cmos5l_nor2b_1
X$1101 VGND VPWR \$3104 \$2507 \$3241 sg13cmos5l_nor2b_1
X$1102 VGND VPWR \$301 \$555 \$850 sg13cmos5l_nor2b_1
X$1103 VGND VPWR \$2173 \$2051 \$1873 sg13cmos5l_nor2b_1
X$1104 VGND VPWR \$3309 \$3241 \$3232 sg13cmos5l_nor2b_1
X$1105 VGND VPWR \$1530 \$1455 \$746 sg13cmos5l_nor2b_1
X$1171 VGND \$608 VPWR \$480 \$573 \$579 \$52 \$463 sg13cmos5l_a221oi_1
X$1172 VGND \$2853 VPWR \$2956 \$2084 \$2915 \$2616 \$2858 sg13cmos5l_a221oi_1
X$1173 VGND \$3156 VPWR \$3274 \$2920 \$2915 \$2616 \$3160 sg13cmos5l_a221oi_1
X$1174 VGND \$3565 VPWR \$3495 \$2227 \$2328 \$2933 \$3564 sg13cmos5l_a221oi_1
X$1175 VGND \$2850 VPWR \$2941 \$2933 \$2915 \$2616 \$2810 sg13cmos5l_a221oi_1
X$1176 VGND \$2700 VPWR \$2998 \$2933 \$2915 \$2595 \$2616 sg13cmos5l_a221oi_1
X$1177 VGND \$3071 VPWR \$3300 \$2933 \$2915 \$2616 \$2940 sg13cmos5l_a221oi_1
X$1178 VGND \$1107 VPWR \$1624 \$905 \$125 \$1433 \$979 sg13cmos5l_a221oi_1
X$1179 VGND \$2227 VPWR \$2225 \$2322 \$2328 \$2119 \$2230 sg13cmos5l_a221oi_1
X$1180 VGND \$283 VPWR \$270 \$170 \$228 \$16 \$48 sg13cmos5l_a221oi_1
X$1181 VGND \$3591 VPWR \$3649 \$2227 \$2463 \$2920 \$3467 sg13cmos5l_a221oi_1
X$1182 VGND \$3555 VPWR \$3558 \$3556 \$3371 \$3605 \$2952 sg13cmos5l_a221oi_1
X$1183 VGND \$950 VPWR \$1421 \$1652 \$1647 \$1257 \$1058 sg13cmos5l_a221oi_1
X$1184 VGND \$3627 VPWR \$3625 \$2227 \$2463 \$2920 \$3511 sg13cmos5l_a221oi_1
X$1185 VGND \$413 VPWR \$734 \$1421 \$346 \$878 \$1176 sg13cmos5l_a221oi_1
X$1186 VGND \$2090 VPWR \$2165 \$2227 \$2328 \$2084 \$2230 sg13cmos5l_a221oi_1
X$1187 VGND \$1058 VPWR \$1176 \$1127 \$603 \$441 \$301 sg13cmos5l_a221oi_1
X$1188 VGND \$3278 VPWR \$3276 \$2920 \$2915 \$2863 \$3094 sg13cmos5l_a221oi_1
X$1189 VGND \$3287 VPWR \$3282 \$2920 \$2915 \$2863 \$3097 sg13cmos5l_a221oi_1
X$1190 VGND \$2243 VPWR \$2096 \$2241 \$2116 \$2000 \$1802 sg13cmos5l_a221oi_1
X$1191 VPWR VGND \$995 \$917 \$847 sg13cmos5l_nand2b_1
X$1192 VPWR VGND \$2309 \$2324 \$2274 sg13cmos5l_nand2b_1
X$1193 VPWR VGND \$3675 \$2623 \$3510 sg13cmos5l_nand2b_1
X$1194 VPWR VGND \$1105 \$1078 \$1046 sg13cmos5l_nand2b_1
X$1195 VPWR VGND \$651 \$25 \$608 sg13cmos5l_nand2b_1
X$1196 VPWR VGND \$51 \$1709 \$1662 sg13cmos5l_nand2b_1
X$1197 VPWR VGND \$2273 \$2223 \$2090 sg13cmos5l_nand2b_1
X$1198 VPWR VGND \$555 \$850 \$965 sg13cmos5l_nand2b_1
X$1199 VPWR VGND \$52 \$195 \$322 sg13cmos5l_nand2b_1
X$1200 VPWR VGND \$3046 \$3095 \$3094 sg13cmos5l_nand2b_1
X$1201 VPWR VGND \$3469 \$2972 \$3590 sg13cmos5l_nand2b_1
X$1202 VPWR VGND \$1916 \$1739 \$1917 sg13cmos5l_nand2b_1
X$1203 VPWR VGND \$1936 \$1546 \$2086 sg13cmos5l_nand2_1
X$1204 VPWR VGND \$1902 \$1928 \$1769 sg13cmos5l_nand2_1
X$1205 VPWR VGND \$2405 \$2061 \$1662 sg13cmos5l_nand2_1
X$1206 VPWR VGND \$2629 \$1882 \$2560 sg13cmos5l_nand2_1
X$1207 VPWR VGND \$3288 \$2967 \$2678 sg13cmos5l_nand2_1
X$1208 VPWR VGND \$2633 \$2456 \$2576 sg13cmos5l_nand2_1
X$1209 VPWR VGND \$2576 \$2682 \$2680 sg13cmos5l_nand2_1
X$1210 VPWR VGND \$2674 \$2532 \$2560 sg13cmos5l_nand2_1
X$1211 VPWR VGND \$2088 \$1058 \$1544 sg13cmos5l_nand2_1
X$1212 VPWR VGND \$2571 \$2240 \$2094 sg13cmos5l_nand2_1
X$1213 VPWR VGND \$2338 \$2283 \$1662 sg13cmos5l_nand2_1
X$1214 VPWR VGND \$2073 \$1774 \$2004 sg13cmos5l_nand2_1
X$1215 VPWR VGND \$1747 \$1888 \$1662 sg13cmos5l_nand2_1
X$1216 VPWR VGND \$3101 \$2681 \$2678 sg13cmos5l_nand2_1
X$1217 VPWR VGND \$840 \$710 \$913 sg13cmos5l_nand2_1
X$1218 VPWR VGND \$1943 \$1873 \$1662 sg13cmos5l_nand2_1
X$1219 VPWR VGND \$2063 \$1961 \$1662 sg13cmos5l_nand2_1
X$1220 VPWR VGND \$2647 \$2197 \$2840 sg13cmos5l_nand2_1
X$1221 VPWR VGND \$2916 \$2241 \$2243 sg13cmos5l_nand2_1
X$1222 VPWR VGND \$2228 \$2090 \$2616 sg13cmos5l_nand2_1
X$1223 VPWR VGND \$3822 \$3153 \$2861 sg13cmos5l_nand2_1
X$1224 VPWR VGND \$2915 \$2463 \$2916 sg13cmos5l_nand2_1
X$1225 VPWR VGND \$3552 \$2241 \$3474 sg13cmos5l_nand2_1
X$1226 VPWR VGND \$2951 \$1790 \$2560 sg13cmos5l_nand2_1
X$1227 VPWR VGND \$303 \$347 \$301 sg13cmos5l_nand2_1
X$1229 VPWR VGND \$335 \$174 \$518 sg13cmos5l_nand2_1
X$1230 VPWR VGND \$3323 \$2623 \$2861 sg13cmos5l_nand2_1
X$1231 VPWR VGND \$2325 \$2616 \$2322 sg13cmos5l_nand2_1
X$1232 VPWR VGND \$719 \$793 \$746 sg13cmos5l_nand2_1
X$1233 VPWR VGND \$2959 \$3153 \$2629 sg13cmos5l_nand2_1
X$1234 VPWR VGND \$3750 \$2972 \$2004 sg13cmos5l_nand2_1
X$1235 VPWR VGND \$331 \$404 \$225 sg13cmos5l_nand2_1
X$1236 VPWR VGND \$501 \$603 \$346 sg13cmos5l_nand2_1
X$1237 VPWR VGND \$2119 \$1624 \$1664 sg13cmos5l_nand2_1
X$1238 VPWR VGND \$2347 \$2460 \$2096 sg13cmos5l_nand2_1
X$1239 VPWR VGND \$3865 \$3909 \$3153 sg13cmos5l_nand2_1
X$1240 VPWR VGND \$1140 \$612 \$301 sg13cmos5l_nand2_1
X$1241 VPWR VGND \$1811 \$861 \$1624 sg13cmos5l_nand2_1
X$1242 VPWR VGND \$1972 \$1931 \$1774 sg13cmos5l_nand2_1
X$1243 VPWR VGND \$3627 \$3471 \$3509 sg13cmos5l_nand2_1
X$1244 VPWR VGND \$2217 \$1859 \$1824 sg13cmos5l_nand2_1
X$1245 VPWR VGND \$275 \$93 \$274 sg13cmos5l_nand2_1
X$1246 VPWR VGND \$3683 \$2673 \$2861 sg13cmos5l_nand2_1
X$1247 VPWR VGND \$3972 \$3604 \$2562 sg13cmos5l_nand2_1
X$1248 VPWR VGND \$556 \$852 \$965 sg13cmos5l_nand2_1
X$1249 VPWR VGND \$2914 \$2751 \$2861 sg13cmos5l_nand2_1
X$1250 VPWR VGND \$3436 \$2947 \$2861 sg13cmos5l_nand2_1
X$1251 VPWR VGND \$3363 \$2989 \$2861 sg13cmos5l_nand2_1
X$1252 VPWR VGND \$2118 \$2071 \$1662 sg13cmos5l_nand2_1
X$1253 VPWR VGND \$3990 \$3953 \$3047 sg13cmos5l_nand2_1
X$1254 VPWR VGND \$2667 \$2626 \$2571 sg13cmos5l_nand2_1
X$1255 VPWR VGND \$3415 \$2967 \$2861 sg13cmos5l_nand2_1
X$1256 VPWR VGND \$1876 \$1728 \$1662 sg13cmos5l_nand2_1
X$1257 VPWR VGND \$442 \$502 \$443 sg13cmos5l_nand2_1
X$1258 VPWR VGND \$852 \$501 \$502 sg13cmos5l_nand2_1
X$1259 VPWR VGND \$2715 \$3070 \$2052 sg13cmos5l_nand2_1
X$1260 VPWR VGND \$3229 \$2562 \$2560 sg13cmos5l_nand2_1
X$1261 VPWR VGND \$413 \$539 \$412 sg13cmos5l_nand2_1
X$1262 VPWR VGND \$3211 \$2463 \$3066 sg13cmos5l_nand2_1
X$1266 VPWR VGND \$2681 \$2967 \$2972 sg13cmos5l_and2_1
X$1267 VPWR VGND \$330 \$399 \$292 sg13cmos5l_and2_1
X$1268 VPWR VGND \$990 \$612 \$504 sg13cmos5l_and2_1
X$1269 VPWR VGND \$2227 \$2456 \$2576 sg13cmos5l_and2_1
X$1270 VPWR VGND \$3123 \$3008 \$2052 sg13cmos5l_and2_1
X$1271 VPWR VGND \$1558 \$1538 \$1177 sg13cmos5l_and2_1
X$1272 VPWR VGND \$3174 \$2681 \$3104 sg13cmos5l_and2_1
X$1273 VPWR VGND \$643 \$327 \$290 sg13cmos5l_and2_1
X$1274 VPWR VGND \$4038 \$3925 \$2972 sg13cmos5l_and2_1
X$1275 VPWR VGND \$2940 \$2713 \$2899 sg13cmos5l_and2_1
X$1276 VPWR VGND \$2456 \$1624 \$1664 sg13cmos5l_and2_1
X$1277 VPWR VGND \$3371 \$3372 \$3070 sg13cmos5l_and2_1
X$1278 VPWR VGND \$2858 \$2823 \$2728 sg13cmos5l_and2_1
X$1279 VPWR VGND \$412 \$555 \$850 sg13cmos5l_and2_1
X$1280 VPWR VGND \$974 \$1530 \$1531 sg13cmos5l_and2_1
X$1281 VPWR VGND \$343 \$603 \$346 sg13cmos5l_and2_1
X$1282 VPWR VGND \$579 \$25 \$629 sg13cmos5l_and2_1
X$1283 VPWR VGND \$2820 \$2952 \$2951 sg13cmos5l_and2_1
X$1284 VPWR VGND \$3690 \$2241 \$2680 sg13cmos5l_and2_1
X$1285 VPWR VGND \$290 \$397 \$82 sg13cmos5l_and2_1
X$1286 VPWR VGND \$2736 \$2673 \$2674 sg13cmos5l_and2_1
X$1287 VPWR VGND \$1664 \$789 \$974 sg13cmos5l_and2_1
X$1288 VPWR VGND \$1544 \$1433 \$979 sg13cmos5l_and2_1
X$1289 VPWR VGND \$4017 \$3899 \$2623 sg13cmos5l_and2_1
X$1290 VPWR VGND \$1326 \$591 \$1140 sg13cmos5l_and2_1
X$1291 VPWR VGND \$82 \$58 \$30 sg13cmos5l_and2_1
X$1292 VPWR VGND \$30 \$174 \$150 sg13cmos5l_and2_1
X$1293 VPWR VGND \$2324 \$2311 \$2134 sg13cmos5l_and2_1
X$1294 VGND \$2665 VPWR \$2567 \$2716 \$2820 sg13cmos5l_o21ai_1
X$1295 VGND \$2252 VPWR \$2073 \$2250 \$2354 sg13cmos5l_o21ai_1
X$1296 VGND \$3450 VPWR \$3319 \$3620 \$2633 sg13cmos5l_o21ai_1
X$1297 VGND \$2462 VPWR \$2460 \$2459 \$2456 sg13cmos5l_o21ai_1
X$1298 VGND \$3460 VPWR \$2352 \$3582 \$2463 sg13cmos5l_o21ai_1
X$1299 VGND \$3368 VPWR \$3488 \$3437 \$2633 sg13cmos5l_o21ai_1
X$1300 VGND \$512 VPWR \$331 \$556 \$16 sg13cmos5l_o21ai_1
X$1301 VGND \$2624 VPWR \$2568 \$2567 \$2564 sg13cmos5l_o21ai_1
X$1302 VGND \$1915 VPWR \$1876 \$1957 \$1905 sg13cmos5l_o21ai_1
X$1303 VGND \$856 VPWR \$174 \$685 \$990 sg13cmos5l_o21ai_1
X$1304 VGND \$20 VPWR \$125 \$150 \$174 sg13cmos5l_o21ai_1
X$1305 VGND \$3550 VPWR \$3552 \$3547 \$3551 sg13cmos5l_o21ai_1
X$1306 VGND \$1992 VPWR \$2063 \$2055 \$1905 sg13cmos5l_o21ai_1
X$1307 VGND \$3446 VPWR \$3323 \$3248 \$3495 sg13cmos5l_o21ai_1
X$1308 VGND \$417 VPWR \$516 \$512 \$480 sg13cmos5l_o21ai_1
X$1309 VGND \$3021 VPWR \$3077 \$3123 \$2710 sg13cmos5l_o21ai_1
X$1310 VGND \$2053 VPWR \$2338 \$2397 \$1905 sg13cmos5l_o21ai_1
X$1311 VGND \$2678 VPWR \$2672 \$2824 \$2829 sg13cmos5l_o21ai_1
X$1312 VGND \$3301 VPWR \$2352 \$3368 \$2328 sg13cmos5l_o21ai_1
X$1313 VGND \$3547 VPWR \$3693 \$2746 \$3768 sg13cmos5l_o21ai_1
X$1314 VGND \$660 VPWR \$16 \$661 \$716 sg13cmos5l_o21ai_1
X$1315 VGND VPWR \$585 \$710 \$660 \$335 sg13cmos5l_nand3_1
X$1316 VGND \$3582 VPWR \$3633 \$3577 \$2633 sg13cmos5l_o21ai_1
X$1317 VGND \$2055 VPWR \$2182 \$1993 \$1961 sg13cmos5l_o21ai_1
X$1318 VGND \$1635 VPWR \$1532 \$1558 \$1534 sg13cmos5l_o21ai_1
X$1319 VGND \$3633 VPWR \$2920 \$3522 \$2230 sg13cmos5l_o21ai_1
X$1320 VGND \$3913 VPWR \$4015 \$3731 \$4017 sg13cmos5l_o21ai_1
X$1321 VGND \$3046 VPWR \$3047 \$2963 \$2736 sg13cmos5l_o21ai_1
X$1322 VGND \$3488 VPWR \$2933 \$3309 \$2230 sg13cmos5l_o21ai_1
X$1323 VGND \$2040 VPWR \$2043 \$443 \$259 sg13cmos5l_o21ai_1
X$1324 VGND \$3560 VPWR \$2933 \$3561 \$2230 sg13cmos5l_o21ai_1
X$1325 VGND \$2800 VPWR \$2914 \$2998 \$3117 sg13cmos5l_o21ai_1
X$1326 VGND \$1688 VPWR \$1546 \$1551 \$1775 sg13cmos5l_o21ai_1
X$1327 VGND \$3319 VPWR \$2933 \$3397 \$2230 sg13cmos5l_o21ai_1
X$1328 VGND \$2086 VPWR \$2088 \$1544 \$847 sg13cmos5l_o21ai_1
X$1329 VGND \$4109 VPWR \$3730 \$3558 \$3729 sg13cmos5l_o21ai_1
X$1330 VGND \$3511 VPWR \$2459 \$3324 \$3104 sg13cmos5l_o21ai_1
X$1331 VGND \$3467 VPWR \$2459 \$3337 \$3174 sg13cmos5l_o21ai_1
X$1332 VGND \$1647 VPWR \$603 \$847 \$1411 sg13cmos5l_o21ai_1
X$1333 VGND \$934 VPWR \$591 \$847 \$501 sg13cmos5l_o21ai_1
X$1334 VGND \$1531 VPWR \$793 \$1363 \$1326 sg13cmos5l_o21ai_1
X$1335 VGND \$2117 VPWR \$2118 \$2119 \$1709 sg13cmos5l_o21ai_1
X$1336 VGND \$3001 VPWR \$2933 \$2805 \$2230 sg13cmos5l_o21ai_1
X$1337 VGND \$2982 VPWR \$2456 \$2864 \$2926 sg13cmos5l_o21ai_1
X$1338 VGND \$3484 VPWR \$2352 \$3609 \$2328 sg13cmos5l_o21ai_1
X$1339 VGND \$3555 VPWR \$3972 \$3659 \$2432 sg13cmos5l_o21ai_1
X$1340 VGND \$3117 VPWR \$2352 \$2931 \$2328 sg13cmos5l_o21ai_1
X$1341 VGND \$3838 VPWR \$3683 \$3751 \$3274 sg13cmos5l_o21ai_1
X$1342 VGND \$2052 VPWR \$1907 \$443 \$259 sg13cmos5l_o21ai_1
X$1343 VGND \$789 VPWR \$832 \$490 \$664 sg13cmos5l_o21ai_1
X$1344 VGND \$788 VPWR \$862 \$936 \$83 sg13cmos5l_o21ai_1
X$1345 VGND \$3480 VPWR \$3436 \$2941 \$3484 sg13cmos5l_o21ai_1
X$1346 VGND \$2273 VPWR \$1769 \$2094 \$1774 sg13cmos5l_o21ai_1
X$1347 VGND \$4036 VPWR \$3990 \$3992 \$4113 sg13cmos5l_o21ai_1
X$1348 VGND \$283 VPWR \$164 \$282 \$249 sg13cmos5l_o21ai_1
X$1349 VGND \$885 VPWR \$736 \$954 \$443 sg13cmos5l_o21ai_1
X$1350 VGND \$3218 VPWR \$3363 \$3300 \$3301 sg13cmos5l_o21ai_1
X$1351 VGND \$1782 VPWR \$1943 \$1909 \$1905 sg13cmos5l_o21ai_1
X$1352 VGND \$1631 VPWR \$1747 \$1811 \$1709 sg13cmos5l_o21ai_1
X$1353 VGND \$783 VPWR \$756 \$851 \$659 sg13cmos5l_o21ai_1
X$1354 VGND \$3509 VPWR \$2673 \$3510 \$3153 sg13cmos5l_o21ai_1
X$1355 VGND \$3631 VPWR \$3415 \$3460 \$3276 sg13cmos5l_o21ai_1
X$1356 VGND \$3248 VPWR \$2352 \$2719 \$2915 sg13cmos5l_o21ai_1
X$1357 VGND \$285 VPWR \$322 \$282 \$249 sg13cmos5l_o21ai_1
X$1358 VGND \$3623 VPWR \$2352 \$3450 \$2328 sg13cmos5l_o21ai_1
X$1359 VGND \$2216 VPWR \$2217 \$1823 \$1972 sg13cmos5l_o21ai_1
X$1360 VGND \$1105 VPWR \$83 \$936 \$685 sg13cmos5l_o21ai_1
X$1361 VGND \$1205 VPWR \$1074 \$776 \$1051 sg13cmos5l_o21ai_1
X$1362 VGND \$854 VPWR \$784 \$783 \$828 sg13cmos5l_o21ai_1
X$1363 VGND \$864 VPWR \$794 \$643 \$669 sg13cmos5l_o21ai_1
X$1364 VGND \$1358 VPWR \$934 \$788 \$775 sg13cmos5l_o21ai_1
X$1365 VGND \$861 VPWR \$974 \$859 \$554 sg13cmos5l_o21ai_1
X$1366 VGND \$2931 VPWR \$3001 \$2633 \$2703 sg13cmos5l_o21ai_1
X$1367 VGND \$3823 VPWR \$3822 \$3623 \$2956 sg13cmos5l_o21ai_1
X$1368 VGND \$3609 VPWR \$3560 \$3559 \$2633 sg13cmos5l_o21ai_1
X$1369 VGND \$3685 VPWR \$3750 \$3282 \$3584 sg13cmos5l_o21ai_1
X$1370 VGND \$3967 VPWR \$3070 \$2703 \$2562 sg13cmos5l_o21ai_1
X$1811 VPWR VGND \$2963 \$3095 \$2736 \$2967 sg13cmos5l_nor3_1
X$1812 VPWR VGND \$1558 \$1557 \$1547 \$51 sg13cmos5l_nor3_1
X$1813 VPWR VGND \$2094 \$2223 \$1774 \$1769 sg13cmos5l_nor3_1
X$1814 VPWR VGND \$3558 \$3731 \$3730 \$3729 sg13cmos5l_nor3_1
X$1815 VPWR VGND \$1177 \$1081 \$1082 \$51 sg13cmos5l_nor3_1
X$1816 VPWR VGND \$685 \$928 \$990 \$174 sg13cmos5l_nor3_1
X$1817 VPWR VGND \$2703 \$3671 \$3070 \$2562 sg13cmos5l_nor3_1
X$1818 VPWR VGND \$643 \$394 \$547 \$12 sg13cmos5l_nor3_1
X$1819 VPWR VGND \$1544 \$1775 \$847 \$259 sg13cmos5l_nor3_1
X$1820 VPWR VGND \$1299 \$1363 \$935 \$1105 sg13cmos5l_nor3_1
X$1821 VPWR VGND \$290 \$108 \$262 \$12 sg13cmos5l_nor3_1
X$1822 VPWR VGND \$1952 \$2281 \$1905 \$2051 sg13cmos5l_nor3_1
X$1823 VPWR VGND \$626 \$828 \$708 \$744 sg13cmos5l_nor3_1
X$1824 VPWR VGND \$3342 \$3595 \$3594 \$2463 sg13cmos5l_nor3_1
X$1825 VPWR VGND \$27 \$207 \$93 \$12 sg13cmos5l_nor3_1
X$1826 VGND \$275 VPWR \$282 \$318 \$352 \$14 \$223 sg13cmos5l_a221oi_1
X$1827 VPWR VGND \$59 \$171 \$156 \$12 sg13cmos5l_nor3_1
X$1828 VPWR VGND \$150 \$152 \$107 \$12 sg13cmos5l_nor3_1
X$1829 VPWR VGND \$936 \$1078 \$1076 \$83 sg13cmos5l_nor3_1
X$1830 VPWR VGND \$1010 \$1140 \$591 sg13cmos5l_xnor2_1
X$1831 VPWR VGND \$2094 \$2139 \$1693 \$1977 sg13cmos5l_nor3_1
X$1832 VPWR VGND \$346 \$661 \$555 \$224 sg13cmos5l_nor3_1
X$1833 VPWR VGND \$291 \$401 \$343 \$174 sg13cmos5l_nor3_1
X$1834 VPWR VGND \$4015 \$4018 \$3731 \$4017 sg13cmos5l_nor3_1
X$1835 VPWR VGND \$2542 \$2426 \$2463 \$2354 sg13cmos5l_and3_1
X$1836 VPWR VGND \$2283 \$2173 \$1790 \$1993 sg13cmos5l_and3_1
X$1837 VPWR VGND \$603 \$346 \$850 \$651 sg13cmos5l_and3_1
X$1838 VPWR VGND \$603 \$1544 \$1058 \$1551 sg13cmos5l_and3_1
X$1839 VPWR VGND \$967 \$643 \$591 \$1177 sg13cmos5l_and3_1
X$1840 VPWR VGND \$2926 \$2864 \$2456 \$2426 sg13cmos5l_and3_1
X$1841 VPWR VGND \$3865 \$3914 \$3913 \$3985 sg13cmos5l_and3_1
X$1842 VPWR VGND \$1961 \$1993 \$2061 \$1952 sg13cmos5l_and3_1
X$1843 VPWR VGND \$2907 \$2904 sg13cmos5l_inv_1
X$1844 VPWR VGND \$1774 \$1693 sg13cmos5l_inv_1
X$1845 VPWR VGND \$441 \$440 sg13cmos5l_inv_1
X$1846 VPWR VGND \$2746 \$2926 sg13cmos5l_inv_1
X$1847 VPWR VGND \$774 \$776 sg13cmos5l_inv_1
X$1848 VPWR VGND \$1372 \$1411 sg13cmos5l_inv_1
X$1849 VPWR VGND \$2768 \$2824 sg13cmos5l_inv_1
X$1850 VPWR VGND \$446 \$348 sg13cmos5l_inv_1
X$1851 VPWR VGND \$64 \$121 sg13cmos5l_inv_1
X$1852 VPWR VGND \$16 \$659 sg13cmos5l_inv_1
X$1853 VPWR VGND \$194 \$437 sg13cmos5l_inv_1
X$1854 VPWR VGND \$1715 \$1813 sg13cmos5l_inv_1
X$1855 VPWR VGND \$949 \$1668 sg13cmos5l_inv_1
X$1856 VPWR VGND \$880 \$1475 sg13cmos5l_inv_1
X$1857 VPWR VGND \$52 \$404 sg13cmos5l_inv_1
X$1858 VPWR VGND \$1696 \$1606 sg13cmos5l_inv_1
X$1859 VPWR VGND \$1871 \$2043 sg13cmos5l_inv_1
X$1860 VPWR VGND \$1690 \$1604 sg13cmos5l_inv_1
X$1861 VPWR VGND \$864 \$888 sg13cmos5l_inv_1
X$1862 VPWR VGND \$347 \$445 sg13cmos5l_inv_1
X$1863 VPWR VGND \$97 \$380 sg13cmos5l_inv_1
X$1864 VPWR VGND \$1824 \$1977 sg13cmos5l_inv_1
X$1865 VPWR VGND \$496 \$497 sg13cmos5l_inv_1
X$1866 VPWR VGND \$3070 \$3008 sg13cmos5l_inv_1
X$1867 VPWR VGND \$1916 \$2114 sg13cmos5l_inv_1
X$1868 VPWR VGND \$2542 \$2305 sg13cmos5l_inv_1
X$1869 VPWR VGND \$1127 \$1674 sg13cmos5l_inv_1
X$1870 VPWR VGND \$168 \$166 sg13cmos5l_inv_1
X$1871 VPWR VGND \$2134 \$2224 sg13cmos5l_inv_1
X$1872 VPWR VGND \$2562 \$2437 sg13cmos5l_inv_1
X$1873 VPWR VGND \$1885 \$1703 sg13cmos5l_inv_1
X$1874 VPWR VGND \$50 \$140 sg13cmos5l_inv_1
X$1875 VPWR VGND \$3153 \$3259 sg13cmos5l_inv_1
X$1876 VPWR VGND \$225 \$463 sg13cmos5l_inv_1
X$1877 \$2829 VGND \$2727 VPWR \$2624 \$3090 sg13cmos5l_a21oi_1
X$1878 \$794 VGND \$643 VPWR \$669 \$51 sg13cmos5l_a21oi_1
X$1879 \$3241 VGND \$2481 VPWR \$3229 \$3008 sg13cmos5l_a21oi_1
X$1880 \$784 VGND \$851 VPWR \$659 \$928 sg13cmos5l_a21oi_1
X$1881 \$746 VGND \$852 VPWR \$1011 \$1179 sg13cmos5l_a21oi_1
X$1882 \$970 VGND \$643 VPWR \$591 \$967 sg13cmos5l_a21oi_1
X$1883 \$2192 VGND \$1802 VPWR \$2000 \$2116 sg13cmos5l_a21oi_1
X$1884 \$2116 VGND \$1664 VPWR \$1624 \$2114 sg13cmos5l_a21oi_1
X$1885 \$2432 VGND \$2309 VPWR \$2216 \$2324 sg13cmos5l_a21oi_1
X$1886 \$533 VGND \$408 VPWR \$303 \$501 sg13cmos5l_a21oi_1
X$1887 \$775 VGND \$691 VPWR \$634 \$664 sg13cmos5l_a21oi_1
X$1888 \$2963 VGND \$2823 VPWR \$2959 \$2768 sg13cmos5l_a21oi_1
X$1889 \$2156 VGND \$2094 VPWR \$1693 \$1902 sg13cmos5l_a21oi_1
X$1890 \$2805 VGND \$2550 VPWR \$1984 \$2754 sg13cmos5l_a21oi_1
X$1891 \$70 VGND \$27 VPWR \$25 \$52 sg13cmos5l_a21oi_1
X$1892 \$1299 VGND \$710 VPWR \$1140 \$591 sg13cmos5l_a21oi_1
X$1893 \$2924 VGND \$3174 VPWR \$2971 \$2305 sg13cmos5l_a21oi_1
X$1894 \$4113 VGND \$2673 VPWR \$3912 \$4021 sg13cmos5l_a21oi_1
X$1895 \$1532 VGND \$1558 VPWR \$1534 \$51 sg13cmos5l_a21oi_1
X$1896 \$2445 VGND \$2560 VPWR \$2562 \$2156 sg13cmos5l_a21oi_1
X$1897 \$2287 VGND \$1993 VPWR \$1882 \$2061 sg13cmos5l_a21oi_1
X$1898 \$2197 VGND \$2084 VPWR \$1811 \$1559 sg13cmos5l_a21oi_1
X$1899 \$2033 VGND \$685 VPWR \$1774 \$1824 sg13cmos5l_a21oi_1
X$1900 \$2452 VGND \$2173 VPWR \$1790 \$2283 sg13cmos5l_a21oi_1
X$1901 \$2716 VGND \$2713 VPWR \$2715 \$2714 sg13cmos5l_a21oi_1
X$1902 \$2308 VGND \$2219 VPWR \$2119 \$2004 sg13cmos5l_a21oi_1
X$1903 \$352 VGND \$274 VPWR \$140 \$121 sg13cmos5l_a21oi_1
X$1904 \$2243 VGND \$1664 VPWR \$1624 \$2637 sg13cmos5l_a21oi_1
X$1905 \$4021 VGND \$3913 VPWR \$3865 \$3914 sg13cmos5l_a21oi_1
X$1906 \$3417 VGND \$3590 VPWR \$2746 \$3690 sg13cmos5l_a21oi_1
X$1907 \$1051 VGND \$854 VPWR \$856 \$841 sg13cmos5l_a21oi_1
X$1908 \$2863 VGND \$2864 VPWR \$2869 \$2920 sg13cmos5l_a21oi_1
X$1909 \$1574 VGND \$905 VPWR \$1107 \$1544 sg13cmos5l_a21oi_1
X$1910 \$1612 VGND \$1563 VPWR \$1546 \$1615 sg13cmos5l_a21oi_1
X$1911 \$554 VGND \$330 VPWR \$417 \$497 sg13cmos5l_a21oi_1
X$1912 \$862 VGND \$936 VPWR \$83 \$1010 sg13cmos5l_a21oi_1
X$1913 \$3594 VGND \$3431 VPWR \$2459 \$2456 sg13cmos5l_a21oi_1
X$1914 \$3337 VGND \$3104 VPWR \$2967 \$3465 sg13cmos5l_a21oi_1
X$1915 \$708 VGND \$225 VPWR \$710 \$52 sg13cmos5l_a21oi_1
X$1916 \$3816 VGND \$3556 VPWR \$3555 \$3371 sg13cmos5l_a21oi_1
X$1917 \$2106 VGND \$2405 VPWR \$1905 \$2341 sg13cmos5l_a21oi_1
X$1918 \$913 VGND \$950 VPWR \$612 \$661 sg13cmos5l_a21oi_1
X$1919 \$2564 VGND \$2714 VPWR \$3021 \$2904 sg13cmos5l_a21oi_1
X$1920 \$1976 VGND \$2087 VPWR \$2084 \$2004 sg13cmos5l_a21oi_1
X$1921 \$718 VGND \$502 VPWR \$501 \$651 sg13cmos5l_a21oi_1
X$1922 VPWR VGND \$719 \$788 \$832 sg13cmos5l_nor2_1
X$1923 VPWR VGND \$2033 \$2139 \$2087 sg13cmos5l_nor2_1
X$1924 VPWR VGND \$2629 \$3259 \$3090 sg13cmos5l_nor2_1
X$1925 VPWR VGND \$2102 \$1952 \$1957 sg13cmos5l_nor2_1
X$1926 VPWR VGND \$1984 \$2437 \$2754 sg13cmos5l_nor2_1
X$1927 VPWR VGND \$685 \$934 \$935 sg13cmos5l_nor2_1
X$1928 VPWR VGND \$2952 \$3605 \$3729 sg13cmos5l_nor2_1
X$1929 VPWR VGND \$20 \$30 \$18 sg13cmos5l_nor2_1
X$1930 VPWR VGND \$3595 \$2004 \$3435 sg13cmos5l_nor2_1
X$1931 VPWR VGND \$2725 \$2456 \$2720 sg13cmos5l_nor2_1
X$1932 VPWR VGND \$2716 \$2820 \$2819 sg13cmos5l_nor2_1
X$1933 VPWR VGND \$501 \$555 \$223 sg13cmos5l_nor2_1
X$1934 VPWR VGND \$291 \$343 \$48 sg13cmos5l_nor2_1
X$1935 VPWR VGND \$48 \$335 \$228 sg13cmos5l_nor2_1
X$1936 VPWR VGND \$443 \$259 \$1076 sg13cmos5l_nor2_1
X$1937 VPWR VGND \$4021 \$3985 \$3987 sg13cmos5l_nor2_1
X$1938 VPWR VGND \$995 \$917 \$950 sg13cmos5l_nor2_1
X$1939 VPWR VGND \$2560 \$2473 \$2510 sg13cmos5l_nor2_1
X$1940 VPWR VGND \$290 \$327 \$547 sg13cmos5l_nor2_1
X$1941 VPWR VGND \$1574 \$1559 \$1546 sg13cmos5l_nor2_1
X$1942 VPWR VGND \$518 \$174 \$519 sg13cmos5l_nor2_1
X$1943 VPWR VGND \$2352 \$2926 \$3347 sg13cmos5l_nor2_1
X$1944 VPWR VGND \$291 \$125 \$979 sg13cmos5l_nor2_1
X$1945 VPWR VGND \$861 \$789 \$905 sg13cmos5l_nor2_1
X$1946 VPWR VGND \$847 \$501 \$716 sg13cmos5l_nor2_1
X$1947 VPWR VGND \$1076 \$125 \$1107 sg13cmos5l_nor2_1
X$1948 VPWR VGND \$2971 \$2241 \$2869 sg13cmos5l_nor2_1
X$1949 VPWR VGND \$195 \$15 \$219 sg13cmos5l_nor2_1
X$1950 VPWR VGND \$3417 \$2920 \$3342 sg13cmos5l_nor2_1
X$1951 VPWR VGND \$1177 \$1538 \$1457 sg13cmos5l_nor2_1
X$1952 VPWR VGND \$1869 \$1952 \$1909 sg13cmos5l_nor2_1
X$1953 VPWR VGND \$3451 \$2673 \$3324 sg13cmos5l_nor2_1
X$1954 VPWR VGND \$3047 \$3953 \$3992 sg13cmos5l_nor2_1
X$1955 VPWR VGND \$2452 \$1993 \$2450 sg13cmos5l_nor2_1
X$1956 VPWR VGND \$533 \$734 \$736 sg13cmos5l_nor2_1
X$1957 VPWR VGND \$30 \$58 \$65 sg13cmos5l_nor2_1
X$1958 VPWR VGND \$661 \$716 \$582 sg13cmos5l_nor2_1
X$1959 VPWR VGND \$3474 \$2241 \$3551 sg13cmos5l_nor2_1
X$1960 VPWR VGND \$82 \$397 \$262 sg13cmos5l_nor2_1
X$1961 VPWR VGND \$59 \$67 \$60 sg13cmos5l_nor2_1
X$1962 VPWR VGND \$629 \$25 \$626 sg13cmos5l_nor2_1
X$1963 VPWR VGND \$50 \$64 \$93 sg13cmos5l_nor2_1
X$1964 VPWR VGND \$3471 \$3047 \$3469 sg13cmos5l_nor2_1
X$1965 VPWR VGND \$2924 \$2456 \$2686 sg13cmos5l_nor2_1
X$1966 VPWR VGND \$219 \$49 \$170 sg13cmos5l_nor2_1
X$1967 VPWR VGND \$2450 \$1952 \$2397 sg13cmos5l_nor2_1
X$1968 VPWR VGND \$48 \$16 \$49 sg13cmos5l_nor2_1
X$1969 VPWR VGND \$140 \$121 \$27 sg13cmos5l_nor2_1
X$1970 VPWR VGND \$1546 \$917 \$1615 sg13cmos5l_nor2_1
X$1971 VPWR VGND \$223 \$25 \$249 sg13cmos5l_nor2_1
X$1972 VPWR VGND \$840 \$17 \$841 sg13cmos5l_nor2_1
X$1973 VPWR VGND \$442 \$396 \$912 sg13cmos5l_nor2_1
X$1974 VPWR VGND \$520 \$519 \$634 sg13cmos5l_nor2_1
X$1975 VPWR VGND \$3445 \$3259 \$3451 sg13cmos5l_nor2_1
X$1976 VPWR VGND \$718 \$396 \$561 sg13cmos5l_nor2_1
X$1977 VPWR VGND \$561 \$496 \$664 sg13cmos5l_nor2_1
X$1978 VPWR VGND sg13cmos5l_decap_8
X$1979 VPWR VGND sg13cmos5l_decap_8
X$1980 VPWR VGND sg13cmos5l_decap_8
X$1981 VPWR VGND sg13cmos5l_decap_8
X$1982 VPWR VGND sg13cmos5l_decap_8
X$1983 VPWR VGND sg13cmos5l_decap_8
X$1984 VPWR VGND sg13cmos5l_decap_8
X$1985 VPWR VGND sg13cmos5l_decap_8
X$1986 VPWR VGND sg13cmos5l_decap_8
X$1987 VPWR VGND sg13cmos5l_decap_8
X$1988 VPWR VGND sg13cmos5l_decap_8
X$1989 VPWR VGND sg13cmos5l_decap_8
X$1990 VPWR VGND sg13cmos5l_decap_8
X$1991 VPWR VGND sg13cmos5l_decap_8
X$1992 VPWR VGND sg13cmos5l_decap_8
X$1993 VPWR VGND sg13cmos5l_decap_8
X$1994 VPWR VGND sg13cmos5l_decap_8
X$1995 VPWR VGND sg13cmos5l_decap_8
X$1996 VPWR VGND sg13cmos5l_decap_8
X$1997 VPWR VGND sg13cmos5l_decap_8
X$1998 VPWR VGND sg13cmos5l_decap_8
X$1999 VPWR VGND sg13cmos5l_decap_8
X$2000 VPWR VGND sg13cmos5l_decap_8
X$2001 VPWR VGND sg13cmos5l_decap_8
X$2002 VPWR VGND sg13cmos5l_decap_8
X$2003 VPWR VGND sg13cmos5l_decap_8
X$2004 VPWR VGND sg13cmos5l_decap_8
X$2005 VPWR VGND sg13cmos5l_decap_8
X$2006 VPWR VGND sg13cmos5l_decap_8
X$2007 VPWR VGND sg13cmos5l_decap_8
X$2008 VPWR VGND sg13cmos5l_decap_8
X$2009 VPWR VGND sg13cmos5l_decap_8
X$2010 VPWR VGND sg13cmos5l_decap_8
X$2011 VPWR VGND sg13cmos5l_decap_8
X$2012 VPWR VGND sg13cmos5l_decap_8
X$2013 VPWR VGND sg13cmos5l_decap_8
X$2014 VPWR VGND sg13cmos5l_decap_8
X$2015 VPWR VGND sg13cmos5l_decap_8
X$2016 VPWR VGND sg13cmos5l_decap_8
X$2017 VPWR VGND sg13cmos5l_decap_8
X$2018 VPWR VGND sg13cmos5l_decap_8
X$2019 VPWR VGND sg13cmos5l_decap_8
X$2020 VPWR VGND sg13cmos5l_decap_8
X$2021 VPWR VGND sg13cmos5l_decap_8
X$2022 VPWR VGND sg13cmos5l_decap_8
X$2023 VPWR VGND \$520 \$519 \$270 \$401 \$490 sg13cmos5l_nor4_1
X$2024 VPWR VGND \$520 \$399 \$496 \$561 sg13cmos5l_nand3b_1
X$2025 VPWR VGND sg13cmos5l_decap_8
X$2026 VPWR VGND sg13cmos5l_decap_8
X$2027 VPWR VGND sg13cmos5l_decap_8
X$2028 VPWR VGND sg13cmos5l_decap_8
X$2029 VPWR VGND sg13cmos5l_decap_8
X$2030 VPWR VGND sg13cmos5l_decap_8
X$2031 VPWR VGND sg13cmos5l_decap_8
X$2032 VPWR VGND sg13cmos5l_decap_8
X$2033 VPWR VGND sg13cmos5l_decap_8
X$2034 VPWR VGND sg13cmos5l_decap_8
X$2035 VPWR VGND sg13cmos5l_decap_8
X$2036 VPWR VGND sg13cmos5l_decap_8
X$2037 VPWR VGND sg13cmos5l_decap_8
X$2038 VPWR VGND sg13cmos5l_decap_8
X$2039 VGND \$578 \$81 VPWR sg13cmos5l_buf_8
X$2040 VPWR VGND sg13cmos5l_decap_8
X$2041 VPWR VGND sg13cmos5l_decap_8
X$2042 VPWR VGND sg13cmos5l_decap_8
X$2043 VPWR VGND sg13cmos5l_decap_8
X$2044 VPWR VGND sg13cmos5l_decap_8
X$2045 VPWR VGND sg13cmos5l_decap_8
X$6975 \$72 \$292 \$291 VPWR VGND sg13cmos5l_or2_1
X$7113 VGND \$1656 \$1316 \$1612 \$1567 VPWR sg13cmos5l_dfrbpq_1
X$7114 VGND \$1656 \$1451 \$1659 \$1175 VPWR sg13cmos5l_dfrbpq_1
X$7115 VGND \$116 \$100 \$242 \$76 VPWR sg13cmos5l_dfrbpq_1
X$7116 VGND \$1445 \$1127 \$1674 \$1372 VPWR sg13cmos5l_dfrbpq_1
X$7117 VGND \$116 \$14 \$166 \$76 VPWR sg13cmos5l_dfrbpq_1
X$7119 VPWR VGND \$52 \$27 \$25 \$59 sg13cmos5l_and3_1
X$7120 VGND \$168 VPWR \$44 \$27 \$25 sg13cmos5l_o21ai_1
X$7121 VGND \$3790 \$3413 \$3631 \$1969 VPWR sg13cmos5l_dfrbpq_1
X$7122 VGND \$3703 \$3821 \$3974 \$3494 VPWR sg13cmos5l_dfrbpq_1
X$7123 VGND \$3790 \$2773 \$3838 \$3527 VPWR sg13cmos5l_dfrbpq_1
X$7124 VGND \$3790 \$3465 \$3685 \$3527 VPWR sg13cmos5l_dfrbpq_1
X$7125 VGND \$46 \$17 \$109 \$81 VPWR sg13cmos5l_dfrbpq_1
X$7126 VPWR VGND \$82 \$109 \$110 \$12 sg13cmos5l_nor3_1
X$7127 VGND \$1445 \$1258 \$1606 \$1444 VPWR sg13cmos5l_dfrbpq_1
X$7128 VGND \$1704 \$1455 \$1813 \$1175 VPWR sg13cmos5l_dfrbpq_1
X$7129 VGND \$1704 \$1709 \$1960 \$1175 VPWR sg13cmos5l_dfrbpq_1
X$7130 VGND \$3703 \$3784 \$3979 \$3494 VPWR sg13cmos5l_dfrbpq_1
X$7131 VGND \$1445 \$1372 \$1411 \$675 VPWR sg13cmos5l_dfrbpq_1
X$7132 VGND \$43 \$347 \$445 \$97 VPWR sg13cmos5l_dfrbpq_1
X$7133 VGND \$3297 \$3069 \$3480 \$2077 VPWR sg13cmos5l_dfrbpq_1
X$7134 VGND \$43 \$575 \$885 \$76 VPWR sg13cmos5l_dfrbpq_1
X$7135 VGND \$1480 \$1769 \$1827 \$1567 VPWR sg13cmos5l_dfrbpq_1
X$7136 VGND \$1480 \$1907 \$1783 \$1567 VPWR sg13cmos5l_dfrbpq_1
X$7137 VGND \$3790 \$3953 \$3839 \$3527 VPWR sg13cmos5l_dfrbpq_1
X$7138 VGND \$1704 \$1916 \$1884 \$1969 VPWR sg13cmos5l_dfrbpq_1
X$7139 VGND \$46 \$72 \$18 \$81 VPWR sg13cmos5l_dfrbpq_1
X$7140 VGND \$2237 \$2682 \$2425 \$1969 VPWR sg13cmos5l_dfrbpq_1
X$7141 VGND \$3703 \$3963 \$3771 \$3494 VPWR sg13cmos5l_dfrbpq_1
X$7142 VGND \$2411 \$2532 \$2289 \$1969 VPWR sg13cmos5l_dfrbpq_1
X$7143 VGND \$1704 \$1790 \$1730 \$1567 VPWR sg13cmos5l_dfrbpq_1
X$7144 VGND \$1704 \$1882 \$1795 \$1175 VPWR sg13cmos5l_dfrbpq_1
X$7145 VGND \$1704 \$2240 \$1911 \$1969 VPWR sg13cmos5l_dfrbpq_1
X$7146 VGND \$1480 \$1894 \$1763 \$1567 VPWR sg13cmos5l_dfrbpq_1
X$7147 VGND \$3790 \$3925 \$3843 \$3527 VPWR sg13cmos5l_dfrbpq_1
X$7148 VGND \$116 \$384 \$449 \$76 VPWR sg13cmos5l_dfrbpq_1
X$7149 \$465 VGND VPWR \$274 \$343 \$504 \$93 sg13cmos5l_a22oi_1
X$7150 VGND \$3790 \$3596 \$3848 \$3527 VPWR sg13cmos5l_dfrbpq_1
X$7151 VGND \$237 \$1011 \$1327 \$1175 VPWR sg13cmos5l_dfrbpq_1
X$7152 VGND \$237 \$591 \$888 \$81 VPWR sg13cmos5l_dfrbpq_1
X$7153 VGND \$3703 \$2626 \$3446 \$3494 VPWR sg13cmos5l_dfrbpq_1
X$7154 VGND \$43 \$446 \$348 \$347 VPWR sg13cmos5l_dfrbpq_1
X$7155 VGND \$1480 \$1291 \$1903 \$1567 VPWR sg13cmos5l_dfrbpq_1
X$7156 VGND \$1480 \$1306 \$1604 \$526 VPWR sg13cmos5l_dfrbpq_1
X$7157 VGND \$1480 \$949 \$1668 \$1127 VPWR sg13cmos5l_dfrbpq_1
X$7158 VGND \$43 \$92 \$91 \$441 VPWR sg13cmos5l_dfrbpq_1
X$7159 VGND \$3703 \$3296 \$3656 \$2077 VPWR sg13cmos5l_dfrbpq_1
X$7160 VGND \$1656 \$1179 \$1582 \$1175 VPWR sg13cmos5l_dfrbpq_1
X$7161 VGND \$2237 \$2473 \$2800 \$2077 VPWR sg13cmos5l_dfrbpq_1
X$7162 VGND \$2237 \$1928 \$2213 \$2077 VPWR sg13cmos5l_dfrbpq_1
X$7163 VGND \$2237 \$1871 \$2233 \$2077 VPWR sg13cmos5l_dfrbpq_1
X$7164 VGND \$2237 \$1922 \$2252 \$1969 VPWR sg13cmos5l_dfrbpq_1
X$7165 VGND \$116 \$97 \$380 \$194 VPWR sg13cmos5l_dfrbpq_1
X$7166 VGND \$3703 \$3195 \$3823 \$3494 VPWR sg13cmos5l_dfrbpq_1
X$7167 VGND \$3790 \$3831 \$3987 \$3527 VPWR sg13cmos5l_dfrbpq_1
X$7168 VGND \$1480 \$880 \$1475 \$949 VPWR sg13cmos5l_dfrbpq_1
X$7169 VGND \$46 \$16 \$152 \$81 VPWR sg13cmos5l_dfrbpq_1
X$7170 VGND \$46 \$15 \$171 \$81 VPWR sg13cmos5l_dfrbpq_1
X$7171 VPWR VGND \$150 \$67 \$59 sg13cmos5l_and2_1
X$7172 VGND \$3790 \$3797 \$3957 \$3527 VPWR sg13cmos5l_dfrbpq_1
X$7173 VGND \$46 \$83 \$394 \$81 VPWR sg13cmos5l_dfrbpq_1
X$7174 VGND \$43 \$10 \$207 \$76 VPWR sg13cmos5l_dfrbpq_1
X$7175 VGND \$1445 \$705 \$1486 \$76 VPWR sg13cmos5l_dfrbpq_1
X$7176 VGND \$2237 \$2669 \$3218 \$2077 VPWR sg13cmos5l_dfrbpq_1
X$7177 VGND \$3297 \$2971 \$3430 \$1969 VPWR sg13cmos5l_dfrbpq_1
X$7178 VGND \$1704 \$1304 \$1703 clk_fb VPWR sg13cmos5l_dfrbpq_1
X$7179 VGND \$3703 \$3859 \$3774 \$3494 VPWR sg13cmos5l_dfrbpq_1
X$7180 VGND \$2237 \$2477 \$2430 \$2077 VPWR sg13cmos5l_dfrbpq_1
X$7181 VGND \$1704 \$1739 \$1714 \$1175 VPWR sg13cmos5l_dfrbpq_1
X$7182 VGND \$43 \$194 \$437 \$92 VPWR sg13cmos5l_dfrbpq_1
X$7183 VGND \$43 \$441 \$440 \$880 VPWR sg13cmos5l_dfrbpq_1
X$7184 VGND \$46 \$396 \$108 \$81 VPWR sg13cmos5l_dfrbpq_1
X$7185 VGND \$1480 \$1860 \$1765 \$1567 VPWR sg13cmos5l_dfrbpq_1
X$7186 VGND \$3703 \$3886 \$3780 \$3494 VPWR sg13cmos5l_dfrbpq_1
X$7187 VPWR VGND \$980 \$1451 sg13cmos5l_dlygate4sd3_1
X$7188 VPWR VGND \$916 \$1316 sg13cmos5l_dlygate4sd3_1
X$7189 VPWR VGND \$1873 \$1907 sg13cmos5l_dlygate4sd3_1
X$7190 VPWR VGND \$2061 \$2532 sg13cmos5l_dlygate4sd3_1
X$7191 VPWR VGND \$1795 \$1992 sg13cmos5l_dlygate4sd3_1
X$7192 VPWR VGND \$3839 \$3994 sg13cmos5l_dlygate4sd3_1
X$7193 VPWR VGND \$449 \$575 sg13cmos5l_dlygate4sd3_1
X$7194 VPWR VGND \$4030 \$4113 sg13cmos5l_dlygate4sd3_1
X$7195 VPWR VGND \$2425 \$2585 sg13cmos5l_dlygate4sd3_1
X$7196 VPWR VGND \$1763 \$1934 sg13cmos5l_dlygate4sd3_1
X$7197 VPWR VGND \$1884 \$2117 sg13cmos5l_dlygate4sd3_1
X$7198 VPWR VGND \$50 \$77 sg13cmos5l_dlygate4sd3_1
X$7199 VPWR VGND \$1783 \$1782 sg13cmos5l_dlygate4sd3_1
X$7200 VPWR VGND \$1911 \$2053 sg13cmos5l_dlygate4sd3_1
X$7201 VPWR VGND \$1730 \$1915 sg13cmos5l_dlygate4sd3_1
X$7202 VPWR VGND \$1082 \$970 sg13cmos5l_dlygate4sd3_1
X$7203 VPWR VGND \$3740 \$2773 sg13cmos5l_dlygate4sd3_1
X$7204 VPWR VGND \$3843 \$3756 sg13cmos5l_dlygate4sd3_1
X$7205 VPWR VGND \$1824 \$1769 sg13cmos5l_dlygate4sd3_1
X$7206 VPWR VGND \$2289 \$2106 sg13cmos5l_dlygate4sd3_1
X$7207 VPWR VGND \$327 \$83 sg13cmos5l_dlygate4sd3_1
X$7208 VPWR VGND \$1961 \$1882 sg13cmos5l_dlygate4sd3_1
X$7209 VPWR VGND \$1765 \$1770 sg13cmos5l_dlygate4sd3_1
X$7210 VPWR VGND \$3935 \$3936 sg13cmos5l_dlygate4sd3_1
X$7211 VPWR VGND \$1888 \$1739 sg13cmos5l_dlygate4sd3_1
X$7212 VPWR VGND \$2283 \$2240 sg13cmos5l_dlygate4sd3_1
X$7213 VPWR VGND \$3909 \$3784 sg13cmos5l_dlygate4sd3_1
X$7214 VPWR VGND \$1582 \$1557 sg13cmos5l_dlygate4sd3_1
X$7215 VPWR VGND \$1327 \$1081 sg13cmos5l_dlygate4sd3_1
X$7216 VPWR VGND \$1559 \$1709 sg13cmos5l_dlygate4sd3_1
X$7217 VPWR VGND \$3182 \$3069 sg13cmos5l_dlygate4sd3_1
X$7218 VPWR VGND \$3899 \$3821 sg13cmos5l_dlygate4sd3_1
X$7219 VPWR VGND \$1714 \$1631 sg13cmos5l_dlygate4sd3_1
X$7220 VPWR VGND \$58 \$17 sg13cmos5l_dlygate4sd3_1
X$7221 VPWR VGND \$2751 \$2473 sg13cmos5l_dlygate4sd3_1
X$7222 VPWR VGND \$2064 \$1709 sg13cmos5l_dlygate4sd3_1
X$7223 VPWR VGND \$2134 \$1928 sg13cmos5l_dlygate4sd3_1
X$7224 VPWR VGND \$2075 \$1922 sg13cmos5l_dlygate4sd3_1
X$7225 VPWR VGND \$3776 \$3810 sg13cmos5l_dlygate4sd3_1
X$7226 VPWR VGND \$1931 \$1860 sg13cmos5l_dlygate4sd3_1
X$7227 VPWR VGND \$3728 \$2626 sg13cmos5l_dlygate4sd3_1
X$7228 VPWR VGND \$3372 \$3859 sg13cmos5l_dlygate4sd3_1
X$7229 VPWR VGND \$3474 \$3596 sg13cmos5l_dlygate4sd3_1
X$7230 VPWR VGND \$302 \$705 sg13cmos5l_dlygate4sd3_1
X$7231 VPWR VGND \$1932 \$1823 sg13cmos5l_dlygate4sd3_1
X$7232 VPWR VGND \$28 \$14 sg13cmos5l_dlygate4sd3_1
X$7233 VPWR VGND \$3780 \$3818 sg13cmos5l_dlygate4sd3_1
X$7234 VPWR VGND \$2311 \$2477 sg13cmos5l_dlygate4sd3_1
X$7235 VPWR VGND \$242 \$384 sg13cmos5l_dlygate4sd3_1
X$7236 VGND VPWR \$53 \$205 \$242 sg13cmos5l_nor2b_1
X$7237 VPWR VGND \$3096 \$3465 sg13cmos5l_dlygate4sd3_1
X$7238 VPWR VGND \$1231 \$1291 sg13cmos5l_dlygate4sd3_1
X$7239 VPWR VGND \$1827 \$1935 sg13cmos5l_dlygate4sd3_1
X$7240 VPWR VGND \$1693 \$1902 \$259 \$443 \$1984 sg13cmos5l_or4_1
X$7241 VPWR VGND \$3605 \$3886 sg13cmos5l_dlygate4sd3_1
X$7242 VPWR VGND \$110 \$65 sg13cmos5l_dlygate4sd3_1
X$7243 VPWR VGND \$1715 \$1635 sg13cmos5l_dlygate4sd3_1
X$7244 VPWR VGND \$205 \$100 sg13cmos5l_dlygate4sd3_1
X$7245 VPWR VGND \$3656 \$3554 sg13cmos5l_dlygate4sd3_1
X$7246 VPWR VGND \$1547 \$1457 sg13cmos5l_dlygate4sd3_1
X$7247 VPWR VGND \$2051 \$1871 sg13cmos5l_dlygate4sd3_1
X$7248 VPWR VGND \$3912 \$3831 sg13cmos5l_dlygate4sd3_1
X$7249 VPWR VGND \$107 \$60 sg13cmos5l_dlygate4sd3_1
X$7250 VPWR VGND \$669 \$591 sg13cmos5l_dlygate4sd3_1
X$7251 VPWR VGND \$1538 \$1179 sg13cmos5l_dlygate4sd3_1
X$7252 VPWR VGND \$1728 \$1790 sg13cmos5l_dlygate4sd3_1
X$7253 VPWR VGND \$67 \$16 sg13cmos5l_dlygate4sd3_1
X$7254 VPWR VGND \$149 \$72 sg13cmos5l_dlygate4sd3_1
X$7255 VPWR VGND \$967 \$1011 sg13cmos5l_dlygate4sd3_1
X$7256 VPWR VGND \$156 \$70 sg13cmos5l_dlygate4sd3_1
X$7257 VPWR VGND \$3957 \$3933 sg13cmos5l_dlygate4sd3_1
X$7258 VPWR VGND \$397 \$396 sg13cmos5l_dlygate4sd3_1
X$7259 VPWR VGND \$1859 \$1894 sg13cmos5l_dlygate4sd3_1
X$7260 VPWR VGND \$3923 \$3925 sg13cmos5l_dlygate4sd3_1
X$7261 VPWR VGND \$3771 \$3550 sg13cmos5l_dlygate4sd3_1
X$7262 VPWR VGND \$2542 \$2682 sg13cmos5l_dlygate4sd3_1
X$7263 VPWR VGND \$2989 \$2669 sg13cmos5l_dlygate4sd3_1
X$7264 VPWR VGND \$1534 \$1455 sg13cmos5l_dlygate4sd3_1
X$7265 VPWR VGND \$3604 \$3296 sg13cmos5l_dlygate4sd3_1
X$7266 VPWR VGND \$3738 \$3195 sg13cmos5l_dlygate4sd3_1
X$7267 VPWR VGND \$54 \$15 sg13cmos5l_dlygate4sd3_1
X$7268 VPWR VGND \$2341 \$2287 sg13cmos5l_dlygate4sd3_1
X$7269 VPWR VGND \$3768 \$3797 sg13cmos5l_dlygate4sd3_1
X$7270 VPWR VGND \$2071 \$1916 sg13cmos5l_dlygate4sd3_1
X$7300 VPWR VGND \$691 \$585 \$285 \$583 sg13cmos5l_a21o_1
X$7440 VGND vctrl_out VPWR \$36 sg13cmos5l_buf_1
X$7441 VPWR VGND sg13cmos5l_decap_4
X$7443 VPWR VGND \$64 \$10 sg13cmos5l_dlygate4sd3_1
X$7444 VGND \$43 \$77 \$13 \$76 VPWR sg13cmos5l_dfrbpq_1
X$7448 VPWR VGND sg13cmos5l_decap_8
X$7449 VPWR VGND \$12 \$50 \$13 sg13cmos5l_nor2_1
X$7450 \$44 VGND \$27 VPWR \$25 \$12 sg13cmos5l_a21oi_1
X$7451 VPWR VGND \$92 \$91 sg13cmos5l_inv_1
X$7453 VPWR VGND \$242 \$205 \$125 sg13cmos5l_nand2b_1
X$7454 VPWR VGND sg13cmos5l_decap_4
X$7455 VPWR VGND sg13cmos5l_decap_4
X$7456 VPWR VGND sg13cmos5l_decap_4
X$7457 VGND \$318 \$612 \$504 \$502 VPWR sg13cmos5l_mux2_1
X$7458 VPWR VGND sg13cmos5l_decap_4
X$7459 VPWR VGND sg13cmos5l_decap_4
X$7460 VPWR VGND sg13cmos5l_decap_4
X$7461 VPWR VGND sg13cmos5l_decap_4
X$7462 VPWR VGND sg13cmos5l_decap_4
X$7463 VPWR VGND sg13cmos5l_decap_4
X$7464 VPWR VGND sg13cmos5l_decap_4
X$7465 VPWR VGND sg13cmos5l_decap_4
X$7466 VPWR VGND sg13cmos5l_decap_4
X$7467 VPWR VGND sg13cmos5l_decap_4
X$7468 VPWR VGND sg13cmos5l_decap_4
X$7469 VPWR VGND sg13cmos5l_decap_4
X$7470 VPWR VGND sg13cmos5l_decap_4
X$7471 VPWR VGND sg13cmos5l_decap_4
X$7472 VPWR VGND sg13cmos5l_decap_4
X$7473 VPWR VGND sg13cmos5l_decap_4
X$7474 VPWR VGND sg13cmos5l_decap_4
X$7475 VPWR VGND sg13cmos5l_decap_4
X$7476 VPWR VGND sg13cmos5l_decap_4
X$7477 VPWR VGND sg13cmos5l_decap_4
X$7478 VPWR VGND sg13cmos5l_decap_4
X$7479 VPWR VGND sg13cmos5l_decap_4
X$7480 VPWR VGND sg13cmos5l_decap_4
X$7481 VPWR VGND sg13cmos5l_decap_4
X$7482 VPWR VGND sg13cmos5l_decap_4
X$7483 VPWR VGND sg13cmos5l_decap_4
X$7484 VPWR VGND sg13cmos5l_decap_4
X$7485 VPWR VGND sg13cmos5l_decap_4
X$7486 VPWR VGND sg13cmos5l_decap_4
X$7487 VPWR VGND sg13cmos5l_decap_4
X$7488 VPWR VGND sg13cmos5l_decap_4
X$7489 VPWR VGND sg13cmos5l_decap_4
X$7490 VPWR VGND sg13cmos5l_decap_4
X$7491 VPWR VGND sg13cmos5l_decap_4
X$7492 VPWR VGND sg13cmos5l_decap_4
X$7493 VPWR VGND sg13cmos5l_decap_4
X$7494 VGND \$1774 VPWR \$2075 sg13cmos5l_buf_1
X$7495 VGND \$3790 VPWR \$3297 sg13cmos5l_buf_1
X$7496 VGND \$710 VPWR \$2034 sg13cmos5l_buf_1
X$7497 VGND \$2967 VPWR \$3047 sg13cmos5l_buf_1
X$7498 VGND \$3703 VPWR \$3297 sg13cmos5l_buf_1
X$7499 VGND \$2352 VPWR \$2197 sg13cmos5l_buf_1
X$7500 VGND \$2861 VPWR \$2004 sg13cmos5l_buf_1
X$7501 VGND \$2947 VPWR \$3182 sg13cmos5l_buf_1
X$7502 VGND \$3047 VPWR \$3413 sg13cmos5l_buf_1
X$7503 VGND \$2746 VPWR \$2971 sg13cmos5l_buf_1
X$7504 VGND \$1704 VPWR \$1656 sg13cmos5l_buf_1
X$7505 VGND \$259 VPWR \$1231 sg13cmos5l_buf_1
X$7506 VGND \$1480 VPWR \$1656 sg13cmos5l_buf_1
X$7507 VGND \$995 VPWR \$980 sg13cmos5l_buf_1
X$7508 VGND \$1656 VPWR \$237 sg13cmos5l_buf_1
X$7509 VGND \$2328 VPWR \$2192 sg13cmos5l_buf_1
X$7510 VGND \$25 VPWR \$28 sg13cmos5l_buf_1
X$7511 VGND \$43 VPWR \$46 sg13cmos5l_buf_1
X$7512 VGND \$1071 VPWR \$302 sg13cmos5l_buf_1
X$7513 VGND \$52 VPWR \$54 sg13cmos5l_buf_1
X$7514 VGND \$116 VPWR \$46 sg13cmos5l_buf_1
X$7515 VGND \$917 VPWR \$916 sg13cmos5l_buf_1
X$7516 VGND \$224 VPWR \$259 sg13cmos5l_buf_1
X$7517 VGND \$3153 VPWR \$3738 sg13cmos5l_buf_1
X$7518 VGND \$2972 VPWR \$3096 sg13cmos5l_buf_1
X$7519 VGND \$2920 VPWR \$2084 sg13cmos5l_buf_1
X$7520 VGND \$3297 VPWR \$2237 sg13cmos5l_buf_1
X$7521 VGND \$I12072 VPWR \$1444 sg13cmos5l_buf_1
X$7522 VGND \$2616 VPWR \$2863 sg13cmos5l_buf_1
X$7523 VGND \$555 VPWR \$917 sg13cmos5l_buf_1
X$7524 VGND \$2562 VPWR \$2473 sg13cmos5l_buf_1
X$7525 VGND \$2463 VPWR \$2328 sg13cmos5l_buf_1
X$7526 VGND \$41 VPWR vctrl_b_in sg13cmos5l_buf_1
X$7527 VGND vctrl_b_out VPWR \$41 sg13cmos5l_buf_1
X$7528 VGND \$850 VPWR \$995 sg13cmos5l_buf_1
X$7529 VGND \$237 VPWR \$2411 sg13cmos5l_buf_1
X$7530 VGND \$46 VPWR \$237 sg13cmos5l_buf_1
X$7531 VPWR VGND \$164 \$52 \$195 sg13cmos5l_nand2_1
X$7532 VGND \$603 VPWR \$1291 sg13cmos5l_buf_1
X$7533 VGND \$2241 VPWR \$2305 sg13cmos5l_buf_1
X$7534 VGND dac_out VPWR \$3963 sg13cmos5l_buf_1
X$7535 VGND \$685 VPWR \$1076 sg13cmos5l_buf_1
X$7536 VGND \$I12058 VPWR \$526 sg13cmos5l_buf_1
X$7537 VGND \$I12057 VPWR \$675 sg13cmos5l_buf_1
X$7538 VGND \$2237 VPWR \$2411 sg13cmos5l_buf_1
X$7539 VGND \$1445 VPWR \$1656 sg13cmos5l_buf_1
X$7540 VGND \$612 VPWR \$343 sg13cmos5l_buf_1
X$7541 VGND \$36 VPWR vctrl_in sg13cmos5l_buf_1
X$7542 VGND \$2560 VPWR \$2094 sg13cmos5l_buf_1
X$7543 VGND \$2084 VPWR \$2119 sg13cmos5l_buf_1
X$7544 VGND \$2004 VPWR \$1999 sg13cmos5l_buf_1
X$7545 VGND \$12 VPWR \$51 sg13cmos5l_buf_1
X$7546 VGND \$346 VPWR \$302 sg13cmos5l_buf_1
X$7547 VGND \$2411 VPWR rst_ni sg13cmos5l_buf_1
X$7548 VGND \$2673 VPWR \$3740 sg13cmos5l_buf_1
X$7549 VGND \$2952 VPWR \$3069 sg13cmos5l_buf_1
X$7550 VGND \$2623 VPWR \$3728 sg13cmos5l_buf_1
X$7551 VGND \$3070 VPWR \$2669 sg13cmos5l_buf_1
X$7552 VGND \$2933 VPWR \$2084 sg13cmos5l_buf_1
X$7553 VGND \$174 VPWR \$149 sg13cmos5l_buf_1
X$7554 VGND \$2094 VPWR \$710 sg13cmos5l_buf_1
X$7555 VGND \$51 VPWR \$53 sg13cmos5l_buf_1
M$1 \$296 \$296 \$296 VAPWR sg13_hv_pmos L=0.5u W=4u AS=1.36p AD=1.36p PS=8.68u
+ PD=8.68u rfmode=0
M$2 \$364 \$364 VGND VGND sg13_hv_nmos L=0.5u W=8u AS=2.72p AD=2.72p PS=18.72u
+ PD=18.72u rfmode=0
M$3 \$297 \$297 \$297 VAPWR sg13_hv_pmos L=0.5u W=12u AS=4.08p AD=4.08p
+ PS=26.04u PD=26.04u rfmode=0
M$4 \$364 \$364 \$364 VGND sg13_hv_nmos L=0.5u W=2u AS=0.68p AD=0.68p PS=4.68u
+ PD=4.68u rfmode=0
M$5 \$364 \$364 \$364 VAPWR sg13_hv_pmos L=0.5u W=4u AS=1.36p AD=1.36p PS=8.68u
+ PD=8.68u rfmode=0
M$6 \$364 ACC_CAP \$297 VAPWR sg13_hv_pmos L=0.5u W=16u AS=5.44p AD=5.44p
+ PS=34.72u PD=34.72u rfmode=0
M$7 \$296 \$296 \$296 VGND sg13_hv_nmos L=0.5u W=2u AS=0.68p AD=0.68p PS=4.68u
+ PD=4.68u rfmode=0
M$8 \$296 vref0 \$297 VAPWR sg13_hv_pmos L=0.5u W=16u AS=5.44p AD=5.44p
+ PS=34.72u PD=34.72u rfmode=0
M$9 \$296 \$364 VGND VGND sg13_hv_nmos L=0.5u W=8u AS=2.72p AD=2.72p PS=18.72u
+ PD=18.72u rfmode=0
M$17 VGND VGND VGND VGND sg13_hv_nmos L=0.5u W=38.5u AS=13.09p AD=13.09p
+ PS=96.72u PD=96.72u rfmode=0
R$25 VGND vref0 VGND rhigh w=2u l=12.9u ps=0u b=0 m=1
M$26 \$1923 \$1925 VGND VGND sg13_hv_nmos L=0.5u W=8u AS=2.72p AD=2.72p
+ PS=18.72u PD=18.72u rfmode=0
M$27 \$1334 \$1334 \$1334 VAPWR sg13_hv_pmos L=0.5u W=12u AS=4.08p AD=4.08p
+ PS=26.04u PD=26.04u rfmode=0
M$28 \$1925 ACC_CAP \$1926 VAPWR sg13_hv_pmos L=0.5u W=16u AS=5.44p AD=5.44p
+ PS=34.72u PD=34.72u rfmode=0
M$29 \$1923 \$1923 \$1923 VGND sg13_hv_nmos L=0.5u W=2u AS=0.68p AD=0.68p
+ PS=4.68u PD=4.68u rfmode=0
M$30 \$1925 \$1925 \$1925 VGND sg13_hv_nmos L=0.5u W=2u AS=0.68p AD=0.68p
+ PS=4.68u PD=4.68u rfmode=0
M$31 \$1397 \$1397 \$1397 VAPWR sg13_hv_pmos L=0.5u W=4u AS=1.36p AD=1.36p
+ PS=8.68u PD=8.68u rfmode=0
R$32 vref0 vref1 VGND rhigh w=2u l=2.8u ps=0u b=0 m=1
M$33 \$1333 vref1 \$1334 VAPWR sg13_hv_pmos L=0.5u W=16u AS=5.44p AD=5.44p
+ PS=34.72u PD=34.72u rfmode=0
M$35 \$1397 \$1397 VGND VGND sg13_hv_nmos L=0.5u W=8u AS=2.72p AD=2.72p
+ PS=18.72u PD=18.72u rfmode=0
M$38 \$1333 \$1397 VGND VGND sg13_hv_nmos L=0.5u W=8u AS=2.72p AD=2.72p
+ PS=18.72u PD=18.72u rfmode=0
M$46 \$1397 ACC_CAP \$1334 VAPWR sg13_hv_pmos L=0.5u W=16u AS=5.44p AD=5.44p
+ PS=34.72u PD=34.72u rfmode=0
M$48 \$1333 \$1333 \$1333 VGND sg13_hv_nmos L=0.5u W=2u AS=0.68p AD=0.68p
+ PS=4.68u PD=4.68u rfmode=0
M$51 \$1397 \$1397 \$1397 VGND sg13_hv_nmos L=0.5u W=2u AS=0.68p AD=0.68p
+ PS=4.68u PD=4.68u rfmode=0
M$54 \$1333 \$1333 \$1333 VAPWR sg13_hv_pmos L=0.5u W=4u AS=1.36p AD=1.36p
+ PS=8.68u PD=8.68u rfmode=0
M$55 \$1926 \$1926 \$1926 VAPWR sg13_hv_pmos L=0.5u W=12u AS=4.08p AD=4.08p
+ PS=26.04u PD=26.04u rfmode=0
M$56 \$1925 \$1925 VGND VGND sg13_hv_nmos L=0.5u W=8u AS=2.72p AD=2.72p
+ PS=18.72u PD=18.72u rfmode=0
M$59 \$1923 vref2 \$1926 VAPWR sg13_hv_pmos L=0.5u W=16u AS=5.44p AD=5.44p
+ PS=34.72u PD=34.72u rfmode=0
R$69 \$1151 VGND VGND rhigh w=2u l=4.25u ps=0u b=0 m=1
R$70 \$181 VGND VGND rhigh w=2u l=13.71u ps=0.18u b=8 m=1
R$71 \$1243 VGND VGND rhigh w=2u l=13.71u ps=0.18u b=8 m=1
R$72 \$1841 VGND VGND rhigh w=2u l=13.71u ps=0.18u b=8 m=1
R$73 \$2782 VGND VGND rhigh w=2u l=13.71u ps=0.18u b=8 m=1
R$74 vcl \$1422 VGND rsil w=0.5u l=0.5u ps=0u b=0 m=1
R$75 dac_out vcl VGND rhigh w=1u l=61.395u ps=0.18u b=2 m=1
R$76 vref1 vref2 VGND rhigh w=2u l=1.4u ps=0u b=0 m=1
R$77 vref2 vref3 VGND rhigh w=2u l=1.4u ps=0u b=0 m=1
M$78 \$1923 \$1923 \$1923 VAPWR sg13_hv_pmos L=0.5u W=4u AS=1.36p AD=1.36p
+ PS=8.68u PD=8.68u rfmode=0
M$79 \$2785 \$2785 \$2785 VAPWR sg13_hv_pmos L=0.5u W=4u AS=1.36p AD=1.36p
+ PS=8.68u PD=8.68u rfmode=0
M$80 \$2787 \$2787 \$2787 VAPWR sg13_hv_pmos L=0.5u W=12u AS=4.08p AD=4.08p
+ PS=26.04u PD=26.04u rfmode=0
M$81 \$2876 \$2876 VGND VGND sg13_hv_nmos L=0.5u W=8u AS=2.72p AD=2.72p
+ PS=18.72u PD=18.72u rfmode=0
M$82 \$2876 ACC_CAP \$2787 VAPWR sg13_hv_pmos L=0.5u W=16u AS=5.44p AD=5.44p
+ PS=34.72u PD=34.72u rfmode=0
M$84 \$2785 vref3 \$2787 VAPWR sg13_hv_pmos L=0.5u W=16u AS=5.44p AD=5.44p
+ PS=34.72u PD=34.72u rfmode=0
M$88 \$1925 \$1925 \$1925 VAPWR sg13_hv_pmos L=0.5u W=4u AS=1.36p AD=1.36p
+ PS=8.68u PD=8.68u rfmode=0
R$89 VGND \$185 VGND rhigh w=2u l=9.27u ps=0.18u b=15 m=1
R$90 VGND \$1846 VGND rhigh w=2u l=9.27u ps=0.18u b=15 m=1
R$91 VGND \$1248 VGND rhigh w=2u l=9.27u ps=0.18u b=15 m=1
R$92 VGND \$2688 VGND rhigh w=2u l=9.27u ps=0.18u b=15 m=1
M$95 \$2785 \$2876 VGND VGND sg13_hv_nmos L=0.5u W=8u AS=2.72p AD=2.72p
+ PS=18.72u PD=18.72u rfmode=0
M$101 \$2876 \$2876 \$2876 VAPWR sg13_hv_pmos L=0.5u W=4u AS=1.36p AD=1.36p
+ PS=8.68u PD=8.68u rfmode=0
M$104 \$2785 \$2785 \$2785 VGND sg13_hv_nmos L=0.5u W=2u AS=0.68p AD=0.68p
+ PS=4.68u PD=4.68u rfmode=0
M$106 \$2876 \$2876 \$2876 VGND sg13_hv_nmos L=0.5u W=2u AS=0.68p AD=0.68p
+ PS=4.68u PD=4.68u rfmode=0
M$108 ACC_CAP ACC_CAP opm opm sg13_hv_pmos L=0.5u W=20u AS=4.1p AD=4.1p
+ PS=26.1u PD=26.1u rfmode=0
R$118 VGND \$3811 VGND rhigh w=2u l=10u ps=0u b=0 m=1
R$119 VGND opm VGND rhigh w=2u l=8u ps=0u b=0 m=1
R$120 \$871 rx_in VGND rhigh w=2u l=9.96u ps=0.18u b=3 m=1
R$121 \$3959 Cap_M21 VGND rhigh w=2u l=9.96u ps=0.18u b=3 m=1
R$122 \$2469 Cap_M2 VGND rhigh w=2u l=9.96u ps=0.18u b=3 m=1
R$123 VGND \$235 VGND rhigh w=2u l=4.95u ps=0.18u b=2 m=1
R$124 VGND \$4171 VGND rhigh w=2u l=4.95u ps=0.18u b=2 m=1
R$125 VGND \$1404 VGND rhigh w=2u l=4.95u ps=0.18u b=2 m=1
R$126 VGND \$2794 VGND rhigh w=2u l=4.95u ps=0.18u b=2 m=1
R$127 VGND \$1849 VGND rhigh w=2u l=4.95u ps=0.18u b=2 m=1
R$128 VGND \$3599 VGND rhigh w=2u l=4.95u ps=0.18u b=2 m=1
R$129 VAPWR \$236 VGND rhigh w=2u l=19.995u ps=0.18u b=9 m=1
R$130 VAPWR \$1853 VGND rhigh w=2u l=19.995u ps=0.18u b=9 m=1
R$131 VAPWR \$3602 VGND rhigh w=2u l=19.995u ps=0.18u b=9 m=1
R$132 VAPWR vref3 VGND rhigh w=2u l=28.8u ps=0u b=0 m=1
R$133 \$1253 VAPWR VGND rhigh w=2u l=22.72u ps=0.18u b=10 m=1
R$134 \$4123 VAPWR VGND rhigh w=2u l=22.72u ps=0.18u b=10 m=1
R$135 \$2697 VAPWR VGND rhigh w=2u l=22.72u ps=0.18u b=10 m=1
R$136 \$871 VAPWR VGND rhigh w=2u l=19.995u ps=0.18u b=9 m=1
R$137 \$3959 VAPWR VGND rhigh w=2u l=19.995u ps=0.18u b=9 m=1
R$138 \$2469 VAPWR VGND rhigh w=2u l=19.995u ps=0.18u b=9 m=1
M$143 VPWR VPWR VPWR VPWR sg13_hv_pmos L=4u W=8u AS=2.72p AD=2.72p PS=18.72u
+ PD=18.72u rfmode=0
M$144 q0 \$429 VPWR VPWR sg13_hv_pmos L=4u W=2u AS=0.68p AD=0.68p PS=4.68u
+ PD=4.68u rfmode=0
M$145 q0 q0 q0 VPWR sg13_hv_pmos L=4u W=2u AS=0.68p AD=0.68p PS=4.68u PD=4.68u
+ rfmode=0
M$146 VAPWR VAPWR VAPWR VAPWR sg13_hv_pmos L=4u W=8u AS=2.72p AD=2.72p
+ PS=18.72u PD=18.72u rfmode=0
M$147 \$429 \$296 VAPWR VAPWR sg13_hv_pmos L=4u W=2u AS=0.68p AD=0.68p PS=4.68u
+ PD=4.68u rfmode=0
M$148 \$429 \$429 \$429 VAPWR sg13_hv_pmos L=4u W=2u AS=0.68p AD=0.68p PS=4.68u
+ PD=4.68u rfmode=0
M$149 \$181 \$181 \$181 VGND sg13_hv_nmos L=4u W=2u AS=0.68p AD=0.68p PS=4.68u
+ PD=4.68u rfmode=0
M$150 \$429 \$296 \$181 VGND sg13_hv_nmos L=4u W=2u AS=0.68p AD=0.68p PS=4.68u
+ PD=4.68u rfmode=0
M$151 \$429 \$429 \$429 VGND sg13_hv_nmos L=4u W=2u AS=0.68p AD=0.68p PS=4.68u
+ PD=4.68u rfmode=0
M$152 \$1243 \$1243 \$1243 VGND sg13_hv_nmos L=4u W=2u AS=0.68p AD=0.68p
+ PS=4.68u PD=4.68u rfmode=0
M$153 \$1461 \$1333 \$1243 VGND sg13_hv_nmos L=4u W=2u AS=0.68p AD=0.68p
+ PS=4.68u PD=4.68u rfmode=0
M$154 \$1461 \$1461 \$1461 VGND sg13_hv_nmos L=4u W=2u AS=0.68p AD=0.68p
+ PS=4.68u PD=4.68u rfmode=0
M$156 q1 \$1461 VPWR VPWR sg13_hv_pmos L=4u W=2u AS=0.68p AD=0.68p PS=4.68u
+ PD=4.68u rfmode=0
M$157 q1 q1 q1 VPWR sg13_hv_pmos L=4u W=2u AS=0.68p AD=0.68p PS=4.68u PD=4.68u
+ rfmode=0
M$159 \$1461 \$1333 VAPWR VAPWR sg13_hv_pmos L=4u W=2u AS=0.68p AD=0.68p
+ PS=4.68u PD=4.68u rfmode=0
M$160 \$1461 \$1461 \$1461 VAPWR sg13_hv_pmos L=4u W=2u AS=0.68p AD=0.68p
+ PS=4.68u PD=4.68u rfmode=0
M$161 \$40 \$40 \$40 VPWR sg13_lv_pmos L=0.13u W=2u AS=0.68p AD=0.68p PS=4.68u
+ PD=4.68u rfmode=0
M$162 VPWR VPWR VPWR VPWR sg13_lv_pmos L=0.13u W=10.25u AS=3.485p AD=3.485p
+ PS=26.62u PD=26.62u rfmode=0
M$163 \$40 \$246 VPWR VPWR sg13_lv_pmos L=0.13u W=40u AS=7.9p AD=7.9p PS=49.9u
+ PD=49.9u rfmode=0
M$183 VGND VGND VGND VGND sg13_lv_nmos L=0.13u W=11u AS=3.74p AD=3.74p
+ PS=28.12u PD=28.12u rfmode=0
M$184 \$40 \$40 \$40 VGND sg13_lv_nmos L=0.13u W=1.8u AS=0.612p AD=0.612p
+ PS=4.28u PD=4.28u rfmode=0
M$185 \$40 \$246 VGND VGND sg13_lv_nmos L=0.13u W=18u AS=3.69p AD=3.69p
+ PS=23.9u PD=23.9u rfmode=0
M$196 tx_out tx_out tx_out VGND sg13_lv_nmos L=0.13u W=4u AS=1.36p AD=1.36p
+ PS=8.68u PD=8.68u rfmode=0
M$197 tx_out \$40 VGND VGND sg13_lv_nmos L=0.13u W=80u AS=15.8p AD=15.8p
+ PS=91.9u PD=91.9u rfmode=0
M$217 \$868 \$868 \$868 VGND sg13_lv_nmos L=0.13u W=0.4u AS=0.136p AD=0.136p
+ PS=1.48u PD=1.48u rfmode=0
M$218 \$1014 \$1014 \$1014 VGND sg13_lv_nmos L=0.13u W=1u AS=0.34p AD=0.34p
+ PS=3.36u PD=3.36u rfmode=0
M$219 \$868 \$1013 \$1014 VGND sg13_lv_nmos L=0.13u W=2u AS=0.44p AD=0.44p
+ PS=4.6u PD=4.6u rfmode=0
M$224 \$1012 \$1012 \$1012 VPWR sg13_lv_pmos L=0.13u W=0.95u AS=0.323p
+ AD=0.323p PS=3.26u PD=3.26u rfmode=0
M$226 \$1012 \$1035 VPWR VPWR sg13_lv_pmos L=0.13u W=5u AS=1.025p AD=1.025p
+ PS=9.6u PD=9.6u rfmode=0
M$236 clk_fb clk_fb clk_fb VPWR sg13_lv_pmos L=0.13u W=2.6u AS=0.884p AD=0.884p
+ PS=6.56u PD=6.56u rfmode=0
M$238 clk_fb \$482 VPWR VPWR sg13_lv_pmos L=0.13u W=13.5u AS=2.7675p AD=2.7675p
+ PS=18.95u PD=18.95u rfmode=0
M$249 \$482 \$482 \$482 VPWR sg13_lv_pmos L=0.13u W=0.45u AS=0.153p AD=0.153p
+ PS=1.58u PD=1.58u rfmode=0
M$250 \$482 \$868 VPWR VPWR sg13_lv_pmos L=0.13u W=4.5u AS=0.9225p AD=0.9225p
+ PS=9.05u PD=9.05u rfmode=0
M$260 \$482 \$482 \$482 VGND sg13_lv_nmos L=0.13u W=0.4u AS=0.136p AD=0.136p
+ PS=1.48u PD=1.48u rfmode=0
M$262 \$482 \$868 VGND VGND sg13_lv_nmos L=0.13u W=2u AS=0.44p AD=0.44p PS=4.6u
+ PD=4.6u rfmode=0
M$268 \$868 \$868 \$868 VPWR sg13_lv_pmos L=0.13u W=0.45u AS=0.153p AD=0.153p
+ PS=1.58u PD=1.58u rfmode=0
M$269 \$868 \$1013 \$1012 VPWR sg13_lv_pmos L=0.13u W=4.5u AS=0.9225p
+ AD=0.9225p PS=9.05u PD=9.05u rfmode=0
M$279 clk_fb clk_fb clk_fb VGND sg13_lv_nmos L=0.13u W=2.4u AS=0.816p AD=0.816p
+ PS=6.16u PD=6.16u rfmode=0
M$281 clk_fb \$482 VGND VGND sg13_lv_nmos L=0.13u W=6u AS=1.32p AD=1.32p
+ PS=9.4u PD=9.4u rfmode=0
M$286 \$246 \$246 \$246 VGND sg13_lv_nmos L=0.13u W=2.4u AS=0.816p AD=0.816p
+ PS=6.16u PD=6.16u rfmode=0
M$288 \$246 vctrl_b_out VGND VGND sg13_lv_nmos L=0.13u W=6u AS=1.32p AD=1.32p
+ PS=9.4u PD=9.4u rfmode=0
M$293 \$246 \$246 \$246 VPWR sg13_lv_pmos L=0.13u W=2.6u AS=0.884p AD=0.884p
+ PS=6.56u PD=6.56u rfmode=0
M$295 \$246 vctrl_b_out clk_fb VPWR sg13_lv_pmos L=0.13u W=13.5u AS=2.7675p
+ AD=2.7675p PS=18.95u PD=18.95u rfmode=0
M$305 tx_out tx_out tx_out VPWR sg13_lv_pmos L=0.13u W=4u AS=1.36p AD=1.36p
+ PS=8.68u PD=8.68u rfmode=0
M$307 tx_out \$40 VPWR VPWR sg13_lv_pmos L=0.13u W=200u AS=38.6p AD=38.6p
+ PS=223.3u PD=223.3u rfmode=0
M$359 \$1014 \$1028 VGND VGND sg13_lv_nmos L=0.13u W=3u AS=0.66p AD=0.66p
+ PS=5.8u PD=5.8u rfmode=0
M$365 VGND VGND VGND VPWR sg13_lv_pmos L=0.13u W=1.3u AS=0.442p AD=0.442p
+ PS=3.28u PD=3.28u rfmode=0
M$366 \$246 vctrl_out VGND VPWR sg13_lv_pmos L=0.13u W=13.5u AS=2.7675p
+ AD=2.7675p PS=18.95u PD=18.95u rfmode=0
M$378 \$246 vctrl_out clk_fb VGND sg13_lv_nmos L=0.13u W=6u AS=1.32p AD=1.32p
+ PS=9.4u PD=9.4u rfmode=0
M$383 \$1085 \$1085 \$1085 VGND sg13_lv_nmos L=0.13u W=0.4u AS=0.136p AD=0.136p
+ PS=1.48u PD=1.48u rfmode=0
M$384 \$1242 \$1242 \$1242 VGND sg13_lv_nmos L=0.13u W=1u AS=0.34p AD=0.34p
+ PS=3.36u PD=3.36u rfmode=0
M$385 \$1085 \$868 \$1242 VGND sg13_lv_nmos L=0.13u W=2u AS=0.44p AD=0.44p
+ PS=4.6u PD=4.6u rfmode=0
M$391 \$1028 \$1028 \$1028 VGND sg13_lv_nmos L=0.13u W=0.6u AS=0.204p AD=0.204p
+ PS=1.88u PD=1.88u rfmode=0
M$392 \$1028 \$1028 VGND VGND sg13_lv_nmos L=0.13u W=3u AS=0.66p AD=0.66p
+ PS=5.8u PD=5.8u rfmode=0
M$397 \$1028 \$1028 \$1028 VPWR sg13_lv_pmos L=0.13u W=0.5u AS=0.17p AD=0.17p
+ PS=1.68u PD=1.68u rfmode=0
M$399 \$1028 \$1035 VPWR VPWR sg13_lv_pmos L=0.13u W=5u AS=1.025p AD=1.025p
+ PS=9.6u PD=9.6u rfmode=0
M$410 \$1035 \$1035 \$1035 VPWR sg13_lv_pmos L=0.13u W=0.5u AS=0.17p AD=0.17p
+ PS=1.68u PD=1.68u rfmode=0
M$411 VPWR \$1035 \$1035 VPWR sg13_lv_pmos L=0.13u W=5u AS=1.025p AD=1.025p
+ PS=9.6u PD=9.6u rfmode=0
M$421 \$1035 \$1035 \$1035 VGND sg13_lv_nmos L=0.13u W=2u AS=0.68p AD=0.68p
+ PS=4.68u PD=4.68u rfmode=0
M$422 \$1151 \$1151 \$1151 VGND sg13_lv_nmos L=0.13u W=2u AS=0.68p AD=0.68p
+ PS=4.68u PD=4.68u rfmode=0
M$423 \$1151 \$1422 \$1035 VGND sg13_lv_nmos L=0.13u W=40u AS=7.9p AD=7.9p
+ PS=49.9u PD=49.9u rfmode=0
M$445 \$1242 \$1028 VGND VGND sg13_lv_nmos L=0.13u W=3u AS=0.66p AD=0.66p
+ PS=5.8u PD=5.8u rfmode=0
M$450 \$1239 \$1239 \$1239 VPWR sg13_lv_pmos L=0.13u W=0.95u AS=0.323p
+ AD=0.323p PS=3.26u PD=3.26u rfmode=0
M$452 \$1239 \$1035 VPWR VPWR sg13_lv_pmos L=0.13u W=5u AS=1.025p AD=1.025p
+ PS=9.6u PD=9.6u rfmode=0
M$463 \$1085 \$1085 \$1085 VPWR sg13_lv_pmos L=0.13u W=0.45u AS=0.153p
+ AD=0.153p PS=1.58u PD=1.58u rfmode=0
M$464 \$1085 \$868 \$1239 VPWR sg13_lv_pmos L=0.13u W=4.5u AS=0.9225p
+ AD=0.9225p PS=9.05u PD=9.05u rfmode=0
M$474 \$1148 \$1148 \$1148 VPWR sg13_lv_pmos L=0.13u W=0.95u AS=0.323p
+ AD=0.323p PS=3.26u PD=3.26u rfmode=0
M$475 \$1013 \$1013 \$1013 VPWR sg13_lv_pmos L=0.13u W=0.45u AS=0.153p
+ AD=0.153p PS=1.58u PD=1.58u rfmode=0
M$476 \$1013 \$1085 \$1148 VPWR sg13_lv_pmos L=0.13u W=4.5u AS=0.9225p
+ AD=0.9225p PS=9.05u PD=9.05u rfmode=0
M$486 \$1013 \$1013 \$1013 VGND sg13_lv_nmos L=0.13u W=0.4u AS=0.136p AD=0.136p
+ PS=1.48u PD=1.48u rfmode=0
M$487 \$1150 \$1150 \$1150 VGND sg13_lv_nmos L=0.13u W=1u AS=0.34p AD=0.34p
+ PS=3.36u PD=3.36u rfmode=0
M$488 \$1013 \$1085 \$1150 VGND sg13_lv_nmos L=0.13u W=2u AS=0.44p AD=0.44p
+ PS=4.6u PD=4.6u rfmode=0
M$495 \$1148 \$1035 VPWR VPWR sg13_lv_pmos L=0.13u W=5u AS=1.025p AD=1.025p
+ PS=9.6u PD=9.6u rfmode=0
M$507 \$1150 \$1028 VGND VGND sg13_lv_nmos L=0.13u W=3u AS=0.66p AD=0.66p
+ PS=5.8u PD=5.8u rfmode=0
M$513 \$2875 \$2785 VAPWR VAPWR sg13_hv_pmos L=4u W=2u AS=0.68p AD=0.68p
+ PS=4.68u PD=4.68u rfmode=0
M$514 \$2875 \$2875 \$2875 VAPWR sg13_hv_pmos L=4u W=2u AS=0.68p AD=0.68p
+ PS=4.68u PD=4.68u rfmode=0
M$515 \$185 \$185 \$185 VAPWR sg13_hv_pmos L=0.5u W=4u AS=1.36p AD=1.36p
+ PS=8.68u PD=8.68u rfmode=0
M$516 \$1846 \$1846 \$1846 VAPWR sg13_hv_pmos L=0.5u W=4u AS=1.36p AD=1.36p
+ PS=8.68u PD=8.68u rfmode=0
M$517 \$1248 \$1248 \$1248 VAPWR sg13_hv_pmos L=0.5u W=4u AS=1.36p AD=1.36p
+ PS=8.68u PD=8.68u rfmode=0
M$518 \$2688 \$2688 \$2688 VAPWR sg13_hv_pmos L=0.5u W=4u AS=1.36p AD=1.36p
+ PS=8.68u PD=8.68u rfmode=0
M$519 \$185 \$185 VAPWR VAPWR sg13_hv_pmos L=0.5u W=4u AS=1.36p AD=1.36p
+ PS=8.68u PD=8.68u rfmode=0
M$520 \$1846 \$1846 VAPWR VAPWR sg13_hv_pmos L=0.5u W=4u AS=1.36p AD=1.36p
+ PS=8.68u PD=8.68u rfmode=0
M$521 \$1248 \$1248 VAPWR VAPWR sg13_hv_pmos L=0.5u W=4u AS=1.36p AD=1.36p
+ PS=8.68u PD=8.68u rfmode=0
M$522 \$2688 \$2688 VAPWR VAPWR sg13_hv_pmos L=0.5u W=4u AS=1.36p AD=1.36p
+ PS=8.68u PD=8.68u rfmode=0
M$523 VAPWR VAPWR VAPWR VAPWR sg13_hv_pmos L=0.5u W=60u AS=20.4p AD=20.4p
+ PS=134.96u PD=134.96u rfmode=0
M$527 \$2782 \$2782 \$2782 VGND sg13_hv_nmos L=4u W=2u AS=0.68p AD=0.68p
+ PS=4.68u PD=4.68u rfmode=0
M$528 \$2875 \$2785 \$2782 VGND sg13_hv_nmos L=4u W=2u AS=0.68p AD=0.68p
+ PS=4.68u PD=4.68u rfmode=0
M$529 \$2875 \$2875 \$2875 VGND sg13_hv_nmos L=4u W=2u AS=0.68p AD=0.68p
+ PS=4.68u PD=4.68u rfmode=0
M$531 q3 \$2875 VPWR VPWR sg13_hv_pmos L=4u W=2u AS=0.68p AD=0.68p PS=4.68u
+ PD=4.68u rfmode=0
M$532 q3 q3 q3 VPWR sg13_hv_pmos L=4u W=2u AS=0.68p AD=0.68p PS=4.68u PD=4.68u
+ rfmode=0
M$533 \$3811 \$3811 \$3811 VAPWR sg13_hv_pmos L=0.5u W=2u AS=0.68p AD=0.68p
+ PS=4.68u PD=4.68u rfmode=0
M$535 \$3811 \$3811 VAPWR VAPWR sg13_hv_pmos L=0.5u W=14u AS=2.96p AD=2.96p
+ PS=18.96u PD=18.96u rfmode=0
M$542 opm opm opm VAPWR sg13_hv_pmos L=0.5u W=2u AS=0.68p AD=0.68p PS=4.68u
+ PD=4.68u rfmode=0
M$544 opm \$3811 VAPWR VAPWR sg13_hv_pmos L=0.5u W=14u AS=2.96p AD=2.96p
+ PS=18.96u PD=18.96u rfmode=0
M$551 \$1404 \$1404 \$1404 VAPWR sg13_hv_pmos L=0.5u W=2u AS=0.68p AD=0.68p
+ PS=4.68u PD=4.68u rfmode=0
M$552 \$4171 \$4171 \$4171 VAPWR sg13_hv_pmos L=0.5u W=2u AS=0.68p AD=0.68p
+ PS=4.68u PD=4.68u rfmode=0
M$553 \$2794 \$2794 \$2794 VAPWR sg13_hv_pmos L=0.5u W=2u AS=0.68p AD=0.68p
+ PS=4.68u PD=4.68u rfmode=0
M$557 \$1404 \$1404 VAPWR VAPWR sg13_hv_pmos L=0.5u W=14u AS=2.96p AD=2.96p
+ PS=18.96u PD=18.96u rfmode=0
M$564 \$4171 \$4171 VAPWR VAPWR sg13_hv_pmos L=0.5u W=14u AS=2.96p AD=2.96p
+ PS=18.96u PD=18.96u rfmode=0
M$571 \$2794 \$2794 VAPWR VAPWR sg13_hv_pmos L=0.5u W=14u AS=2.96p AD=2.96p
+ PS=18.96u PD=18.96u rfmode=0
M$578 Cap_M1 Cap_M1 Cap_M1 VGND sg13_hv_nmos L=0.5u W=1.5u AS=0.51p AD=0.51p
+ PS=4.36u PD=4.36u rfmode=0
M$579 Cap_M11 Cap_M11 Cap_M11 VGND sg13_hv_nmos L=0.5u W=1.5u AS=0.51p AD=0.51p
+ PS=4.36u PD=4.36u rfmode=0
M$580 lnaf lnaf lnaf VGND sg13_hv_nmos L=0.5u W=1.5u AS=0.51p AD=0.51p PS=4.36u
+ PD=4.36u rfmode=0
M$581 Cap_M1 \$1253 VGND VGND sg13_hv_nmos L=0.5u W=0.5u AS=0.17p AD=0.17p
+ PS=1.68u PD=1.68u rfmode=0
M$582 Cap_M11 \$2697 VGND VGND sg13_hv_nmos L=0.5u W=0.5u AS=0.17p AD=0.17p
+ PS=1.68u PD=1.68u rfmode=0
M$583 lnaf \$4123 VGND VGND sg13_hv_nmos L=0.5u W=0.5u AS=0.17p AD=0.17p
+ PS=1.68u PD=1.68u rfmode=0
M$587 Cap_M1 Cap_M1 Cap_M1 VAPWR sg13_hv_pmos L=0.5u W=2.7u AS=0.918p AD=0.918p
+ PS=6.76u PD=6.76u rfmode=0
M$588 Cap_M11 Cap_M11 Cap_M11 VAPWR sg13_hv_pmos L=0.5u W=2.7u AS=0.918p
+ AD=0.918p PS=6.76u PD=6.76u rfmode=0
M$589 lnaf lnaf lnaf VAPWR sg13_hv_pmos L=0.5u W=2.7u AS=0.918p AD=0.918p
+ PS=6.76u PD=6.76u rfmode=0
M$593 Cap_M1 \$1404 VAPWR VAPWR sg13_hv_pmos L=0.5u W=14u AS=2.96p AD=2.96p
+ PS=18.96u PD=18.96u rfmode=0
M$600 Cap_M11 \$2794 VAPWR VAPWR sg13_hv_pmos L=0.5u W=14u AS=2.96p AD=2.96p
+ PS=18.96u PD=18.96u rfmode=0
M$607 lnaf \$4171 VAPWR VAPWR sg13_hv_pmos L=0.5u W=14u AS=2.96p AD=2.96p
+ PS=18.96u PD=18.96u rfmode=0
M$614 \$871 \$871 \$871 VGND sg13_hv_nmos L=0.5u W=1u AS=0.34p AD=0.34p
+ PS=2.68u PD=2.68u rfmode=0
M$615 \$3959 \$3959 \$3959 VGND sg13_hv_nmos L=0.5u W=1u AS=0.34p AD=0.34p
+ PS=2.68u PD=2.68u rfmode=0
M$616 \$2469 \$2469 \$2469 VGND sg13_hv_nmos L=0.5u W=1u AS=0.34p AD=0.34p
+ PS=2.68u PD=2.68u rfmode=0
M$620 \$871 \$871 VGND VGND sg13_hv_nmos L=0.5u W=2u AS=0.53p AD=0.53p PS=4.06u
+ PD=4.06u rfmode=0
M$622 \$3959 \$3959 VGND VGND sg13_hv_nmos L=0.5u W=2u AS=0.53p AD=0.53p
+ PS=4.06u PD=4.06u rfmode=0
M$624 \$2469 \$2469 VGND VGND sg13_hv_nmos L=0.5u W=2u AS=0.53p AD=0.53p
+ PS=4.06u PD=4.06u rfmode=0
M$629 \$1152 \$1152 \$1152 VGND sg13_hv_nmos L=0.5u W=2u AS=0.68p AD=0.68p
+ PS=5.36u PD=5.36u rfmode=0
M$630 \$2690 \$2690 \$2690 VGND sg13_hv_nmos L=0.5u W=2u AS=0.68p AD=0.68p
+ PS=5.36u PD=5.36u rfmode=0
M$631 \$4115 \$4115 \$4115 VGND sg13_hv_nmos L=0.5u W=2u AS=0.68p AD=0.68p
+ PS=5.36u PD=5.36u rfmode=0
M$632 \$1152 rx_in VGND VGND sg13_hv_nmos L=0.5u W=18u AS=3.57p AD=3.57p
+ PS=26.14u PD=26.14u rfmode=0
M$650 \$2690 Cap_M2 VGND VGND sg13_hv_nmos L=0.5u W=18u AS=3.57p AD=3.57p
+ PS=26.14u PD=26.14u rfmode=0
M$668 \$4115 Cap_M21 VGND VGND sg13_hv_nmos L=0.5u W=18u AS=3.57p AD=3.57p
+ PS=26.14u PD=26.14u rfmode=0
M$686 \$1253 \$1253 \$1253 VGND sg13_hv_nmos L=0.5u W=0.5u AS=0.17p AD=0.17p
+ PS=1.68u PD=1.68u rfmode=0
M$687 \$2697 \$2697 \$2697 VGND sg13_hv_nmos L=0.5u W=0.5u AS=0.17p AD=0.17p
+ PS=1.68u PD=1.68u rfmode=0
M$688 \$4123 \$4123 \$4123 VGND sg13_hv_nmos L=0.5u W=0.5u AS=0.17p AD=0.17p
+ PS=1.68u PD=1.68u rfmode=0
M$689 \$1253 \$1253 VGND VGND sg13_hv_nmos L=0.5u W=0.5u AS=0.17p AD=0.17p
+ PS=1.68u PD=1.68u rfmode=0
M$690 \$2697 \$2697 VGND VGND sg13_hv_nmos L=0.5u W=0.5u AS=0.17p AD=0.17p
+ PS=1.68u PD=1.68u rfmode=0
M$691 \$4123 \$4123 VGND VGND sg13_hv_nmos L=0.5u W=0.5u AS=0.17p AD=0.17p
+ PS=1.68u PD=1.68u rfmode=0
M$695 VGND VGND VGND VAPWR sg13_hv_pmos L=0.5u W=2.1u AS=0.714p AD=0.714p
+ PS=6.24u PD=6.24u rfmode=0
M$698 VGND \$371 Cap_M1 VAPWR sg13_hv_pmos L=0.5u W=0.7u AS=0.238p AD=0.238p
+ PS=2.08u PD=2.08u rfmode=0
M$699 VGND \$3700 lnaf VAPWR sg13_hv_pmos L=0.5u W=0.7u AS=0.238p AD=0.238p
+ PS=2.08u PD=2.08u rfmode=0
M$700 VGND \$1852 Cap_M11 VAPWR sg13_hv_pmos L=0.5u W=0.7u AS=0.238p AD=0.238p
+ PS=2.08u PD=2.08u rfmode=0
M$710 Cap_M1 VAPWR \$1152 VGND sg13_hv_nmos L=0.5u W=2u AS=0.53p AD=0.53p
+ PS=4.06u PD=4.06u rfmode=0
M$712 Cap_M11 VAPWR \$2690 VGND sg13_hv_nmos L=0.5u W=2u AS=0.53p AD=0.53p
+ PS=4.06u PD=4.06u rfmode=0
M$714 lnaf VAPWR \$4115 VGND sg13_hv_nmos L=0.5u W=2u AS=0.53p AD=0.53p
+ PS=4.06u PD=4.06u rfmode=0
M$716 \$732 \$732 \$732 VGND sg13_hv_nmos L=0.5u W=0.5u AS=0.17p AD=0.17p
+ PS=1.68u PD=1.68u rfmode=0
M$717 \$3878 \$3878 \$3878 VGND sg13_hv_nmos L=0.5u W=0.5u AS=0.17p AD=0.17p
+ PS=1.68u PD=1.68u rfmode=0
M$718 \$2261 \$2261 \$2261 VGND sg13_hv_nmos L=0.5u W=0.5u AS=0.17p AD=0.17p
+ PS=1.68u PD=1.68u rfmode=0
M$719 \$732 Cap_M1 VGND VGND sg13_hv_nmos L=0.5u W=0.5u AS=0.17p AD=0.17p
+ PS=1.68u PD=1.68u rfmode=0
M$720 \$3878 lnaf VGND VGND sg13_hv_nmos L=0.5u W=0.5u AS=0.17p AD=0.17p
+ PS=1.68u PD=1.68u rfmode=0
M$721 \$2261 Cap_M11 VGND VGND sg13_hv_nmos L=0.5u W=0.5u AS=0.17p AD=0.17p
+ PS=1.68u PD=1.68u rfmode=0
M$725 VAPWR VAPWR VAPWR VGND sg13_hv_nmos L=0.5u W=4.5u AS=1.53p AD=1.53p
+ PS=11.04u PD=11.04u rfmode=0
M$728 VAPWR \$3878 \$3700 VGND sg13_hv_nmos L=0.5u W=1.5u AS=0.51p AD=0.51p
+ PS=3.68u PD=3.68u rfmode=0
M$729 VAPWR \$2261 \$1852 VGND sg13_hv_nmos L=0.5u W=1.5u AS=0.51p AD=0.51p
+ PS=3.68u PD=3.68u rfmode=0
M$730 VAPWR \$732 \$371 VGND sg13_hv_nmos L=0.5u W=1.5u AS=0.51p AD=0.51p
+ PS=3.68u PD=3.68u rfmode=0
M$731 \$3700 \$3700 \$3700 VGND sg13_hv_nmos L=0.5u W=3.5u AS=1.19p AD=1.19p
+ PS=8.36u PD=8.36u rfmode=0
M$732 \$1852 \$1852 \$1852 VGND sg13_hv_nmos L=0.5u W=3.5u AS=1.19p AD=1.19p
+ PS=8.36u PD=8.36u rfmode=0
M$733 \$371 \$371 \$371 VGND sg13_hv_nmos L=0.5u W=3.5u AS=1.19p AD=1.19p
+ PS=8.36u PD=8.36u rfmode=0
M$740 \$371 \$236 VGND VGND sg13_hv_nmos L=0.5u W=10u AS=2.2p AD=2.2p PS=14.2u
+ PD=14.2u rfmode=0
M$745 \$3700 \$3602 VGND VGND sg13_hv_nmos L=0.5u W=10u AS=2.2p AD=2.2p
+ PS=14.2u PD=14.2u rfmode=0
M$750 \$1852 \$1853 VGND VGND sg13_hv_nmos L=0.5u W=10u AS=2.2p AD=2.2p
+ PS=14.2u PD=14.2u rfmode=0
M$758 \$236 \$236 \$236 VGND sg13_hv_nmos L=0.5u W=2u AS=0.68p AD=0.68p
+ PS=4.68u PD=4.68u rfmode=0
M$759 \$3602 \$3602 \$3602 VGND sg13_hv_nmos L=0.5u W=2u AS=0.68p AD=0.68p
+ PS=4.68u PD=4.68u rfmode=0
M$760 \$1853 \$1853 \$1853 VGND sg13_hv_nmos L=0.5u W=2u AS=0.68p AD=0.68p
+ PS=4.68u PD=4.68u rfmode=0
M$761 \$236 \$236 VGND VGND sg13_hv_nmos L=0.5u W=10u AS=2.2p AD=2.2p PS=14.2u
+ PD=14.2u rfmode=0
M$766 \$3602 \$3602 VGND VGND sg13_hv_nmos L=0.5u W=10u AS=2.2p AD=2.2p
+ PS=14.2u PD=14.2u rfmode=0
M$771 \$1853 \$1853 VGND VGND sg13_hv_nmos L=0.5u W=10u AS=2.2p AD=2.2p
+ PS=14.2u PD=14.2u rfmode=0
M$779 \$732 \$732 \$732 VAPWR sg13_hv_pmos L=0.5u W=2u AS=0.68p AD=0.68p
+ PS=4.68u PD=4.68u rfmode=0
M$780 \$3878 \$3878 \$3878 VAPWR sg13_hv_pmos L=0.5u W=2u AS=0.68p AD=0.68p
+ PS=4.68u PD=4.68u rfmode=0
M$781 \$2261 \$2261 \$2261 VAPWR sg13_hv_pmos L=0.5u W=2u AS=0.68p AD=0.68p
+ PS=4.68u PD=4.68u rfmode=0
M$782 \$732 \$235 VAPWR VAPWR sg13_hv_pmos L=0.5u W=14u AS=2.96p AD=2.96p
+ PS=18.96u PD=18.96u rfmode=0
M$789 \$3878 \$3599 VAPWR VAPWR sg13_hv_pmos L=0.5u W=14u AS=2.96p AD=2.96p
+ PS=18.96u PD=18.96u rfmode=0
M$796 \$2261 \$1849 VAPWR VAPWR sg13_hv_pmos L=0.5u W=14u AS=2.96p AD=2.96p
+ PS=18.96u PD=18.96u rfmode=0
M$803 \$235 \$235 \$235 VAPWR sg13_hv_pmos L=0.5u W=2u AS=0.68p AD=0.68p
+ PS=4.68u PD=4.68u rfmode=0
M$804 \$3599 \$3599 \$3599 VAPWR sg13_hv_pmos L=0.5u W=2u AS=0.68p AD=0.68p
+ PS=4.68u PD=4.68u rfmode=0
M$805 \$1849 \$1849 \$1849 VAPWR sg13_hv_pmos L=0.5u W=2u AS=0.68p AD=0.68p
+ PS=4.68u PD=4.68u rfmode=0
M$809 \$235 \$235 VAPWR VAPWR sg13_hv_pmos L=0.5u W=14u AS=2.96p AD=2.96p
+ PS=18.96u PD=18.96u rfmode=0
M$816 \$3599 \$3599 VAPWR VAPWR sg13_hv_pmos L=0.5u W=14u AS=2.96p AD=2.96p
+ PS=18.96u PD=18.96u rfmode=0
M$823 \$1849 \$1849 VAPWR VAPWR sg13_hv_pmos L=0.5u W=14u AS=2.96p AD=2.96p
+ PS=18.96u PD=18.96u rfmode=0
M$830 VGND VGND VGND VGND sg13_hv_nmos L=4u W=8u AS=2.72p AD=2.72p PS=18.72u
+ PD=18.72u rfmode=0
M$831 q0 \$429 VGND VGND sg13_hv_nmos L=4u W=2u AS=0.68p AD=0.68p PS=4.68u
+ PD=4.68u rfmode=0
M$832 q0 q0 q0 VGND sg13_hv_nmos L=4u W=2u AS=0.68p AD=0.68p PS=4.68u PD=4.68u
+ rfmode=0
M$834 q2 \$2005 VGND VGND sg13_hv_nmos L=4u W=2u AS=0.68p AD=0.68p PS=4.68u
+ PD=4.68u rfmode=0
M$835 q2 q2 q2 VGND sg13_hv_nmos L=4u W=2u AS=0.68p AD=0.68p PS=4.68u PD=4.68u
+ rfmode=0
M$836 \$1841 \$1841 \$1841 VGND sg13_hv_nmos L=4u W=2u AS=0.68p AD=0.68p
+ PS=4.68u PD=4.68u rfmode=0
M$837 \$2005 \$1923 \$1841 VGND sg13_hv_nmos L=4u W=2u AS=0.68p AD=0.68p
+ PS=4.68u PD=4.68u rfmode=0
M$838 \$2005 \$2005 \$2005 VGND sg13_hv_nmos L=4u W=2u AS=0.68p AD=0.68p
+ PS=4.68u PD=4.68u rfmode=0
M$840 q2 \$2005 VPWR VPWR sg13_hv_pmos L=4u W=2u AS=0.68p AD=0.68p PS=4.68u
+ PD=4.68u rfmode=0
M$841 q2 q2 q2 VPWR sg13_hv_pmos L=4u W=2u AS=0.68p AD=0.68p PS=4.68u PD=4.68u
+ rfmode=0
M$843 \$2005 \$1923 VAPWR VAPWR sg13_hv_pmos L=4u W=2u AS=0.68p AD=0.68p
+ PS=4.68u PD=4.68u rfmode=0
M$844 \$2005 \$2005 \$2005 VAPWR sg13_hv_pmos L=4u W=2u AS=0.68p AD=0.68p
+ PS=4.68u PD=4.68u rfmode=0
M$849 \$297 \$185 VAPWR VAPWR sg13_hv_pmos L=0.5u W=4u AS=1.36p AD=1.36p
+ PS=8.68u PD=8.68u rfmode=0
M$850 \$2787 \$2688 VAPWR VAPWR sg13_hv_pmos L=0.5u W=4u AS=1.36p AD=1.36p
+ PS=8.68u PD=8.68u rfmode=0
M$851 \$1334 \$1248 VAPWR VAPWR sg13_hv_pmos L=0.5u W=4u AS=1.36p AD=1.36p
+ PS=8.68u PD=8.68u rfmode=0
M$852 \$1926 \$1846 VAPWR VAPWR sg13_hv_pmos L=0.5u W=4u AS=1.36p AD=1.36p
+ PS=8.68u PD=8.68u rfmode=0
M$858 q1 \$1461 VGND VGND sg13_hv_nmos L=4u W=2u AS=0.68p AD=0.68p PS=4.68u
+ PD=4.68u rfmode=0
M$859 q1 q1 q1 VGND sg13_hv_nmos L=4u W=2u AS=0.68p AD=0.68p PS=4.68u PD=4.68u
+ rfmode=0
M$861 q3 \$2875 VGND VGND sg13_hv_nmos L=4u W=2u AS=0.68p AD=0.68p PS=4.68u
+ PD=4.68u rfmode=0
M$862 q3 q3 q3 VGND sg13_hv_nmos L=4u W=2u AS=0.68p AD=0.68p PS=4.68u PD=4.68u
+ rfmode=0
.ENDS ook_analog_system

.SUBCKT sg13cmos5l_or4_1 VDD VSS B D A C X
M$1 VSS D \$7 VSS sg13_lv_nmos L=0.13u W=0.55u AS=0.187p AD=0.1045p PS=1.78u
+ PD=0.93u rfmode=0
M$2 VSS C \$7 VSS sg13_lv_nmos L=0.13u W=0.55u AS=0.16755p AD=0.1045p PS=1.165u
+ PD=0.93u rfmode=0
M$3 VSS B \$7 VSS sg13_lv_nmos L=0.13u W=0.55u AS=0.16755p AD=0.1045p PS=1.165u
+ PD=0.93u rfmode=0
M$4 VSS A \$7 VSS sg13_lv_nmos L=0.13u W=0.55u AS=0.14135p AD=0.1045p PS=1.14u
+ PD=0.93u rfmode=0
M$5 VSS \$7 X VSS sg13_lv_nmos L=0.13u W=0.74u AS=0.14135p AD=0.2516p PS=1.14u
+ PD=2.16u rfmode=0
M$6 \$7 D \$11 VDD sg13_lv_pmos L=0.13u W=1u AS=0.34p AD=0.19p PS=2.68u
+ PD=1.38u rfmode=0
M$7 \$11 C \$10 VDD sg13_lv_pmos L=0.13u W=1u AS=0.19p AD=0.2925p PS=1.38u
+ PD=1.585u rfmode=0
M$8 \$10 B \$9 VDD sg13_lv_pmos L=0.13u W=1u AS=0.2925p AD=0.19p PS=1.585u
+ PD=1.38u rfmode=0
M$9 VDD A \$9 VDD sg13_lv_pmos L=0.13u W=1u AS=0.2144p AD=0.19p PS=1.52u
+ PD=1.38u rfmode=0
M$10 VDD \$7 X VDD sg13_lv_pmos L=0.13u W=1.12u AS=0.2144p AD=0.3808p PS=1.52u
+ PD=2.92u rfmode=0
.ENDS sg13cmos5l_or4_1

.SUBCKT sg13cmos5l_mux2_1 VSS X S A1 A0 VDD
M$1 VSS S \$2 VSS sg13_lv_nmos L=0.13u W=0.55u AS=0.18945p AD=0.187p PS=1.27u
+ PD=1.78u rfmode=0
M$2 VSS S \$8 VSS sg13_lv_nmos L=0.13u W=0.74u AS=0.18945p AD=0.13135p PS=1.27u
+ PD=1.095u rfmode=0
M$3 \$8 A1 \$3 VSS sg13_lv_nmos L=0.13u W=0.74u AS=0.13135p AD=0.1628p
+ PS=1.095u PD=1.18u rfmode=0
M$4 \$3 A0 \$9 VSS sg13_lv_nmos L=0.13u W=0.74u AS=0.1628p AD=0.3367p PS=1.18u
+ PD=1.65u rfmode=0
M$5 \$9 \$2 VSS VSS sg13_lv_nmos L=0.13u W=0.74u AS=0.3367p AD=0.148p PS=1.65u
+ PD=1.14u rfmode=0
M$6 VSS \$3 X VSS sg13_lv_nmos L=0.13u W=0.74u AS=0.148p AD=0.4033p PS=1.14u
+ PD=2.57u rfmode=0
M$7 \$2 S VDD VDD sg13_lv_pmos L=0.13u W=0.84u AS=0.2856p AD=0.253p PS=2.36u
+ PD=1.53u rfmode=0
M$8 VDD S \$10 VDD sg13_lv_pmos L=0.13u W=1u AS=0.253p AD=0.3325p PS=1.53u
+ PD=1.665u rfmode=0
M$9 \$10 A0 \$3 VDD sg13_lv_pmos L=0.13u W=1u AS=0.3325p AD=0.2225p PS=1.665u
+ PD=1.445u rfmode=0
M$10 \$3 A1 \$11 VDD sg13_lv_pmos L=0.13u W=1u AS=0.2225p AD=0.2975p PS=1.445u
+ PD=1.595u rfmode=0
M$11 \$11 \$2 VDD VDD sg13_lv_pmos L=0.13u W=1u AS=0.2975p AD=0.2198p PS=1.595u
+ PD=1.52u rfmode=0
M$12 VDD \$3 X VDD sg13_lv_pmos L=0.13u W=1.12u AS=0.2198p AD=0.6048p PS=1.52u
+ PD=3.32u rfmode=0
.ENDS sg13cmos5l_mux2_1

.SUBCKT sg13cmos5l_nand4_1 VDD A VSS Y B C D
M$1 VSS D \$10 VSS sg13_lv_nmos L=0.13u W=0.74u AS=0.2516p AD=0.1406p PS=2.16u
+ PD=1.12u rfmode=0
M$2 \$10 C \$9 VSS sg13_lv_nmos L=0.13u W=0.74u AS=0.1406p AD=0.1406p PS=1.12u
+ PD=1.12u rfmode=0
M$3 \$9 B \$8 VSS sg13_lv_nmos L=0.13u W=0.74u AS=0.1406p AD=0.1406p PS=1.12u
+ PD=1.12u rfmode=0
M$4 \$8 A Y VSS sg13_lv_nmos L=0.13u W=0.74u AS=0.1406p AD=0.2516p PS=1.12u
+ PD=2.16u rfmode=0
M$5 VDD D Y VDD sg13_lv_pmos L=0.13u W=1.12u AS=0.3808p AD=0.2128p PS=2.92u
+ PD=1.5u rfmode=0
M$6 Y C VDD VDD sg13_lv_pmos L=0.13u W=1.12u AS=0.2128p AD=0.2128p PS=1.5u
+ PD=1.5u rfmode=0
M$7 VDD B Y VDD sg13_lv_pmos L=0.13u W=1.12u AS=0.2128p AD=0.2128p PS=1.5u
+ PD=1.5u rfmode=0
M$8 Y A VDD VDD sg13_lv_pmos L=0.13u W=1.12u AS=0.2128p AD=0.3808p PS=1.5u
+ PD=2.92u rfmode=0
.ENDS sg13cmos5l_nand4_1

.SUBCKT sg13cmos5l_a22oi_1 Y VSS VDD A2 B2 B1 A1
M$1 VSS B1 \$10 VSS sg13_lv_nmos L=0.13u W=0.74u AS=0.2553p AD=0.13875p
+ PS=2.17u PD=1.115u rfmode=0
M$2 \$10 B2 Y VSS sg13_lv_nmos L=0.13u W=0.74u AS=0.13875p AD=0.2664p PS=1.115u
+ PD=1.46u rfmode=0
M$3 Y A1 \$9 VSS sg13_lv_nmos L=0.13u W=0.74u AS=0.2664p AD=0.0962p PS=1.46u
+ PD=1u rfmode=0
M$4 \$9 A2 VSS VSS sg13_lv_nmos L=0.13u W=0.74u AS=0.0962p AD=0.2516p PS=1u
+ PD=2.16u rfmode=0
M$5 VDD A1 \$5 VDD sg13_lv_pmos L=0.13u W=1.12u AS=0.3808p AD=0.2716p PS=2.92u
+ PD=1.605u rfmode=0
M$6 \$5 B1 Y VDD sg13_lv_pmos L=0.13u W=1.12u AS=0.2716p AD=0.2128p PS=1.605u
+ PD=1.5u rfmode=0
M$7 Y B2 \$5 VDD sg13_lv_pmos L=0.13u W=1.12u AS=0.2128p AD=0.2744p PS=1.5u
+ PD=1.61u rfmode=0
M$8 \$5 A2 VDD VDD sg13_lv_pmos L=0.13u W=1.12u AS=0.2744p AD=0.3808p PS=1.61u
+ PD=2.92u rfmode=0
.ENDS sg13cmos5l_a22oi_1

.SUBCKT sg13cmos5l_buf_8 VSS A X VDD
M$1 \$2 A VSS VSS sg13_lv_nmos L=0.13u W=2.22u AS=0.5365p AD=0.4218p PS=4.41u
+ PD=3.36u rfmode=0
M$4 VSS \$2 X VSS sg13_lv_nmos L=0.13u W=5.92u AS=1.1248p AD=1.2358p PS=8.96u
+ PD=10u rfmode=0
M$12 \$2 A VDD VDD sg13_lv_pmos L=0.13u W=3.36u AS=0.8064p AD=0.6384p PS=5.92u
+ PD=4.5u rfmode=0
M$15 VDD \$2 X VDD sg13_lv_pmos L=0.13u W=8.96u AS=1.7024p AD=1.876p PS=12u
+ PD=13.43u rfmode=0
.ENDS sg13cmos5l_buf_8

.SUBCKT sg13cmos5l_nand3_1 VSS VDD Y B C A
M$1 VSS C \$8 VSS sg13_lv_nmos L=0.13u W=0.74u AS=0.2886p AD=0.1406p PS=2.26u
+ PD=1.12u rfmode=0
M$2 \$8 B \$7 VSS sg13_lv_nmos L=0.13u W=0.74u AS=0.1406p AD=0.1406p PS=1.12u
+ PD=1.12u rfmode=0
M$3 \$7 A Y VSS sg13_lv_nmos L=0.13u W=0.74u AS=0.1406p AD=0.2516p PS=1.12u
+ PD=2.16u rfmode=0
M$4 VDD C Y VDD sg13_lv_pmos L=0.13u W=1.12u AS=0.3808p AD=0.2128p PS=2.92u
+ PD=1.5u rfmode=0
M$5 Y B VDD VDD sg13_lv_pmos L=0.13u W=1.12u AS=0.2128p AD=0.2128p PS=1.5u
+ PD=1.5u rfmode=0
M$6 VDD A Y VDD sg13_lv_pmos L=0.13u W=1.12u AS=0.2128p AD=0.3808p PS=1.5u
+ PD=2.92u rfmode=0
.ENDS sg13cmos5l_nand3_1

.SUBCKT sg13cmos5l_or3_1 VDD VSS C A B X
M$1 \$6 C VSS VSS sg13_lv_nmos L=0.13u W=0.55u AS=0.187p AD=0.1045p PS=1.78u
+ PD=0.93u rfmode=0
M$2 VSS B \$6 VSS sg13_lv_nmos L=0.13u W=0.55u AS=0.1045p AD=0.198p PS=0.93u
+ PD=1.27u rfmode=0
M$3 \$6 A VSS VSS sg13_lv_nmos L=0.13u W=0.55u AS=0.198p AD=0.13395p PS=1.27u
+ PD=1.12u rfmode=0
M$4 VSS \$6 X VSS sg13_lv_nmos L=0.13u W=0.74u AS=0.13395p AD=0.2516p PS=1.12u
+ PD=2.16u rfmode=0
M$5 \$6 C \$9 VDD sg13_lv_pmos L=0.13u W=1u AS=0.34p AD=0.19p PS=2.68u PD=1.38u
+ rfmode=0
M$6 \$9 B \$8 VDD sg13_lv_pmos L=0.13u W=1u AS=0.19p AD=0.1575p PS=1.38u
+ PD=1.315u rfmode=0
M$7 \$8 A VDD VDD sg13_lv_pmos L=0.13u W=1u AS=0.1575p AD=0.3822p PS=1.315u
+ PD=1.84u rfmode=0
M$8 VDD \$6 X VDD sg13_lv_pmos L=0.13u W=1.12u AS=0.3822p AD=0.3808p PS=1.84u
+ PD=2.92u rfmode=0
.ENDS sg13cmos5l_or3_1

.SUBCKT sg13cmos5l_nor4_1 VDD VSS B A C D Y
M$1 VSS A Y VSS sg13_lv_nmos L=0.13u W=0.74u AS=0.2516p AD=0.1406p PS=2.16u
+ PD=1.12u rfmode=0
M$2 Y B VSS VSS sg13_lv_nmos L=0.13u W=0.74u AS=0.1406p AD=0.1406p PS=1.12u
+ PD=1.12u rfmode=0
M$3 VSS C Y VSS sg13_lv_nmos L=0.13u W=0.74u AS=0.1406p AD=0.1406p PS=1.12u
+ PD=1.12u rfmode=0
M$4 Y D VSS VSS sg13_lv_nmos L=0.13u W=0.74u AS=0.1406p AD=0.237575p PS=1.12u
+ PD=2.16u rfmode=0
M$5 VDD A \$9 VDD sg13_lv_pmos L=0.13u W=1.12u AS=0.3808p AD=0.2128p PS=2.92u
+ PD=1.5u rfmode=0
M$6 \$9 B \$8 VDD sg13_lv_pmos L=0.13u W=1.12u AS=0.2128p AD=0.2128p PS=1.5u
+ PD=1.5u rfmode=0
M$7 \$8 C \$10 VDD sg13_lv_pmos L=0.13u W=1.12u AS=0.2128p AD=0.2128p PS=1.5u
+ PD=1.5u rfmode=0
M$8 \$10 D Y VDD sg13_lv_pmos L=0.13u W=1.12u AS=0.2128p AD=0.4368p PS=1.5u
+ PD=3.02u rfmode=0
.ENDS sg13cmos5l_nor4_1

.SUBCKT sg13cmos5l_decap_4 VDD VSS
M$1 VSS VDD VSS VSS sg13_lv_nmos L=1u W=0.42u AS=0.1428p AD=0.1428p PS=1.52u
+ PD=1.52u rfmode=0
M$2 VDD VSS VDD VDD sg13_lv_pmos L=1u W=1u AS=0.34p AD=0.34p PS=2.68u PD=2.68u
+ rfmode=0
.ENDS sg13cmos5l_decap_4

.SUBCKT sg13cmos5l_nor2b_1 VSS VDD Y A B_N
M$1 VSS B_N \$5 VSS sg13_lv_nmos L=0.13u W=0.55u AS=0.17255p AD=0.187p PS=1.25u
+ PD=1.78u rfmode=0
M$2 VSS \$5 Y VSS sg13_lv_nmos L=0.13u W=0.74u AS=0.17255p AD=0.1406p PS=1.25u
+ PD=1.12u rfmode=0
M$3 Y A VSS VSS sg13_lv_nmos L=0.13u W=0.74u AS=0.1406p AD=0.2516p PS=1.12u
+ PD=2.16u rfmode=0
M$4 \$5 B_N VDD VDD sg13_lv_pmos L=0.13u W=0.84u AS=0.2856p AD=0.2618p PS=2.36u
+ PD=1.63u rfmode=0
M$5 VDD \$5 \$7 VDD sg13_lv_pmos L=0.13u W=1.12u AS=0.2618p AD=0.1176p PS=1.63u
+ PD=1.33u rfmode=0
M$6 \$7 A Y VDD sg13_lv_pmos L=0.13u W=1.12u AS=0.1176p AD=0.3808p PS=1.33u
+ PD=2.92u rfmode=0
.ENDS sg13cmos5l_nor2b_1

.SUBCKT sg13cmos5l_and2_1 VDD VSS X A B
M$1 \$4 A \$7 VSS sg13_lv_nmos L=0.13u W=0.64u AS=0.2176p AD=0.1216p PS=1.96u
+ PD=1.02u rfmode=0
M$2 VSS B \$7 VSS sg13_lv_nmos L=0.13u W=0.64u AS=0.1331p AD=0.1216p PS=1.12u
+ PD=1.02u rfmode=0
M$3 VSS \$4 X VSS sg13_lv_nmos L=0.13u W=0.74u AS=0.1331p AD=0.2516p PS=1.12u
+ PD=2.16u rfmode=0
M$4 VDD A \$4 VDD sg13_lv_pmos L=0.13u W=0.84u AS=0.2856p AD=0.1596p PS=2.36u
+ PD=1.22u rfmode=0
M$5 VDD B \$4 VDD sg13_lv_pmos L=0.13u W=0.84u AS=0.1918p AD=0.1596p PS=1.5u
+ PD=1.22u rfmode=0
M$6 VDD \$4 X VDD sg13_lv_pmos L=0.13u W=1.12u AS=0.1918p AD=0.3808p PS=1.5u
+ PD=2.92u rfmode=0
.ENDS sg13cmos5l_and2_1

.SUBCKT sg13cmos5l_or2_1 A X B VDD VSS
M$1 VSS B \$6 VSS sg13_lv_nmos L=0.13u W=0.55u AS=0.187p AD=0.1045p PS=1.78u
+ PD=0.93u rfmode=0
M$2 \$6 A VSS VSS sg13_lv_nmos L=0.13u W=0.55u AS=0.1045p AD=0.1469p PS=0.93u
+ PD=1.155u rfmode=0
M$3 VSS \$6 X VSS sg13_lv_nmos L=0.13u W=0.74u AS=0.1469p AD=0.2516p PS=1.155u
+ PD=2.16u rfmode=0
M$4 \$6 B \$7 VDD sg13_lv_pmos L=0.13u W=0.84u AS=0.2856p AD=0.1596p PS=2.36u
+ PD=1.22u rfmode=0
M$5 VDD A \$7 VDD sg13_lv_pmos L=0.13u W=0.84u AS=0.2226p AD=0.1596p PS=1.535u
+ PD=1.22u rfmode=0
M$6 VDD \$6 X VDD sg13_lv_pmos L=0.13u W=1.12u AS=0.2226p AD=0.3976p PS=1.535u
+ PD=2.95u rfmode=0
.ENDS sg13cmos5l_or2_1

.SUBCKT sg13cmos5l_nand2_1 VDD VSS Y A B
M$1 VSS B \$6 VSS sg13_lv_nmos L=0.13u W=0.74u AS=0.2516p AD=0.1406p PS=2.16u
+ PD=1.12u rfmode=0
M$2 \$6 A Y VSS sg13_lv_nmos L=0.13u W=0.74u AS=0.1406p AD=0.2516p PS=1.12u
+ PD=2.16u rfmode=0
M$3 VDD B Y VDD sg13_lv_pmos L=0.13u W=1.12u AS=0.3808p AD=0.2128p PS=2.92u
+ PD=1.5u rfmode=0
M$4 Y A VDD VDD sg13_lv_pmos L=0.13u W=1.12u AS=0.2128p AD=0.3808p PS=1.5u
+ PD=2.92u rfmode=0
.ENDS sg13cmos5l_nand2_1

.SUBCKT sg13cmos5l_decap_8 VDD VSS
M$1 VSS VDD VSS VSS sg13_lv_nmos L=1u W=0.84u AS=0.2226p AD=0.2226p PS=2.32u
+ PD=2.32u rfmode=0
M$3 VDD VSS VDD VDD sg13_lv_pmos L=1u W=2u AS=0.53p AD=0.53p PS=4.06u PD=4.06u
+ rfmode=0
.ENDS sg13cmos5l_decap_8

.SUBCKT sg13cmos5l_a221oi_1 VSS B1 VDD Y B2 C1 A1 A2
M$1 Y A1 \$11 VSS sg13_lv_nmos L=0.13u W=0.74u AS=0.2516p AD=0.1406p PS=2.16u
+ PD=1.12u rfmode=0
M$2 \$11 A2 VSS VSS sg13_lv_nmos L=0.13u W=0.74u AS=0.1406p AD=0.2516p PS=1.12u
+ PD=2.16u rfmode=0
M$3 Y C1 VSS VSS sg13_lv_nmos L=0.13u W=0.74u AS=0.2516p AD=0.1406p PS=2.16u
+ PD=1.12u rfmode=0
M$4 VSS B2 \$12 VSS sg13_lv_nmos L=0.13u W=0.74u AS=0.1406p AD=0.1406p PS=1.12u
+ PD=1.12u rfmode=0
M$5 \$12 B1 Y VSS sg13_lv_nmos L=0.13u W=0.74u AS=0.1406p AD=0.2516p PS=1.12u
+ PD=2.16u rfmode=0
M$6 VDD A1 \$9 VDD sg13_lv_pmos L=0.13u W=1.12u AS=0.3808p AD=0.2128p PS=2.92u
+ PD=1.5u rfmode=0
M$7 \$9 A2 VDD VDD sg13_lv_pmos L=0.13u W=1.12u AS=0.2128p AD=0.3808p PS=1.5u
+ PD=2.92u rfmode=0
M$8 Y C1 \$6 VDD sg13_lv_pmos L=0.13u W=1.12u AS=0.3808p AD=0.2128p PS=2.92u
+ PD=1.5u rfmode=0
M$9 \$6 B2 \$9 VDD sg13_lv_pmos L=0.13u W=1.12u AS=0.2128p AD=0.2128p PS=1.5u
+ PD=1.5u rfmode=0
M$10 \$9 B1 \$6 VDD sg13_lv_pmos L=0.13u W=1.12u AS=0.2128p AD=0.3808p PS=1.5u
+ PD=2.92u rfmode=0
.ENDS sg13cmos5l_a221oi_1

.SUBCKT sg13cmos5l_xnor2_1 VDD VSS Y B A
M$1 VSS A \$8 VSS sg13_lv_nmos L=0.13u W=0.64u AS=0.2272p AD=0.0784p PS=1.99u
+ PD=0.885u rfmode=0
M$2 \$8 B \$7 VSS sg13_lv_nmos L=0.13u W=0.64u AS=0.0784p AD=0.2176p PS=0.885u
+ PD=1.96u rfmode=0
M$3 VSS A \$3 VSS sg13_lv_nmos L=0.13u W=0.74u AS=0.1898p AD=0.2516p PS=1.36u
+ PD=2.16u rfmode=0
M$4 VSS B \$3 VSS sg13_lv_nmos L=0.13u W=0.74u AS=0.1898p AD=0.1406p PS=1.36u
+ PD=1.12u rfmode=0
M$5 \$3 \$7 Y VSS sg13_lv_nmos L=0.13u W=0.74u AS=0.1406p AD=0.2516p PS=1.12u
+ PD=2.16u rfmode=0
M$6 VDD A \$7 VDD sg13_lv_pmos L=0.13u W=0.84u AS=0.4536p AD=0.1596p PS=2.76u
+ PD=1.22u rfmode=0
M$7 VDD B \$7 VDD sg13_lv_pmos L=0.13u W=0.84u AS=0.2891p AD=0.1596p PS=1.695u
+ PD=1.22u rfmode=0
M$8 VDD A \$9 VDD sg13_lv_pmos L=0.13u W=1.12u AS=0.2891p AD=0.1428p PS=1.695u
+ PD=1.375u rfmode=0
M$9 \$9 B Y VDD sg13_lv_pmos L=0.13u W=1.12u AS=0.1428p AD=0.2408p PS=1.375u
+ PD=1.55u rfmode=0
M$10 Y \$7 VDD VDD sg13_lv_pmos L=0.13u W=1.12u AS=0.2408p AD=0.3808p PS=1.55u
+ PD=2.92u rfmode=0
.ENDS sg13cmos5l_xnor2_1

.SUBCKT sg13cmos5l_nor3_1 VDD VSS C Y B A
M$1 VSS A Y VSS sg13_lv_nmos L=0.13u W=0.77u AS=0.2618p AD=0.1694p PS=2.22u
+ PD=1.21u rfmode=0
M$2 Y B VSS VSS sg13_lv_nmos L=0.13u W=0.77u AS=0.1694p AD=0.1463p PS=1.21u
+ PD=1.15u rfmode=0
M$3 VSS C Y VSS sg13_lv_nmos L=0.13u W=0.77u AS=0.1463p AD=0.2618p PS=1.15u
+ PD=2.22u rfmode=0
M$4 VDD A \$8 VDD sg13_lv_pmos L=0.13u W=1.12u AS=0.3808p AD=0.2464p PS=2.92u
+ PD=1.56u rfmode=0
M$5 \$8 B \$7 VDD sg13_lv_pmos L=0.13u W=1.12u AS=0.2464p AD=0.2128p PS=1.56u
+ PD=1.5u rfmode=0
M$6 \$7 C Y VDD sg13_lv_pmos L=0.13u W=1.12u AS=0.2128p AD=0.3808p PS=1.5u
+ PD=2.92u rfmode=0
.ENDS sg13cmos5l_nor3_1

.SUBCKT sg13cmos5l_dfrbpq_1 VSS RESET_B Q D CLK VDD
M$1 VSS \$4 \$18 VSS sg13_lv_nmos L=0.13u W=0.74u AS=0.317325p AD=0.2516p
+ PS=1.805u PD=2.16u rfmode=0
M$2 VSS CLK \$4 VSS sg13_lv_nmos L=0.13u W=0.74u AS=0.317325p AD=0.2516p
+ PS=1.805u PD=2.16u rfmode=0
M$3 \$14 \$4 \$7 VSS sg13_lv_nmos L=0.13u W=0.42u AS=0.12665p AD=0.1428p
+ PS=1.145u PD=1.52u rfmode=0
M$4 \$3 \$18 \$14 VSS sg13_lv_nmos L=0.13u W=0.74u AS=0.3473p AD=0.12665p
+ PS=2.71u PD=1.145u rfmode=0
M$5 \$5 D \$15 VSS sg13_lv_nmos L=0.13u W=0.42u AS=0.1428p AD=0.0609p PS=1.52u
+ PD=0.71u rfmode=0
M$6 \$15 RESET_B VSS VSS sg13_lv_nmos L=0.13u W=0.42u AS=0.0609p AD=0.1626p
+ PS=0.71u PD=1.415u rfmode=0
M$7 VSS \$12 \$3 VSS sg13_lv_nmos L=0.13u W=0.74u AS=0.1626p AD=0.2516p
+ PS=1.415u PD=2.16u rfmode=0
M$8 \$9 \$14 VSS VSS sg13_lv_nmos L=0.13u W=0.74u AS=0.2516p AD=0.1406p
+ PS=2.16u PD=1.12u rfmode=0
M$9 VSS \$9 Q VSS sg13_lv_nmos L=0.13u W=0.74u AS=0.1406p AD=0.2516p PS=1.12u
+ PD=2.16u rfmode=0
M$10 \$5 \$4 \$12 VSS sg13_lv_nmos L=0.13u W=0.42u AS=0.1296p AD=0.0798p
+ PS=1.52u PD=0.8u rfmode=0
M$11 \$12 \$18 \$6 VSS sg13_lv_nmos L=0.13u W=0.42u AS=0.0798p AD=0.2373p
+ PS=0.8u PD=1.97u rfmode=0
M$12 \$7 \$8 VSS VSS sg13_lv_nmos L=0.13u W=0.42u AS=0.1428p AD=0.0798p
+ PS=1.52u PD=0.8u rfmode=0
M$13 VSS RESET_B \$17 VSS sg13_lv_nmos L=0.13u W=0.42u AS=0.0798p AD=0.0378p
+ PS=0.8u PD=0.6u rfmode=0
M$14 \$17 \$14 \$8 VSS sg13_lv_nmos L=0.13u W=0.42u AS=0.0378p AD=0.1428p
+ PS=0.6u PD=1.52u rfmode=0
M$15 VSS RESET_B \$16 VSS sg13_lv_nmos L=0.13u W=0.42u AS=0.1701p AD=0.0378p
+ PS=1.65u PD=0.6u rfmode=0
M$16 \$16 \$3 \$6 VSS sg13_lv_nmos L=0.13u W=0.42u AS=0.0378p AD=0.1428p
+ PS=0.6u PD=1.52u rfmode=0
M$17 \$14 \$18 \$21 VDD sg13_lv_pmos L=0.13u W=0.42u AS=0.2048p AD=0.09345p
+ PS=1.63u PD=0.865u rfmode=0
M$18 \$21 \$8 VDD VDD sg13_lv_pmos L=0.13u W=0.42u AS=0.09345p AD=0.204p
+ PS=0.865u PD=1.835u rfmode=0
M$19 VDD RESET_B \$8 VDD sg13_lv_pmos L=0.13u W=0.42u AS=0.204p AD=0.0798p
+ PS=1.835u PD=0.8u rfmode=0
M$20 \$8 \$14 VDD VDD sg13_lv_pmos L=0.13u W=0.42u AS=0.0798p AD=0.4659p
+ PS=0.8u PD=3.65u rfmode=0
M$21 \$3 \$4 \$14 VDD sg13_lv_pmos L=0.13u W=1u AS=0.34p AD=0.2048p PS=2.68u
+ PD=1.63u rfmode=0
M$22 \$9 \$14 VDD VDD sg13_lv_pmos L=0.13u W=1.12u AS=0.3864p AD=0.2128p
+ PS=2.93u PD=1.5u rfmode=0
M$23 VDD \$9 Q VDD sg13_lv_pmos L=0.13u W=1.12u AS=0.2128p AD=0.3808p PS=1.5u
+ PD=2.92u rfmode=0
M$24 VDD D \$5 VDD sg13_lv_pmos L=0.13u W=0.42u AS=0.1428p AD=0.0798p PS=1.52u
+ PD=0.8u rfmode=0
M$25 VDD RESET_B \$5 VDD sg13_lv_pmos L=0.13u W=0.42u AS=0.3623875p AD=0.0798p
+ PS=2.605u PD=0.8u rfmode=0
M$26 VDD \$12 \$3 VDD sg13_lv_pmos L=0.13u W=1u AS=0.3623875p AD=0.34p
+ PS=2.605u PD=2.68u rfmode=0
M$27 \$18 \$4 VDD VDD sg13_lv_pmos L=0.13u W=1.12u AS=0.3864p AD=0.41165p
+ PS=2.93u PD=2.12u rfmode=0
M$28 VDD CLK \$4 VDD sg13_lv_pmos L=0.13u W=1.12u AS=0.41165p AD=0.4088p
+ PS=2.12u PD=2.97u rfmode=0
M$29 \$12 RESET_B VDD VDD sg13_lv_pmos L=0.13u W=0.42u AS=0.147p AD=0.1563p
+ PS=1.54u PD=1.22u rfmode=0
M$30 VDD \$3 \$20 VDD sg13_lv_pmos L=0.13u W=0.42u AS=0.1563p AD=0.063p
+ PS=1.22u PD=0.72u rfmode=0
M$31 \$20 \$4 \$12 VDD sg13_lv_pmos L=0.13u W=0.42u AS=0.063p AD=0.0798p
+ PS=0.72u PD=0.8u rfmode=0
M$32 \$12 \$18 \$5 VDD sg13_lv_pmos L=0.13u W=0.42u AS=0.0798p AD=0.1428p
+ PS=0.8u PD=1.52u rfmode=0
.ENDS sg13cmos5l_dfrbpq_1

.SUBCKT sg13cmos5l_o21ai_1 VSS Y VDD B1 A2 A1
M$1 \$2 A1 VSS VSS sg13_lv_nmos L=0.15u W=0.74u AS=0.2516p AD=0.1406p PS=2.16u
+ PD=1.12u rfmode=0
M$2 VSS A2 \$2 VSS sg13_lv_nmos L=0.15u W=0.74u AS=0.1406p AD=0.1406p PS=1.12u
+ PD=1.12u rfmode=0
M$3 \$2 B1 Y VSS sg13_lv_nmos L=0.15u W=0.74u AS=0.1406p AD=0.2516p PS=1.12u
+ PD=2.16u rfmode=0
M$4 VDD A1 \$8 VDD sg13_lv_pmos L=0.15u W=1.12u AS=0.3808p AD=0.2128p PS=2.92u
+ PD=1.5u rfmode=0
M$5 \$8 A2 Y VDD sg13_lv_pmos L=0.15u W=1.12u AS=0.2128p AD=0.2128p PS=1.5u
+ PD=1.5u rfmode=0
M$6 Y B1 VDD VDD sg13_lv_pmos L=0.15u W=1.12u AS=0.2128p AD=0.3808p PS=1.5u
+ PD=2.92u rfmode=0
.ENDS sg13cmos5l_o21ai_1

.SUBCKT sg13cmos5l_nand3b_1 VDD VSS Y B C A_N
M$1 VSS A_N \$6 VSS sg13_lv_nmos L=0.13u W=0.55u AS=0.18575p AD=0.187p PS=1.26u
+ PD=1.78u rfmode=0
M$2 VSS C \$9 VSS sg13_lv_nmos L=0.13u W=0.74u AS=0.18575p AD=0.1406p PS=1.26u
+ PD=1.12u rfmode=0
M$3 \$9 B \$8 VSS sg13_lv_nmos L=0.13u W=0.74u AS=0.1406p AD=0.1406p PS=1.12u
+ PD=1.12u rfmode=0
M$4 \$8 \$6 Y VSS sg13_lv_nmos L=0.13u W=0.74u AS=0.1406p AD=0.3404p PS=1.12u
+ PD=2.4u rfmode=0
M$5 \$6 A_N VDD VDD sg13_lv_pmos L=0.13u W=0.84u AS=0.2856p AD=0.2198p PS=2.36u
+ PD=1.53u rfmode=0
M$6 VDD C Y VDD sg13_lv_pmos L=0.13u W=1.12u AS=0.2198p AD=0.2128p PS=1.53u
+ PD=1.5u rfmode=0
M$7 Y B VDD VDD sg13_lv_pmos L=0.13u W=1.12u AS=0.2128p AD=0.2128p PS=1.5u
+ PD=1.5u rfmode=0
M$8 VDD \$6 Y VDD sg13_lv_pmos L=0.13u W=1.12u AS=0.2128p AD=0.3808p PS=1.5u
+ PD=2.92u rfmode=0
.ENDS sg13cmos5l_nand3b_1

.SUBCKT sg13cmos5l_inv_1 VDD VSS A Y
M$1 VSS A Y VSS sg13_lv_nmos L=0.13u W=0.74u AS=0.2516p AD=0.2516p PS=2.16u
+ PD=2.16u rfmode=0
M$2 VDD A Y VDD sg13_lv_pmos L=0.13u W=1.12u AS=0.3808p AD=0.3808p PS=2.92u
+ PD=2.92u rfmode=0
.ENDS sg13cmos5l_inv_1

.SUBCKT sg13cmos5l_nor2_1 VDD VSS B A Y
M$1 VSS A Y VSS sg13_lv_nmos L=0.13u W=0.74u AS=0.2516p AD=0.1406p PS=2.16u
+ PD=1.12u rfmode=0
M$2 Y B VSS VSS sg13_lv_nmos L=0.13u W=0.74u AS=0.1406p AD=0.2516p PS=1.12u
+ PD=2.16u rfmode=0
M$3 VDD A \$6 VDD sg13_lv_pmos L=0.13u W=1.12u AS=0.4032p AD=0.1176p PS=2.96u
+ PD=1.33u rfmode=0
M$4 \$6 B Y VDD sg13_lv_pmos L=0.13u W=1.12u AS=0.1176p AD=0.3808p PS=1.33u
+ PD=2.92u rfmode=0
.ENDS sg13cmos5l_nor2_1

.SUBCKT sg13cmos5l_dlygate4sd3_1 VDD VSS X A
M$1 VSS \$5 \$4 VSS sg13_lv_nmos L=0.5u W=0.42u AS=0.1426p AD=0.1428p PS=1.16u
+ PD=1.52u rfmode=0
M$2 VSS \$4 X VSS sg13_lv_nmos L=0.13u W=0.74u AS=0.1426p AD=0.2516p PS=1.16u
+ PD=2.16u rfmode=0
M$3 \$6 A VSS VSS sg13_lv_nmos L=0.13u W=0.42u AS=0.1428p AD=0.0798p PS=1.52u
+ PD=0.8u rfmode=0
M$4 VSS \$6 \$5 VSS sg13_lv_nmos L=0.5u W=0.42u AS=0.0798p AD=0.1428p PS=0.8u
+ PD=1.52u rfmode=0
M$5 \$4 \$5 VDD VDD sg13_lv_pmos L=0.5u W=1u AS=0.34p AD=0.2254p PS=2.68u
+ PD=1.53u rfmode=0
M$6 VDD \$4 X VDD sg13_lv_pmos L=0.13u W=1.12u AS=0.2254p AD=0.4256p PS=1.53u
+ PD=3u rfmode=0
M$7 VDD A \$6 VDD sg13_lv_pmos L=0.13u W=0.42u AS=0.1523p AD=0.1428p PS=1.38u
+ PD=1.52u rfmode=0
M$8 VDD \$6 \$5 VDD sg13_lv_pmos L=0.5u W=1u AS=0.1523p AD=0.34p PS=1.38u
+ PD=2.68u rfmode=0
.ENDS sg13cmos5l_dlygate4sd3_1

.SUBCKT sg13cmos5l_and3_1 VDD VSS A C B X
M$1 \$7 A \$9 VSS sg13_lv_nmos L=0.13u W=0.64u AS=0.2176p AD=0.1216p PS=1.96u
+ PD=1.02u rfmode=0
M$2 \$9 B \$8 VSS sg13_lv_nmos L=0.13u W=0.64u AS=0.1216p AD=0.1216p PS=1.02u
+ PD=1.02u rfmode=0
M$3 VSS C \$8 VSS sg13_lv_nmos L=0.13u W=0.64u AS=0.1371p AD=0.1216p PS=1.12u
+ PD=1.02u rfmode=0
M$4 VSS \$7 X VSS sg13_lv_nmos L=0.13u W=0.74u AS=0.1371p AD=0.2516p PS=1.12u
+ PD=2.16u rfmode=0
M$5 \$7 A VDD VDD sg13_lv_pmos L=0.13u W=0.84u AS=0.2856p AD=0.1596p PS=2.36u
+ PD=1.22u rfmode=0
M$6 VDD B \$7 VDD sg13_lv_pmos L=0.13u W=0.84u AS=0.1596p AD=0.1596p PS=1.22u
+ PD=1.22u rfmode=0
M$7 VDD C \$7 VDD sg13_lv_pmos L=0.13u W=0.84u AS=0.36195p AD=0.1596p PS=1.84u
+ PD=1.22u rfmode=0
M$8 VDD \$7 X VDD sg13_lv_pmos L=0.13u W=1.12u AS=0.36195p AD=0.3808p PS=1.84u
+ PD=2.92u rfmode=0
.ENDS sg13cmos5l_and3_1

.SUBCKT sg13cmos5l_a21oi_1 Y VSS A2 VDD A1 B1
M$1 VSS B1 Y VSS sg13_lv_nmos L=0.13u W=0.74u AS=0.2516p AD=0.1406p PS=2.16u
+ PD=1.12u rfmode=0
M$2 Y A1 \$8 VSS sg13_lv_nmos L=0.13u W=0.74u AS=0.1406p AD=0.1406p PS=1.12u
+ PD=1.12u rfmode=0
M$3 \$8 A2 VSS VSS sg13_lv_nmos L=0.13u W=0.74u AS=0.1406p AD=0.2516p PS=1.12u
+ PD=2.16u rfmode=0
M$4 Y B1 \$3 VDD sg13_lv_pmos L=0.13u W=1.12u AS=0.3808p AD=0.2128p PS=2.92u
+ PD=1.5u rfmode=0
M$5 \$3 A1 VDD VDD sg13_lv_pmos L=0.13u W=1.12u AS=0.2128p AD=0.2128p PS=1.5u
+ PD=1.5u rfmode=0
M$6 VDD A2 \$3 VDD sg13_lv_pmos L=0.13u W=1.12u AS=0.2128p AD=0.3808p PS=1.5u
+ PD=2.92u rfmode=0
.ENDS sg13cmos5l_a21oi_1

.SUBCKT sg13cmos5l_buf_1 VSS X VDD A
M$1 VSS A \$1 VSS sg13_lv_nmos L=0.13u W=0.55u AS=0.14875p AD=0.187p PS=1.16u
+ PD=1.78u rfmode=0
M$2 VSS \$1 X VSS sg13_lv_nmos L=0.13u W=0.74u AS=0.14875p AD=0.2886p PS=1.16u
+ PD=2.26u rfmode=0
M$3 VDD A \$1 VDD sg13_lv_pmos L=0.13u W=0.84u AS=0.2114p AD=0.2856p PS=1.54u
+ PD=2.36u rfmode=0
M$4 VDD \$1 X VDD sg13_lv_pmos L=0.13u W=1.12u AS=0.2114p AD=0.42p PS=1.54u
+ PD=2.99u rfmode=0
.ENDS sg13cmos5l_buf_1

.SUBCKT sg13cmos5l_a21o_1 VDD VSS X B1 A1 A2
M$1 X \$6 VSS VSS sg13_lv_nmos L=0.13u W=0.74u AS=0.2351p AD=0.15745p PS=2.16u
+ PD=1.175u rfmode=0
M$2 VSS B1 \$6 VSS sg13_lv_nmos L=0.13u W=0.64u AS=0.15745p AD=0.1216p
+ PS=1.175u PD=1.02u rfmode=0
M$3 \$6 A1 \$9 VSS sg13_lv_nmos L=0.13u W=0.64u AS=0.1216p AD=0.0816p PS=1.02u
+ PD=0.895u rfmode=0
M$4 \$9 A2 VSS VSS sg13_lv_nmos L=0.13u W=0.64u AS=0.0816p AD=0.2176p PS=0.895u
+ PD=1.96u rfmode=0
M$5 \$6 B1 \$5 VDD sg13_lv_pmos L=0.13u W=1u AS=0.35p AD=0.2125p PS=2.7u
+ PD=1.425u rfmode=0
M$6 \$5 A1 VDD VDD sg13_lv_pmos L=0.13u W=1u AS=0.2125p AD=0.19p PS=1.425u
+ PD=1.38u rfmode=0
M$7 VDD A2 \$5 VDD sg13_lv_pmos L=0.13u W=1u AS=0.19p AD=0.34p PS=1.38u
+ PD=2.68u rfmode=0
M$8 X \$6 VDD VDD sg13_lv_pmos L=0.13u W=1.12u AS=0.3808p AD=0.3808p PS=2.92u
+ PD=2.92u rfmode=0
.ENDS sg13cmos5l_a21o_1

.SUBCKT sg13cmos5l_nand2b_1 VDD VSS B A_N Y
M$1 VSS A_N \$6 VSS sg13_lv_nmos L=0.13u W=0.55u AS=0.14505p AD=0.187p PS=1.15u
+ PD=1.78u rfmode=0
M$2 VSS B \$7 VSS sg13_lv_nmos L=0.13u W=0.74u AS=0.14505p AD=0.1406p PS=1.15u
+ PD=1.12u rfmode=0
M$3 \$7 \$6 Y VSS sg13_lv_nmos L=0.13u W=0.74u AS=0.1406p AD=0.333p PS=1.12u
+ PD=2.38u rfmode=0
M$4 \$6 A_N VDD VDD sg13_lv_pmos L=0.13u W=0.84u AS=0.2856p AD=0.2198p PS=2.36u
+ PD=1.53u rfmode=0
M$5 VDD B Y VDD sg13_lv_pmos L=0.13u W=1.12u AS=0.2198p AD=0.2128p PS=1.53u
+ PD=1.5u rfmode=0
M$6 Y \$6 VDD VDD sg13_lv_pmos L=0.13u W=1.12u AS=0.2128p AD=0.3808p PS=1.5u
+ PD=2.92u rfmode=0
.ENDS sg13cmos5l_nand2b_1

.SUBCKT sg13cmos5l_xor2_1 VSS X VDD B A
M$1 VSS A \$1 VSS sg13_lv_nmos L=0.13u W=0.55u AS=0.374p AD=0.174625p PS=2.46u
+ PD=1.185u rfmode=0
M$2 VSS B \$1 VSS sg13_lv_nmos L=0.13u W=0.55u AS=0.15245p AD=0.174625p
+ PS=1.17u PD=1.185u rfmode=0
M$3 VSS A \$8 VSS sg13_lv_nmos L=0.13u W=0.74u AS=0.15245p AD=0.0888p PS=1.17u
+ PD=0.98u rfmode=0
M$4 \$8 B X VSS sg13_lv_nmos L=0.13u W=0.74u AS=0.0888p AD=0.1628p PS=0.98u
+ PD=1.18u rfmode=0
M$5 X \$1 VSS VSS sg13_lv_nmos L=0.13u W=0.74u AS=0.1628p AD=0.3108p PS=1.18u
+ PD=2.32u rfmode=0
M$6 \$3 A VDD VDD sg13_lv_pmos L=0.13u W=1.12u AS=0.3808p AD=0.2128p PS=2.92u
+ PD=1.5u rfmode=0
M$7 VDD B \$3 VDD sg13_lv_pmos L=0.13u W=1.12u AS=0.2128p AD=0.2128p PS=1.5u
+ PD=1.5u rfmode=0
M$8 \$3 \$1 X VDD sg13_lv_pmos L=0.13u W=1.12u AS=0.2128p AD=0.3808p PS=1.5u
+ PD=2.92u rfmode=0
M$9 VDD A \$9 VDD sg13_lv_pmos L=0.13u W=1u AS=0.36p AD=0.1225p PS=2.72u
+ PD=1.245u rfmode=0
M$10 \$9 B \$1 VDD sg13_lv_pmos L=0.13u W=1u AS=0.1225p AD=0.34p PS=1.245u
+ PD=2.68u rfmode=0
.ENDS sg13cmos5l_xor2_1
