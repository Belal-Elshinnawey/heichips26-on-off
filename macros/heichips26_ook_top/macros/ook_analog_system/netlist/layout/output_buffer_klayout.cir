* Extracted by KLayout with SG13CMOS5L LVS runset on : 21/09/2026 13:19

.SUBCKT output_buffer VDD VSS vctrl vctrl_b vin vout vout_fb
M$1 VSS VSS VSS VSS sg13_lv_nmos L=0.13u W=8.2u AS=2.788p AD=2.788p PS=19.12u
+ PD=19.12u rfmode=0
M$2 vout vout vout VSS sg13_lv_nmos L=0.13u W=4u AS=1.36p AD=1.36p PS=8.68u
+ PD=8.68u rfmode=0
M$3 vout \$7 VSS VSS sg13_lv_nmos L=0.13u W=80u AS=15.8p AD=15.8p PS=91.9u
+ PD=91.9u rfmode=0
M$23 vout_fb vout_fb vout_fb VDD sg13_lv_pmos L=0.13u W=2.6u AS=0.884p
+ AD=0.884p PS=6.56u PD=6.56u rfmode=0
M$24 VDD VDD VDD VDD sg13_lv_pmos L=0.13u W=7.3u AS=2.482p AD=2.482p PS=16.64u
+ PD=16.64u rfmode=0
M$25 vout_fb vin VDD VDD sg13_lv_pmos L=0.13u W=13.5u AS=2.7675p AD=2.7675p
+ PS=18.95u PD=18.95u rfmode=0
M$35 vout_fb vout_fb vout_fb VSS sg13_lv_nmos L=0.13u W=2.4u AS=0.816p
+ AD=0.816p PS=6.16u PD=6.16u rfmode=0
M$37 vout_fb vin VSS VSS sg13_lv_nmos L=0.13u W=6u AS=1.32p AD=1.32p PS=9.4u
+ PD=9.4u rfmode=0
M$42 \$23 \$23 \$23 VDD sg13_lv_pmos L=0.13u W=2.6u AS=0.884p AD=0.884p
+ PS=6.56u PD=6.56u rfmode=0
M$43 VSS VSS VSS VDD sg13_lv_pmos L=0.13u W=1.3u AS=0.442p AD=0.442p PS=3.28u
+ PD=3.28u rfmode=0
M$44 \$23 vctrl VSS VDD sg13_lv_pmos L=0.13u W=13.5u AS=2.7675p AD=2.7675p
+ PS=18.95u PD=18.95u rfmode=0
M$54 \$23 \$23 \$23 VSS sg13_lv_nmos L=0.13u W=2.4u AS=0.816p AD=0.816p
+ PS=6.16u PD=6.16u rfmode=0
M$56 \$23 vctrl_b VSS VSS sg13_lv_nmos L=0.13u W=6u AS=1.32p AD=1.32p PS=9.4u
+ PD=9.4u rfmode=0
M$63 \$23 vctrl vout_fb VSS sg13_lv_nmos L=0.13u W=6u AS=1.32p AD=1.32p PS=9.4u
+ PD=9.4u rfmode=0
M$70 \$23 vctrl_b vout_fb VDD sg13_lv_pmos L=0.13u W=13.5u AS=2.7675p
+ AD=2.7675p PS=18.95u PD=18.95u rfmode=0
M$81 \$7 \$7 \$7 VSS sg13_lv_nmos L=0.13u W=1.8u AS=0.612p AD=0.612p PS=4.28u
+ PD=4.28u rfmode=0
M$82 \$7 \$23 VSS VSS sg13_lv_nmos L=0.13u W=18u AS=3.69p AD=3.69p PS=23.9u
+ PD=23.9u rfmode=0
M$92 \$7 \$7 \$7 VDD sg13_lv_pmos L=0.13u W=2u AS=0.68p AD=0.68p PS=4.68u
+ PD=4.68u rfmode=0
M$94 \$7 \$23 VDD VDD sg13_lv_pmos L=0.13u W=40u AS=7.9p AD=7.9p PS=49.9u
+ PD=49.9u rfmode=0
M$114 vout vout vout VDD sg13_lv_pmos L=0.13u W=4u AS=1.36p AD=1.36p PS=8.68u
+ PD=8.68u rfmode=0
M$116 vout \$7 VDD VDD sg13_lv_pmos L=0.13u W=200u AS=38.6p AD=38.6p PS=223.3u
+ PD=223.3u rfmode=0
.ENDS output_buffer
