** sch_path: /home/belal/HeiChips/heichips26-on-off/macros/heichips26_ook/macros/ook_analog_system/schematic/xschem/charge_pump.sch
.subckt charge_pump cp_cap_p cp_cap_m VSS VDD UP vout DN
*.PININFO VDD:B VSS:B UP:I DN:I vout:B cp_cap_m:B cp_cap_p:B
RR2 net2 VSS 205.84k $SUB=VSS $[rhigh] w=2.0e-6 l=27.585e-6 b=9 m=1 ps=0.18e-6
MM3 net2 net2 VDD VDD sg13_lv_pmos w=12u l=0.5u ng=6
MM4 net3 net2 VDD VDD sg13_lv_pmos w=12u l=0.5u ng=6
MM2 cp_cap_p UP net3 VDD sg13_lv_pmos w=2.5u l=0.5u ng=4
MM6 net4 net1 VSS VSS sg13_lv_nmos w=10u l=0.5u ng=5
MM7 net1 net1 VSS VSS sg13_lv_nmos w=10u l=0.5u ng=5
MM1 cp_cap_p DN net4 VSS sg13_lv_nmos w=2.5u l=0.5u ng=4
RR1 cp_cap_m VSS 1.9571MEG $SUB=VSS $[rhigh] w=1.0e-6 l=80.11e-6 b=16 m=1 ps=0.18e-6
RR3 vout cp_cap_p 23.108k $SUB=VSS $[rhigh] w=2.0e-6 l=9.53e-6 b=2 m=1 ps=0.18e-6
RR4 VDD net1 205.84k $SUB=VSS $[rhigh] w=2.0e-6 l=27.585e-6 b=9 m=1 ps=0.18e-6
MM5 VDD VDD VDD VDD sg13_lv_pmos w=2u l=0.5u ng=1
MM8 VDD VDD VDD VDD sg13_lv_pmos w=2u l=0.5u ng=1
MM9 net3 net3 net3 VDD sg13_lv_pmos w=2u l=0.5u ng=1
MM10 net2 net2 net2 VDD sg13_lv_pmos w=2u l=0.5u ng=1
MM11 net4 net4 net4 VSS sg13_lv_nmos w=2u l=0.5u ng=1
MM12 net1 net1 net1 VSS sg13_lv_nmos w=2u l=0.5u ng=1
MM13 VSS VSS VSS VSS sg13_lv_nmos w=2u l=0.5u ng=1
MM14 VSS VSS VSS VSS sg13_lv_nmos w=2u l=0.5u ng=1
MM15 cp_cap_p cp_cap_p cp_cap_p VSS sg13_lv_nmos w=0.63u l=0.5u ng=1
MM16 net4 net4 net4 VSS sg13_lv_nmos w=0.63u l=0.5u ng=1
MM17 cp_cap_p cp_cap_p cp_cap_p VDD sg13_lv_pmos w=0.63u l=0.5u ng=1
MM18 net3 net3 net3 VDD sg13_lv_pmos w=0.63u l=0.5u ng=1
.ends
