** sch_path: /home/belal/HeiChips/heichips26-on-off/macros/heichips26_ook_top/macros/ook_analog_system/schematic/xschem/ook_analgo_system.sch
.subckt ook_analgo_system

.ends
