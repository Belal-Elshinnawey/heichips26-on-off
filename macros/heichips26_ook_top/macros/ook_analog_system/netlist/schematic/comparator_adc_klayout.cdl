** sch_path: /home/belal/HeiChips/heichips26-on-off/macros/heichips26_ook/macros/ook_analog_system/schematic/xschem/comparator_adc.sch
.subckt comparator_adc VDDL VDD vin q3 VSS q2 q1 q0 clk vref_1 vref_2 vref_3 vref_4
*.PININFO VDD:B VDDL:B q0:B VSS:B clk:I q1:B q2:B q3:B vin:I vref_4:B vref_3:B vref_2:B vref_1:B
RR1 VDD vref_4 29.223k $SUB=VSS $[rhigh] w=2e-6 l=4.2e-5 b=0
RR2 vref_4 vref_3 294.22 $SUB=VSS $[rppd] w=2e-6 l=2.0e-6 b=0
RR4 vref_2 vref_1 501.6 $SUB=VSS $[rppd] w=2e-6 l=3.6e-6 b=0
RR3 vref_3 vref_2 200.9 $SUB=VSS $[rppd] w=2e-6 l=1.28e-6 b=0
RR10 clk_h net2 1.3311k $SUB=VSS $[rppd] w=2e-6 l=10e-6 b=0
RR6 net1 clk 1.3311k $SUB=VSS $[rppd] w=2e-6 l=10e-6 b=0
RR5 vref_1 VSS 2.5016k $SUB=VSS $[rhigh] w=2e-6 l=3.49e-6 b=0
x1 clk_h vref_1 VDDL VDD vin q0 VSS clocked_comparator
x2 clk_h vref_2 VDDL VDD vin q1 VSS clocked_comparator
x3 clk_h vref_3 VDDL VDD vin q2 VSS clocked_comparator
x4 clk_h vref_4 VDDL VDD vin q3 VSS clocked_comparator
x5 VDD net1 net2 VSS VDDL level_up_shifter W_P_HV=3.0u L_P_HV=0.50u W_N_HV=10.0u L_N_HV=0.50u W_P_LV=1.0u L_P_LV=0.13u W_N_LV=1.0u
+ L_N_LV=0.13u
.ends

* expanding   symbol:  clocked_comparator.sym # of pins=7
** sym_path: /home/belal/HeiChips/heichips26-on-off/macros/heichips26_ook/macros/ook_analog_system/schematic/xschem/clocked_comparator.sym
** sch_path: /home/belal/HeiChips/heichips26-on-off/macros/heichips26_ook/macros/ook_analog_system/schematic/xschem/clocked_comparator.sch
.subckt clocked_comparator clk vref VDDL VDD vin vout VSS
*.PININFO VDD:B VDDL:B vin:I vref:I vout:B clk:I VSS:B
MMT VDD clkb net3 VDD sg13_hv_pmos w=5u l=0.5u ng=1
MM5 net3 vin net1 VDD sg13_hv_pmos w=5u l=0.5u ng=1
MM6 net1 net2 net5 VDD sg13_hv_pmos w=2u l=0.5u ng=1
MM7 net5 net2 VSS VSS sg13_hv_nmos w=1u l=0.5u ng=1
MM8 net3 vref net4 VDD sg13_hv_pmos w=5u l=0.5u ng=1
MM9 net4 net5 net2 VDD sg13_hv_pmos w=2u l=0.5u ng=1
MM10 net2 net5 VSS VSS sg13_hv_nmos w=1u l=0.5u ng=1
MM11 net5 clkb VSS VSS sg13_hv_nmos w=1u l=0.5u ng=1
MM12 net2 clkb VSS VSS sg13_hv_nmos w=1u l=0.5u ng=1
MM13 net4 clkb VSS VSS sg13_hv_nmos w=1u l=0.5u ng=1
MMPA1 VDDL net5 net8 VDDL sg13_hv_pmos w=4u l=0.5u ng=1
MMPA2 net8 net6 vout VDDL sg13_hv_pmos w=4u l=0.5u ng=1
MMNA1 vout net5 VSS VSS sg13_hv_nmos w=1u l=0.5u ng=1
MMNA2 vout net6 VSS VSS sg13_hv_nmos w=1u l=0.5u ng=1
MMPB1 VDDL net2 net7 VDDL sg13_hv_pmos w=4u l=0.5u ng=1
MMPB2 net7 vout net6 VDDL sg13_hv_pmos w=4u l=0.5u ng=1
MMNB1 net6 net2 VSS VSS sg13_hv_nmos w=1u l=0.5u ng=1
MMNB2 net6 vout VSS VSS sg13_hv_nmos w=1u l=0.5u ng=1
MM14 net1 clkb VSS VSS sg13_hv_nmos w=1u l=0.5u ng=1
MMIP1 clkb VSS clk VDD sg13_hv_pmos w=24u l=0.5u ng=12
MMIN1 clkb VDD clk VSS sg13_hv_nmos w=24u l=0.5u ng=12
MMT1 VDD VDD VDD VDD sg13_hv_pmos w=5u l=0.5u ng=1
MMT2 net3 net3 net3 VDD sg13_hv_pmos w=5u l=0.5u ng=1
MMIN2 clkb clkb clkb VSS sg13_hv_nmos w=2u l=0.5u ng=1
MMIN3 clk clk clk VSS sg13_hv_nmos w=2u l=0.5u ng=1
MMIP2 clk clk clk VDD sg13_hv_pmos w=2u l=0.5u ng=1
MMIP3 clkb clkb clkb VDD sg13_hv_pmos w=2u l=0.5u ng=1
MM1 net3 net3 net3 VDD sg13_hv_pmos w=5u l=0.5u ng=1
MM2 net3 net3 net3 VDD sg13_hv_pmos w=5u l=0.5u ng=1
MM3 net4 net4 net4 VDD sg13_hv_pmos w=5u l=0.5u ng=1
MM4 net1 net1 net1 VDD sg13_hv_pmos w=5u l=0.5u ng=1
MM15 net1 net1 net1 VDD sg13_hv_pmos w=2u l=0.5u ng=1
MM16 net4 net4 net4 VDD sg13_hv_pmos w=2u l=0.5u ng=1
MM17 net4 net4 net4 VSS sg13_hv_nmos w=1u l=0.5u ng=1
MM18 net1 net1 net1 VSS sg13_hv_nmos w=1u l=0.5u ng=1
MM19 net5 net5 net5 VDD sg13_hv_pmos w=2u l=0.5u ng=1
MM20 net2 net2 net2 VDD sg13_hv_pmos w=2u l=0.5u ng=1
MM21 VSS VSS VSS VSS sg13_hv_nmos w=1u l=0.5u ng=1
MM22 VSS VSS VSS VSS sg13_hv_nmos w=1u l=0.5u ng=1
MM23 net2 net2 net2 VSS sg13_hv_nmos w=1u l=0.5u ng=1
MM24 net5 net5 net5 VSS sg13_hv_nmos w=1u l=0.5u ng=1
MM25 VSS VSS VSS VSS sg13_hv_nmos w=1u l=0.5u ng=1
MM26 VSS VSS VSS VSS sg13_hv_nmos w=1u l=0.5u ng=1
MMPA3 VDDL VDDL VDDL VDDL sg13_hv_pmos w=4u l=0.5u ng=1
MMPB3 VDDL VDDL VDDL VDDL sg13_hv_pmos w=4u l=0.5u ng=1
MMPB4 net7 net7 net7 VDDL sg13_hv_pmos w=4u l=0.5u ng=1
MMPA4 net8 net8 net8 VDDL sg13_hv_pmos w=4u l=0.5u ng=1
MMPA5 net8 net8 net8 VDDL sg13_hv_pmos w=4u l=0.5u ng=1
MMPB5 net7 net7 net7 VDDL sg13_hv_pmos w=4u l=0.5u ng=1
MMPA6 vout vout vout VDDL sg13_hv_pmos w=4u l=0.5u ng=1
MMPB6 net6 net6 net6 VDDL sg13_hv_pmos w=4u l=0.5u ng=1
MMNA3 vout vout vout VSS sg13_hv_nmos w=1u l=0.5u ng=1
MMNA4 vout vout vout VSS sg13_hv_nmos w=1u l=0.5u ng=1
MMNB3 net6 net6 net6 VSS sg13_hv_nmos w=1u l=0.5u ng=1
MMNB4 net6 net6 net6 VSS sg13_hv_nmos w=1u l=0.5u ng=1
MMNB5 VSS VSS VSS VSS sg13_hv_nmos w=1u l=0.5u ng=1
MMNB6 VSS VSS VSS VSS sg13_hv_nmos w=1u l=0.5u ng=1
MMNA5 VSS VSS VSS VSS sg13_hv_nmos w=1u l=0.5u ng=1
MMNA6 VSS VSS VSS VSS sg13_hv_nmos w=1u l=0.5u ng=1
MM27 net5 net5 net5 VSS sg13_hv_nmos w=1u l=0.5u ng=1
MM28 VSS VSS VSS VSS sg13_hv_nmos w=1u l=0.5u ng=1
MM29 net2 net2 net2 VSS sg13_hv_nmos w=1u l=0.5u ng=1
MM30 VSS VSS VSS VSS sg13_hv_nmos w=1u l=0.5u ng=1
.ends

* expanding   symbol:  level_up_shifter.sym # of pins=5
** sym_path: /home/belal/HeiChips/heichips26-on-off/macros/heichips26_ook/macros/ook_analog_system/schematic/xschem/level_up_shifter.sym
** sch_path: /home/belal/HeiChips/heichips26-on-off/macros/heichips26_ook/macros/ook_analog_system/schematic/xschem/level_up_shifter.sch
.subckt level_up_shifter VDD2 A B VSS VDD1  W_P_HV=3.0u L_P_HV=0.50u W_N_HV=10.0u L_N_HV=0.50u W_P_LV=1.0u L_P_LV=0.13u
+ W_N_LV=1.0u L_N_LV=0.13u
*.PININFO VSS:B VDD2:B B:O A:I VDD1:B
MM1 net1 AB VSS VSS sg13_hv_nmos w=10u l=0.5u ng=1
MM4 T net1 VDD2 VDD2 sg13_hv_pmos w=1u l=0.5u ng=1
MM3 net1 T VDD2 VDD2 sg13_hv_pmos w=1u l=0.5u ng=1
MM2 T AM VSS VSS sg13_hv_nmos w=10u l=0.5u ng=1
MM5 B T VDD2 VDD2 sg13_hv_pmos w=3u l=0.5u ng=1
MM6 B T VSS VSS sg13_hv_nmos w=1u l=0.5u ng=1
MM7 VSS VSS VSS VSS sg13_hv_nmos w=1u l=0.5u ng=1
MM8 VDD2 VDD2 VDD2 VDD2 sg13_hv_pmos w=3u l=0.5u ng=1
MM9 VDD1 VDD1 VDD1 VDD1 sg13_lv_pmos w=1u l=0.13u ng=1
MM12 AB A VDD1 VDD1 sg13_lv_pmos w=1u l=0.13u ng=1
MM10 VSS VSS VSS VSS sg13_lv_nmos w=1u l=0.13u ng=1
MM11 VDD1 VDD1 VDD1 VDD1 sg13_lv_pmos w=1u l=0.13u ng=1
MM14 AM AB VDD1 VDD1 sg13_lv_pmos w=1u l=0.13u ng=1
MM15 VSS VSS VSS VSS sg13_lv_nmos w=1u l=0.13u ng=1
MM17 AB A VSS VSS sg13_lv_nmos w=1u l=0.13u ng=1
MM13 AM AB VSS VSS sg13_lv_nmos w=1u l=0.13u ng=1
MM16 AB AB AB VSS sg13_lv_nmos w=1u l=0.13u ng=1
MM18 AB AB AB VDD1 sg13_lv_pmos w=1u l=0.13u ng=1
MM19 AM AM AM VDD1 sg13_lv_pmos w=1u l=0.13u ng=1
MM20 AM AM AM VSS sg13_lv_nmos w=1u l=0.13u ng=1
MM21 B B B VDD2 sg13_hv_pmos w=3u l=0.5u ng=1
MM22 B B B VSS sg13_hv_nmos w=1u l=0.5u ng=1
.ends
