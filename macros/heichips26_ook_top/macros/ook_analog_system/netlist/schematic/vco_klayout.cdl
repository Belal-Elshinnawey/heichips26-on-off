** sch_path: /home/belal/HeiChips/heichips26-on-off/macros/heichips26_ook/macros/ook_analog_system/schematic/xschem/vco.sch
.subckt vco vout VDD VSS VCL
*.PININFO vout:O VDD:B VSS:B VCL:I
MM1 net1 vosc net4 VDD sg13_lv_pmos w=4.5u l=0.13u ng=10
MM2 net1 vosc net7 VSS sg13_lv_nmos w=2u l=0.13u ng=5
MM3 net2 net1 net5 VDD sg13_lv_pmos w=4.5u l=0.13u ng=10
MM4 net2 net1 net8 VSS sg13_lv_nmos w=2u l=0.13u ng=5
MM5 vosc net2 net6 VDD sg13_lv_pmos w=4.5u l=0.13u ng=10
MM6 vosc net2 net9 VSS sg13_lv_nmos w=2u l=0.13u ng=5
MM7 vout vosc VDD VDD sg13_lv_pmos w=4.5u l=0.13u ng=10
MM8 vout vosc VSS VSS sg13_lv_nmos w=2u l=0.13u ng=5
MM9 net4 VCH VDD VDD sg13_lv_pmos w=5u l=0.13u ng=10
MM10 net5 VCH VDD VDD sg13_lv_pmos w=5u l=0.13u ng=10
MM11 net6 VCH VDD VDD sg13_lv_pmos w=5u l=0.13u ng=10
MM12 net7 VCL_L VSS VSS sg13_lv_nmos w=3u l=0.13u ng=5
MM13 net8 VCL_L VSS VSS sg13_lv_nmos w=3u l=0.13u ng=5
MM14 net9 VCL_L VSS VSS sg13_lv_nmos w=3u l=0.13u ng=5
MM15 VCH VCH VDD VDD sg13_lv_pmos w=5u l=0.13u ng=10
MM16 VCH VCL net3 VSS sg13_lv_nmos w=40u l=0.13u ng=20
MM17 VCL_L VCH VDD VDD sg13_lv_pmos w=5u l=0.13u ng=10
MM18 VCL_L VCL_L VSS VSS sg13_lv_nmos w=3u l=0.13u ng=5
RR1 net3 VSS 3.5494k $SUB=VSS $[rhigh] w=2e-6 l=5e-6 b=0
MM19 VDD VDD VDD VDD sg13_lv_pmos w=0.5u l=0.13u ng=1
MM20 VCH VCH VCH VDD sg13_lv_pmos w=0.5u l=0.13u ng=1
MM21 VCH VCH VCH VSS sg13_lv_nmos w=2u l=0.13u ng=1
MM22 net3 net3 net3 VSS sg13_lv_nmos w=2u l=0.13u ng=1
MM23 VDD VDD VDD VDD sg13_lv_pmos w=0.5u l=0.13u ng=1
MM24 VCL_L VCL_L VCL_L VDD sg13_lv_pmos w=0.5u l=0.13u ng=1
MM25 VCL_L VCL_L VCL_L VSS sg13_lv_nmos w=0.6u l=0.13u ng=1
MM26 VSS VSS VSS VSS sg13_lv_nmos w=0.6u l=0.13u ng=1
MM27 VDD VDD VDD VDD sg13_lv_pmos w=0.5u l=0.13u ng=1
MM28 VDD VDD VDD VDD sg13_lv_pmos w=0.5u l=0.13u ng=1
MM29 VDD VDD VDD VDD sg13_lv_pmos w=0.5u l=0.13u ng=1
MM30 net4 net4 net4 VDD sg13_lv_pmos w=0.5u l=0.13u ng=1
MM31 net5 net5 net5 VDD sg13_lv_pmos w=0.5u l=0.13u ng=1
MM32 net6 net6 net6 VDD sg13_lv_pmos w=0.5u l=0.13u ng=1
MM33 net7 net7 net7 VSS sg13_lv_nmos w=0.6u l=0.13u ng=1
MM34 net8 net8 net8 VSS sg13_lv_nmos w=0.6u l=0.13u ng=1
MM35 net9 net9 net9 VSS sg13_lv_nmos w=0.6u l=0.13u ng=1
MM36 VSS VSS VSS VSS sg13_lv_nmos w=0.6u l=0.13u ng=1
MM37 VSS VSS VSS VSS sg13_lv_nmos w=0.6u l=0.13u ng=1
MM38 VSS VSS VSS VSS sg13_lv_nmos w=0.6u l=0.13u ng=1
MM39 net7 net7 net7 VSS sg13_lv_nmos w=0.4u l=0.13u ng=1
MM40 net8 net8 net8 VSS sg13_lv_nmos w=0.4u l=0.13u ng=1
MM41 net9 net9 net9 VSS sg13_lv_nmos w=0.4u l=0.13u ng=1
MM42 net1 net1 net1 VSS sg13_lv_nmos w=0.4u l=0.13u ng=1
MM43 net2 net2 net2 VSS sg13_lv_nmos w=0.4u l=0.13u ng=1
MM44 vosc vosc vosc VSS sg13_lv_nmos w=0.4u l=0.13u ng=1
MM45 net1 net1 net1 VDD sg13_lv_pmos w=0.45u l=0.13u ng=1
MM46 net2 net2 net2 VDD sg13_lv_pmos w=0.45u l=0.13u ng=1
MM47 vosc vosc vosc VDD sg13_lv_pmos w=0.45u l=0.13u ng=1
MM48 net4 net4 net4 VDD sg13_lv_pmos w=0.45u l=0.13u ng=1
MM49 net5 net5 net5 VDD sg13_lv_pmos w=0.45u l=0.13u ng=1
MM50 net6 net6 net6 VDD sg13_lv_pmos w=0.45u l=0.13u ng=1
MM51 VSS VSS VSS VSS sg13_lv_nmos w=0.4u l=0.13u ng=1
MM52 vout vout vout VSS sg13_lv_nmos w=0.4u l=0.13u ng=1
MM53 vout vout vout VDD sg13_lv_pmos w=0.45u l=0.13u ng=1
MM54 VDD VDD VDD VDD sg13_lv_pmos w=0.45u l=0.13u ng=1
.ends
