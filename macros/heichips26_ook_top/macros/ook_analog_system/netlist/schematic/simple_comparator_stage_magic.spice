** sch_path: /home/belal/HeiChips/heichips26-on-off/macros/heichips26_ook_top/macros/ook_analog_system/schematic/xschem/simple_comparator_stage.sch
.subckt simple_comparator_stage VDD1_5 VDD3_3 vin q0 vref0 VSS q1 vref1 q2 vref2 q3 vref3
*.PININFO VDD3_3:B VSS:B VDD1_5:B vin:I q0:O vref3:I vref2:I vref1:I vref0:I q1:O q2:O q3:O
x2 VDD1_5 VSS VDD3_3 vref0 vin q0 simple_comparator
x1 VDD1_5 VSS VDD3_3 vref1 vin q1 simple_comparator
x3 VDD1_5 VSS VDD3_3 vref2 vin q2 simple_comparator
x4 VDD1_5 VSS VDD3_3 vref3 vin q3 simple_comparator
XM1 net2 net2 VSS GND sg13_lv_nmos w=0.15u l=0.13u ng=1 m=1 mm_ok=1
XM2 net1 net1 VDD1_5 VDD1_5 sg13_lv_pmos w=4u l=0.13u ng=1 m=1 mm_ok=1
XR6 vref0 VSS VSS rhigh w=2e-6 l=3.85e-6 m=1 b=0 mm_ok=1
XM3 net2 net1 VDD1_5 VDD1_5 sg13_lv_pmos w=4u l=0.13u ng=1 m=1 mm_ok=1
XM4 net1 net2 vref0 VSS sg13_lv_nmos w=0.83u l=0.13u ng=1 m=1 mm_ok=1
XM17 net3 net3 VDD1_5 VDD1_5 sg13_lv_pmos w=4u l=0.13u ng=1 m=1 mm_ok=1
XM18 net3 net2 VSS VSS sg13_lv_nmos w=0.15u l=0.13u ng=1 m=1 mm_ok=1
XM19 net2 net3 VDD1_5 VSS sg13_lv_nmos w=0.15u l=0.13u ng=1 m=1 mm_ok=1
XM29 VDD1_5 VDD1_5 VDD1_5 VDD1_5 sg13_lv_pmos w=4u l=0.13u ng=1 m=1 mm_ok=1
XM30 VDD1_5 VDD1_5 VDD1_5 VSS sg13_lv_nmos w=0.15u l=0.13u ng=1 m=1 mm_ok=1
XM31 net3 net3 net3 VDD1_5 sg13_lv_pmos w=4u l=0.13u ng=1 m=1 mm_ok=1
XM32 net2 net2 net2 VSS sg13_lv_nmos w=0.15u l=0.13u ng=1 m=1 mm_ok=1
XM33 net3 net3 net3 VSS sg13_lv_nmos w=0.15u l=0.13u ng=1 m=1 mm_ok=1
XM34 VSS VSS VSS VSS sg13_lv_nmos w=0.15u l=0.13u ng=1 m=1 mm_ok=1
XM35 VDD1_5 VDD1_5 VDD1_5 VDD1_5 sg13_lv_pmos w=4u l=0.13u ng=1 m=1 mm_ok=1
XM36 VDD1_5 VDD1_5 VDD1_5 VDD1_5 sg13_lv_pmos w=4u l=0.13u ng=1 m=1 mm_ok=1
XM37 net1 net1 net1 VDD1_5 sg13_lv_pmos w=4u l=0.13u ng=1 m=1 mm_ok=1
XM38 net2 net2 net2 VDD1_5 sg13_lv_pmos w=4u l=0.13u ng=1 m=1 mm_ok=1
XM39 VSS VSS VSS VDD1_5 sg13_lv_pmos w=4u l=0.13u ng=1 m=1 mm_ok=1
XM40 vref0 vref0 vref0 VSS sg13_lv_nmos w=0.83u l=0.13u ng=1 m=1 mm_ok=1
XM41 net1 net1 net1 VSS sg13_lv_nmos w=0.83u l=0.13u ng=1 m=1 mm_ok=1
XM42 net5 net5 VSS GND sg13_lv_nmos w=0.15u l=0.13u ng=1 m=1 mm_ok=1
XM43 net4 net4 VDD1_5 VDD1_5 sg13_lv_pmos w=4u l=0.13u ng=1 m=1 mm_ok=1
XR1 vref1 VSS VSS rhigh w=2e-6 l=3.85e-6 m=1 b=0 mm_ok=1
XM44 net5 net4 VDD1_5 VDD1_5 sg13_lv_pmos w=4u l=0.13u ng=1 m=1 mm_ok=1
XM45 net4 net5 vref1 VSS sg13_lv_nmos w=1.02u l=0.13u ng=1 m=1 mm_ok=1
XM46 net6 net6 VDD1_5 VDD1_5 sg13_lv_pmos w=4u l=0.13u ng=1 m=1 mm_ok=1
XM47 net6 net5 VSS VSS sg13_lv_nmos w=0.15u l=0.13u ng=1 m=1 mm_ok=1
XM48 net5 net6 VDD1_5 VSS sg13_lv_nmos w=0.15u l=0.13u ng=1 m=1 mm_ok=1
XM49 VDD1_5 VDD1_5 VDD1_5 VDD1_5 sg13_lv_pmos w=4u l=0.13u ng=1 m=1 mm_ok=1
XM50 VDD1_5 VDD1_5 VDD1_5 VSS sg13_lv_nmos w=0.15u l=0.13u ng=1 m=1 mm_ok=1
XM51 net6 net6 net6 VDD1_5 sg13_lv_pmos w=4u l=0.13u ng=1 m=1 mm_ok=1
XM52 net5 net5 net5 VSS sg13_lv_nmos w=0.15u l=0.13u ng=1 m=1 mm_ok=1
XM53 net6 net6 net6 VSS sg13_lv_nmos w=0.15u l=0.13u ng=1 m=1 mm_ok=1
XM54 VSS VSS VSS VSS sg13_lv_nmos w=0.15u l=0.13u ng=1 m=1 mm_ok=1
XM55 VDD1_5 VDD1_5 VDD1_5 VDD1_5 sg13_lv_pmos w=4u l=0.13u ng=1 m=1 mm_ok=1
XM56 VDD1_5 VDD1_5 VDD1_5 VDD1_5 sg13_lv_pmos w=4u l=0.13u ng=1 m=1 mm_ok=1
XM57 net4 net4 net4 VDD1_5 sg13_lv_pmos w=4u l=0.13u ng=1 m=1 mm_ok=1
XM58 net5 net5 net5 VDD1_5 sg13_lv_pmos w=4u l=0.13u ng=1 m=1 mm_ok=1
XM59 VSS VSS VSS VDD1_5 sg13_lv_pmos w=4u l=0.13u ng=1 m=1 mm_ok=1
XM60 vref1 vref1 vref1 VSS sg13_lv_nmos w=1.02u l=0.13u ng=1 m=1 mm_ok=1
XM61 net4 net4 net4 VSS sg13_lv_nmos w=1.02u l=0.13u ng=1 m=1 mm_ok=1
XM62 net8 net8 VSS GND sg13_lv_nmos w=0.15u l=0.13u ng=1 m=1 mm_ok=1
XM63 net7 net7 VDD1_5 VDD1_5 sg13_lv_pmos w=4u l=0.13u ng=1 m=1 mm_ok=1
XR2 vref2 VSS VSS rhigh w=2e-6 l=3.85e-6 m=1 b=0 mm_ok=1
XM64 net8 net7 VDD1_5 VDD1_5 sg13_lv_pmos w=4u l=0.13u ng=1 m=1 mm_ok=1
XM65 net7 net8 vref2 VSS sg13_lv_nmos w=1.48u l=0.13u ng=1 m=1 mm_ok=1
XM66 net9 net9 VDD1_5 VDD1_5 sg13_lv_pmos w=4u l=0.13u ng=1 m=1 mm_ok=1
XM67 net9 net8 VSS VSS sg13_lv_nmos w=0.15u l=0.13u ng=1 m=1 mm_ok=1
XM68 net8 net9 VDD1_5 VSS sg13_lv_nmos w=0.15u l=0.13u ng=1 m=1 mm_ok=1
XM69 VDD1_5 VDD1_5 VDD1_5 VDD1_5 sg13_lv_pmos w=4u l=0.13u ng=1 m=1 mm_ok=1
XM70 VDD1_5 VDD1_5 VDD1_5 VSS sg13_lv_nmos w=0.15u l=0.13u ng=1 m=1 mm_ok=1
XM71 net9 net9 net9 VDD1_5 sg13_lv_pmos w=4u l=0.13u ng=1 m=1 mm_ok=1
XM72 net8 net8 net8 VSS sg13_lv_nmos w=0.15u l=0.13u ng=1 m=1 mm_ok=1
XM73 net9 net9 net9 VSS sg13_lv_nmos w=0.15u l=0.13u ng=1 m=1 mm_ok=1
XM74 VSS VSS VSS VSS sg13_lv_nmos w=0.15u l=0.13u ng=1 m=1 mm_ok=1
XM75 VDD1_5 VDD1_5 VDD1_5 VDD1_5 sg13_lv_pmos w=4u l=0.13u ng=1 m=1 mm_ok=1
XM76 VDD1_5 VDD1_5 VDD1_5 VDD1_5 sg13_lv_pmos w=4u l=0.13u ng=1 m=1 mm_ok=1
XM77 net7 net7 net7 VDD1_5 sg13_lv_pmos w=4u l=0.13u ng=1 m=1 mm_ok=1
XM78 net8 net8 net8 VDD1_5 sg13_lv_pmos w=4u l=0.13u ng=1 m=1 mm_ok=1
XM79 VSS VSS VSS VDD1_5 sg13_lv_pmos w=4u l=0.13u ng=1 m=1 mm_ok=1
XM80 vref2 vref2 vref2 VSS sg13_lv_nmos w=1.48u l=0.13u ng=1 m=1 mm_ok=1
XM81 net7 net7 net7 VSS sg13_lv_nmos w=1.48u l=0.13u ng=1 m=1 mm_ok=1
XM82 net11 net11 VSS GND sg13_lv_nmos w=0.15u l=0.13u ng=1 m=1 mm_ok=1
XM83 net10 net10 VDD1_5 VDD1_5 sg13_lv_pmos w=4u l=0.13u ng=1 m=1 mm_ok=1
XR3 vref3 VSS VSS rhigh w=2e-6 l=3.85e-6 m=1 b=0 mm_ok=1
XM84 net11 net10 VDD1_5 VDD1_5 sg13_lv_pmos w=4u l=0.13u ng=1 m=1 mm_ok=1
XM85 net10 net11 vref3 VSS sg13_lv_nmos w=2.77u l=0.13u ng=1 m=1 mm_ok=1
XM86 net12 net12 VDD1_5 VDD1_5 sg13_lv_pmos w=4u l=0.13u ng=1 m=1 mm_ok=1
XM87 net12 net11 VSS VSS sg13_lv_nmos w=0.15u l=0.13u ng=1 m=1 mm_ok=1
XM88 net11 net12 VDD1_5 VSS sg13_lv_nmos w=0.15u l=0.13u ng=1 m=1 mm_ok=1
XM89 VDD1_5 VDD1_5 VDD1_5 VDD1_5 sg13_lv_pmos w=4u l=0.13u ng=1 m=1 mm_ok=1
XM90 VDD1_5 VDD1_5 VDD1_5 VSS sg13_lv_nmos w=0.15u l=0.13u ng=1 m=1 mm_ok=1
XM91 net12 net12 net12 VDD1_5 sg13_lv_pmos w=4u l=0.13u ng=1 m=1 mm_ok=1
XM92 net11 net11 net11 VSS sg13_lv_nmos w=0.15u l=0.13u ng=1 m=1 mm_ok=1
XM93 net12 net12 net12 VSS sg13_lv_nmos w=0.15u l=0.13u ng=1 m=1 mm_ok=1
XM94 VSS VSS VSS VSS sg13_lv_nmos w=0.15u l=0.13u ng=1 m=1 mm_ok=1
XM95 VDD1_5 VDD1_5 VDD1_5 VDD1_5 sg13_lv_pmos w=4u l=0.13u ng=1 m=1 mm_ok=1
XM96 VDD1_5 VDD1_5 VDD1_5 VDD1_5 sg13_lv_pmos w=4u l=0.13u ng=1 m=1 mm_ok=1
XM97 net10 net10 net10 VDD1_5 sg13_lv_pmos w=4u l=0.13u ng=1 m=1 mm_ok=1
XM98 net11 net11 net11 VDD1_5 sg13_lv_pmos w=4u l=0.13u ng=1 m=1 mm_ok=1
XM99 VSS VSS VSS VDD1_5 sg13_lv_pmos w=4u l=0.13u ng=1 m=1 mm_ok=1
XM100 vref3 vref3 vref3 VSS sg13_lv_nmos w=2.77u l=0.13u ng=1 m=1 mm_ok=1
XM101 net10 net10 net10 VSS sg13_lv_nmos w=2.77u l=0.13u ng=1 m=1 mm_ok=1
.ends

* expanding   symbol:  simple_comparator.sym # of pins=6
** sym_path: /home/belal/HeiChips/heichips26-on-off/macros/heichips26_ook_top/macros/ook_analog_system/schematic/xschem/simple_comparator.sym
** sch_path: /home/belal/HeiChips/heichips26-on-off/macros/heichips26_ook_top/macros/ook_analog_system/schematic/xschem/simple_comparator.sch
.subckt simple_comparator VDDL VSS VDD vref vin comp_out
*.PININFO vin:I vref:I VDD:B VSS:B comp_out:O VDDL:B
XMBIAS vbias vbias VDD VDD sg13_hv_pmos w=4u l=0.5u ng=1 m=1 mm_ok=1
XRBIAS vbias VSS VSS rhigh w=2e-6 l=9.27e-6 m=1 b=15 ps=0.18e-6 mm_ok=1
XM3P net4 vbias VDD VDD sg13_hv_pmos w=4u l=0.5u ng=1 m=1 mm_ok=1
XM1P outn vin net4 VDD sg13_hv_pmos w=4u l=0.5u ng=1 m=4 mm_ok=1
XM2P net1 vref net4 VDD sg13_hv_pmos w=4u l=0.5u ng=1 m=4 mm_ok=1
XM4N outn outn VSS VSS sg13_hv_nmos w=2u l=0.5u ng=1 m=4 mm_ok=1
XM5N net1 outn VSS VSS sg13_hv_nmos w=2u l=0.5u ng=1 m=4 mm_ok=1
XMP1 net2 net1 VDD VDD sg13_hv_pmos w=8u l=0.45u ng=1 m=1 mm_ok=1
XMN1 net2 net1 VSS VSS sg13_hv_nmos w=4u l=0.45u ng=1 m=1 mm_ok=1
XMP2 comp_out net3 VDDL VDDL sg13_lv_pmos w=8u l=0.13u ng=1 m=1 mm_ok=1
XMBIAS1 vbias vbias vbias VDD sg13_hv_pmos w=4u l=0.5u ng=1 m=1 mm_ok=1
XMBIAS2 VDD VDD VDD VDD sg13_hv_pmos w=4u l=0.5u ng=1 m=1 mm_ok=1
XM1 VDD VDD VDD VDD sg13_hv_pmos w=4u l=0.5u ng=1 m=1 mm_ok=1
XM2 net4 net4 net4 VDD sg13_hv_pmos w=4u l=0.5u ng=1 m=1 mm_ok=1
XMP3 net2 net2 net2 VDD sg13_hv_pmos w=8u l=0.45u ng=1 m=1 mm_ok=1
XMP4 VDD VDD VDD VDD sg13_hv_pmos w=8u l=0.45u ng=1 m=1 mm_ok=1
XMP5 VDDL VDDL VDDL VDDL sg13_lv_pmos w=8u l=0.13u ng=1 m=1 mm_ok=1
XMP6 comp_out comp_out comp_out VDDL sg13_lv_pmos w=8u l=0.13u ng=1 m=1 mm_ok=1
XMN3 comp_out comp_out comp_out VSS sg13_lv_nmos w=4u l=0.13u ng=1 m=1 mm_ok=1
XMN4 VSS VSS VSS VSS sg13_lv_nmos w=4u l=0.13u ng=1 m=1 mm_ok=1
XMN5 net2 net2 net2 VSS sg13_hv_nmos w=4u l=0.45u ng=1 m=1 mm_ok=1
XMN6 VSS VSS VSS VSS sg13_hv_nmos w=4u l=0.45u ng=1 m=1 mm_ok=1
XM3 net4 net4 net4 VDD sg13_hv_pmos w=4u l=0.5u ng=1 m=1 mm_ok=1
XM4 outn outn outn VDD sg13_hv_pmos w=4u l=0.5u ng=1 m=1 mm_ok=1
XM5 net1 net1 net1 VSS sg13_hv_nmos w=2u l=0.5u ng=1 m=1 mm_ok=1
XM6 VSS VSS VSS VSS sg13_hv_nmos w=2u l=0.5u ng=1 m=1 mm_ok=1
XM7 net4 net4 net4 VDD sg13_hv_pmos w=4u l=0.5u ng=1 m=1 mm_ok=1
XM8 net1 net1 net1 VDD sg13_hv_pmos w=4u l=0.5u ng=1 m=1 mm_ok=1
XM9 outn outn outn VSS sg13_hv_nmos w=2u l=0.5u ng=1 m=1 mm_ok=1
XM10 VSS VSS VSS VSS sg13_hv_nmos w=2u l=0.5u ng=1 m=1 mm_ok=1
XMN8 comp_out net3 VSS VSS sg13_lv_nmos w=4u l=0.13u ng=1 m=1 mm_ok=1
XMP7 net3 net2 VDDL VDDL sg13_hv_pmos w=8u l=0.45u ng=1 m=1 mm_ok=1
XMN2 net3 net2 VSS VSS sg13_hv_nmos w=4u l=0.45u ng=1 m=1 mm_ok=1
XMP8 net3 net3 net3 VDDL sg13_hv_pmos w=8u l=0.45u ng=1 m=1 mm_ok=1
XMP9 VDDL VDDL VDDL VDDL sg13_hv_pmos w=8u l=0.45u ng=1 m=1 mm_ok=1
XMN7 net3 net3 net3 VSS sg13_hv_nmos w=4u l=0.45u ng=1 m=1 mm_ok=1
XMN9 VSS VSS VSS VSS sg13_hv_nmos w=4u l=0.45u ng=1 m=1 mm_ok=1
.ends

.GLOBAL GND
