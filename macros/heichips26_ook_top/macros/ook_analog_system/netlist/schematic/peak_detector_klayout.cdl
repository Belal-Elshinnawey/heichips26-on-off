** sch_path: /home/belal/HeiChips/heichips26-on-off/macros/heichips26_ook/macros/ook_analog_system/schematic/xschem/peak_detector.sch
.subckt peak_detector VSS vin vout VDD vamp
*.PININFO vin:I vout:B VSS:B VDD:B vamp:B
MM1 vamp vamp vout VSS sg13_hv_nmos w=20.0u l=0.5u ng=10
MM24 net1 net1 VDD VDD sg13_hv_pmos w=14u l=0.5u ng=7
MM25 vamp net1 VDD VDD sg13_hv_pmos w=14u l=0.5u ng=7
RR5 net1 VSS 7.0188k $SUB=VSS $[rhigh] w=2e-6 l=10e-6 b=0 m=1 ps=0.18e-6
MM13 VDD VDD VDD VDD sg13_hv_pmos w=2u l=0.5u ng=1
MM26 VDD VDD VDD VDD sg13_hv_pmos w=2u l=0.5u ng=1
MM27 vamp vamp vamp VDD sg13_hv_pmos w=2u l=0.5u ng=1
MM28 net1 net1 net1 VDD sg13_hv_pmos w=2u l=0.5u ng=1
RR3 vamp VSS 2.1616k $SUB=VSS $[rhigh] w=2e-6 l=3e-6 b=0 m=1 ps=0.18e-6
.ends
