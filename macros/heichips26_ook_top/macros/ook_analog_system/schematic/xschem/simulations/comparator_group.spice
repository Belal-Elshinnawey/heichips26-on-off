** sch_path: /home/belal/HeiChips/heichips26-on-off/macros/heichips26_ook/macros/ook_analog_system/schematic/xschem/comparator_group.sch
**.subckt comparator_group VDDL VDD vin q3 VSS q2 q1 q0 clk_h vref_1 vref_2 vref_3 vref_4
*.iopin VDD
*.iopin VDDL
*.iopin q0
*.iopin VSS
*.ipin clk_h
*.iopin q1
*.iopin q2
*.iopin q3
*.ipin vin
*.iopin vref_4
*.iopin vref_3
*.iopin vref_2
*.iopin vref_1
x1 clk_h vref_1 VDDL VDD vin q0 VSS clocked_comparator
x2 clk_h vref_2 VDDL VDD vin q1 VSS clocked_comparator
x3 clk_h vref_3 VDDL VDD vin q2 VSS clocked_comparator
x4 clk_h vref_4 VDDL VDD vin q3 VSS clocked_comparator
**.ends

* expanding   symbol:  clocked_comparator.sym # of pins=7
** sym_path: /home/belal/HeiChips/heichips26-on-off/macros/heichips26_ook/macros/ook_analog_system/schematic/xschem/clocked_comparator.sym
** sch_path: /home/belal/HeiChips/heichips26-on-off/macros/heichips26_ook/macros/ook_analog_system/schematic/xschem/clocked_comparator.sch
.subckt clocked_comparator clk vref VDDL VDD vin vout VSS
*.iopin VDD
*.iopin VDDL
*.ipin vin
*.ipin vref
*.iopin vout
*.ipin clk
*.iopin VSS
XMT VDD clkb net3 VDD sg13_hv_pmos w=5u l=0.5u ng=1 m=1 mm_ok=1
XM5 net3 vin net1 VDD sg13_hv_pmos w=5u l=0.5u ng=1 m=1 mm_ok=1
XM6 net1 net2 net5 VDD sg13_hv_pmos w=2u l=0.5u ng=1 m=1 mm_ok=1
XM7 net5 net2 VSS VSS sg13_hv_nmos w=1u l=0.5u ng=1 m=1 mm_ok=1
XM8 net3 vref net4 VDD sg13_hv_pmos w=5u l=0.5u ng=1 m=1 mm_ok=1
XM9 net4 net5 net2 VDD sg13_hv_pmos w=2u l=0.5u ng=1 m=1 mm_ok=1
XM10 net2 net5 VSS VSS sg13_hv_nmos w=1u l=0.5u ng=1 m=1 mm_ok=1
XM11 net5 clkb VSS VSS sg13_hv_nmos w=1u l=0.5u ng=1 m=1 mm_ok=1
XM12 net2 clkb VSS VSS sg13_hv_nmos w=1u l=0.5u ng=1 m=1 mm_ok=1
XM13 net4 clkb VSS VSS sg13_hv_nmos w=1u l=0.5u ng=1 m=1 mm_ok=1
XMPA1 VDDL net5 net8 VDDL sg13_hv_pmos w=4u l=0.5u ng=1 m=1 mm_ok=1
XMPA2 net8 net6 vout VDDL sg13_hv_pmos w=4u l=0.5u ng=1 m=1 mm_ok=1
XMNA1 vout net5 VSS VSS sg13_hv_nmos w=1u l=0.5u ng=1 m=1 mm_ok=1
XMNA2 vout net6 VSS VSS sg13_hv_nmos w=1u l=0.5u ng=1 m=1 mm_ok=1
XMPB1 VDDL net2 net7 VDDL sg13_hv_pmos w=4u l=0.5u ng=1 m=1 mm_ok=1
XMPB2 net7 vout net6 VDDL sg13_hv_pmos w=4u l=0.5u ng=1 m=1 mm_ok=1
XMNB1 net6 net2 VSS VSS sg13_hv_nmos w=1u l=0.5u ng=1 m=1 mm_ok=1
XMNB2 net6 vout VSS VSS sg13_hv_nmos w=1u l=0.5u ng=1 m=1 mm_ok=1
XM14 net1 clkb VSS VSS sg13_hv_nmos w=1u l=0.5u ng=1 m=1 mm_ok=1
XMIP1 clkb VSS clk VDD sg13_hv_pmos w=24u l=0.5u ng=12 m=1 mm_ok=1
XMIN1 clkb VDD clk VSS sg13_hv_nmos w=24u l=0.5u ng=12 m=1 mm_ok=1
XMT1 VDD VDD VDD VDD sg13_hv_pmos w=5u l=0.5u ng=1 m=1 mm_ok=1
XMT2 net3 net3 net3 VDD sg13_hv_pmos w=5u l=0.5u ng=1 m=1 mm_ok=1
XMIN2 clkb clkb clkb VSS sg13_hv_nmos w=2u l=0.5u ng=1 m=1 mm_ok=1
XMIN3 clk clk clk VSS sg13_hv_nmos w=2u l=0.5u ng=1 m=1 mm_ok=1
XMIP2 clk clk clk VDD sg13_hv_pmos w=2u l=0.5u ng=1 m=1 mm_ok=1
XMIP3 clkb clkb clkb VDD sg13_hv_pmos w=2u l=0.5u ng=1 m=1 mm_ok=1
XM1 net3 net3 net3 VDD sg13_hv_pmos w=5u l=0.5u ng=1 m=1 mm_ok=1
XM2 net3 net3 net3 VDD sg13_hv_pmos w=5u l=0.5u ng=1 m=1 mm_ok=1
XM3 net4 net4 net4 VDD sg13_hv_pmos w=5u l=0.5u ng=1 m=1 mm_ok=1
XM4 net1 net1 net1 VDD sg13_hv_pmos w=5u l=0.5u ng=1 m=1 mm_ok=1
XM15 net1 net1 net1 VDD sg13_hv_pmos w=2u l=0.5u ng=1 m=1 mm_ok=1
XM16 net4 net4 net4 VDD sg13_hv_pmos w=2u l=0.5u ng=1 m=1 mm_ok=1
XM17 net4 net4 net4 VSS sg13_hv_nmos w=1u l=0.5u ng=1 m=1 mm_ok=1
XM18 net1 net1 net1 VSS sg13_hv_nmos w=1u l=0.5u ng=1 m=1 mm_ok=1
XM19 net5 net5 net5 VDD sg13_hv_pmos w=2u l=0.5u ng=1 m=1 mm_ok=1
XM20 net2 net2 net2 VDD sg13_hv_pmos w=2u l=0.5u ng=1 m=1 mm_ok=1
XM21 VSS VSS VSS VSS sg13_hv_nmos w=1u l=0.5u ng=1 m=1 mm_ok=1
XM22 VSS VSS VSS VSS sg13_hv_nmos w=1u l=0.5u ng=1 m=1 mm_ok=1
XM23 net2 net2 net2 VSS sg13_hv_nmos w=1u l=0.5u ng=1 m=1 mm_ok=1
XM24 net5 net5 net5 VSS sg13_hv_nmos w=1u l=0.5u ng=1 m=1 mm_ok=1
XM25 VSS VSS VSS VSS sg13_hv_nmos w=1u l=0.5u ng=1 m=1 mm_ok=1
XM26 VSS VSS VSS VSS sg13_hv_nmos w=1u l=0.5u ng=1 m=1 mm_ok=1
XMPA3 VDDL VDDL VDDL VDDL sg13_hv_pmos w=4u l=0.5u ng=1 m=1 mm_ok=1
XMPB3 VDDL VDDL VDDL VDDL sg13_hv_pmos w=4u l=0.5u ng=1 m=1 mm_ok=1
XMPB4 net7 net7 net7 VDDL sg13_hv_pmos w=4u l=0.5u ng=1 m=1 mm_ok=1
XMPA4 net8 net8 net8 VDDL sg13_hv_pmos w=4u l=0.5u ng=1 m=1 mm_ok=1
XMPA5 net8 net8 net8 VDDL sg13_hv_pmos w=4u l=0.5u ng=1 m=1 mm_ok=1
XMPB5 net7 net7 net7 VDDL sg13_hv_pmos w=4u l=0.5u ng=1 m=1 mm_ok=1
XMPA6 vout vout vout VDDL sg13_hv_pmos w=4u l=0.5u ng=1 m=1 mm_ok=1
XMPB6 net6 net6 net6 VDDL sg13_hv_pmos w=4u l=0.5u ng=1 m=1 mm_ok=1
XMNA3 vout vout vout VSS sg13_hv_nmos w=1u l=0.5u ng=1 m=1 mm_ok=1
XMNA4 vout vout vout VSS sg13_hv_nmos w=1u l=0.5u ng=1 m=1 mm_ok=1
XMNB3 net6 net6 net6 VSS sg13_hv_nmos w=1u l=0.5u ng=1 m=1 mm_ok=1
XMNB4 net6 net6 net6 VSS sg13_hv_nmos w=1u l=0.5u ng=1 m=1 mm_ok=1
XMNB5 VSS VSS VSS VSS sg13_hv_nmos w=1u l=0.5u ng=1 m=1 mm_ok=1
XMNB6 VSS VSS VSS VSS sg13_hv_nmos w=1u l=0.5u ng=1 m=1 mm_ok=1
XMNA5 VSS VSS VSS VSS sg13_hv_nmos w=1u l=0.5u ng=1 m=1 mm_ok=1
XMNA6 VSS VSS VSS VSS sg13_hv_nmos w=1u l=0.5u ng=1 m=1 mm_ok=1
XM27 net5 net5 net5 VSS sg13_hv_nmos w=1u l=0.5u ng=1 m=1 mm_ok=1
XM28 VSS VSS VSS VSS sg13_hv_nmos w=1u l=0.5u ng=1 m=1 mm_ok=1
XM29 net2 net2 net2 VSS sg13_hv_nmos w=1u l=0.5u ng=1 m=1 mm_ok=1
XM30 VSS VSS VSS VSS sg13_hv_nmos w=1u l=0.5u ng=1 m=1 mm_ok=1
.ends

.end
