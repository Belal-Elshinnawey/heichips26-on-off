** sch_path: /home/belal/HeiChips/heichips26-on-off/macros/heichips26_ook/macros/ook_analog_system/testbenches/xschem/simple_comparator_tb_tran.sch
**.subckt simple_comparator_tb_tran comp_out
*.opin comp_out
VDDSRC VDD GND {VDD}
VIN vin GND PWL(0 0 10u {0.35})
VREF vref GND 0.3
x2 vin vref VDD GND comp_out VDDL simple_comparator_pex
VDDSRC1 VDDL GND {VDD/2}
**** begin user architecture code

.param VDD=3.3
.options savecurrents klu reltol=1e-3 abstol=1e-12 vntol=1e-6 gmin=1e-9
.control
save v(vin) v(vref) v(comp_out) v(VDD) v(VSS)
tran 10n 10u
write simple_comparator_tb_tran\.raw
meas tran trip_point TRIG v(vin) VAL=1.5 RISE=1 TARG v(comp_out) VAL={VDD/2} CROSS=1
print trip_point
plot vin vref comp_out
.endc

.lib cornerMOSlv.lib mos_tt
.lib cornerMOShv.lib mos_tt
.lib cornerRES.lib res_typ
.lib cornerDIO.lib dio_tt
.lib cornerCAP.lib cap_typ
.include /home/belal/HeiChips/heichips26-on-off/macros/heichips26_ook/macros/ook_analog_system/netlist/pex/simple_comparator_magic_pex_3.spice

**** end user architecture code
**.ends
.GLOBAL VDD
.GLOBAL GND
.GLOBAL VDDL
.end
