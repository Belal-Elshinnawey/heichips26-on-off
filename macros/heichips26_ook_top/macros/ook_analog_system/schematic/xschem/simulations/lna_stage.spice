** sch_path: /home/belal/HeiChips/heichips26-on-off/macros/heichips26_ook/macros/ook_analog_system/schematic/xschem/lna_stage.sch
**.subckt lna_stage Cap_M2 Cap_M1 VDD vout vin VSS Cap_M21 Cap_M11
*.ipin vin
*.iopin VSS
*.iopin VDD
*.iopin Cap_M2
*.iopin Cap_M1
*.iopin vout
*.iopin Cap_M21
*.iopin Cap_M11
x2 VDD Cap_M1 vin VSS lna
x1 VDD Cap_M11 Cap_M2 VSS lna
x3 VDD vout Cap_M21 VSS lna
**.ends

* expanding   symbol:  lna.sym # of pins=4
** sym_path: /home/belal/HeiChips/heichips26-on-off/macros/heichips26_ook/macros/ook_analog_system/schematic/xschem/lna.sym
** sch_path: /home/belal/HeiChips/heichips26-on-off/macros/heichips26_ook/macros/ook_analog_system/schematic/xschem/lna.sch
.subckt lna VDD vout vin VSS
*.iopin VDD
*.iopin VSS
*.ipin vin
*.iopin vout
XM14 vout VDD net6 VSS sg13_hv_nmos w=2.0u l=0.5u ng=2 m=1 mm_ok=1
XM15 net6 vin VSS VSS sg13_hv_nmos w=18.0u l=0.5u ng=18 m=1 mm_ok=1
XM16 net1 net1 VSS VSS sg13_hv_nmos w=2.00u l=0.5u ng=2 m=1 mm_ok=1
XM17 isource1 vout VSS VSS sg13_hv_nmos w=0.5u l=0.5u ng=1 m=1 mm_ok=1
XM18 VDD isource1 isink1 VSS sg13_hv_nmos w=1.5u l=0.5u ng=1 m=1 mm_ok=1
XM19 VSS isink1 vout VDD sg13_hv_pmos w=0.7u l=0.5u ng=1 m=1 mm_ok=1
XM20 net2 net2 VSS VSS sg13_hv_nmos w=10.0u l=0.5u ng=5 m=1 mm_ok=1
XM21 isink1 net2 VSS VSS sg13_hv_nmos w=10.0u l=0.5u ng=5 m=1 mm_ok=1
XM22 net3 net3 VDD VDD sg13_hv_pmos w=14u l=0.5u ng=7 m=1 mm_ok=1
XM23 isource1 net3 VDD VDD sg13_hv_pmos w=14u l=0.5u ng=7 m=1 mm_ok=1
XM24 net4 net4 VDD VDD sg13_hv_pmos w=14u l=0.5u ng=7 m=1 mm_ok=1
XM25 vout net4 VDD VDD sg13_hv_pmos w=14u l=0.5u ng=7 m=1 mm_ok=1
XR2 net1 vin VSS rhigh w=2.0e-6 l=9.96e-6 m=1 b=3 ps=0.18e-6 mm_ok=1
XR5 net4 VSS VSS rhigh w=2e-6 l=4.95e-6 m=1 b=2 ps=0.18e-6 mm_ok=1
XR1 VDD net1 VSS rhigh w=2e-6 l=19.995e-6 m=1 b=9 ps=0.18e-6 mm_ok=1
XR6 VDD net2 VSS rhigh w=2.0e-6 l=19.995e-6 m=1 b=9 ps=0.18e-6 mm_ok=1
XM2 net5 net5 VSS VSS sg13_hv_nmos w=0.5u l=0.5u ng=1 m=1 mm_ok=1
XM3 vout net5 VSS VSS sg13_hv_nmos w=0.5u l=0.5u ng=1 m=1 mm_ok=1
XR4 net3 VSS VSS rhigh w=2e-6 l=4.95e-6 m=1 b=2 ps=0.18e-6 mm_ok=1
XR13 VDD net5 VSS rhigh w=2e-6 l=22.72e-6 m=1 b=10 ps=0.18e-6 mm_ok=1
XM1 VSS VSS VSS VDD sg13_hv_pmos w=0.7u l=0.5u ng=1 m=1 mm_ok=1
XM4 vout vout vout VDD sg13_hv_pmos w=0.7u l=0.5u ng=1 m=1 mm_ok=1
XM5 VSS VSS VSS VSS sg13_hv_nmos w=0.5u l=0.5u ng=1 m=1 mm_ok=1
XM6 isource1 isource1 isource1 VSS sg13_hv_nmos w=0.5u l=0.5u ng=1 m=1 mm_ok=1
XM7 isink1 isink1 isink1 VSS sg13_hv_nmos w=1.5u l=0.5u ng=1 m=1 mm_ok=1
XM8 VDD VDD VDD VSS sg13_hv_nmos w=1.5u l=0.5u ng=1 m=1 mm_ok=1
XM9 isource1 isource1 isource1 VDD sg13_hv_pmos w=2u l=0.5u ng=1 m=1 mm_ok=1
XM10 VDD VDD VDD VDD sg13_hv_pmos w=2u l=0.5u ng=1 m=1 mm_ok=1
XM11 VDD VDD VDD VDD sg13_hv_pmos w=2u l=0.5u ng=1 m=1 mm_ok=1
XM12 net3 net3 net3 VDD sg13_hv_pmos w=2u l=0.5u ng=1 m=1 mm_ok=1
XM13 VDD VDD VDD VDD sg13_hv_pmos w=2u l=0.5u ng=1 m=1 mm_ok=1
XM26 VDD VDD VDD VDD sg13_hv_pmos w=2u l=0.5u ng=1 m=1 mm_ok=1
XM27 vout vout vout VDD sg13_hv_pmos w=2u l=0.5u ng=1 m=1 mm_ok=1
XM28 net4 net4 net4 VDD sg13_hv_pmos w=2u l=0.5u ng=1 m=1 mm_ok=1
XM29 isink1 isink1 isink1 VSS sg13_hv_nmos w=2.0u l=0.5u ng=1 m=1 mm_ok=1
XM30 VSS VSS VSS VSS sg13_hv_nmos w=2.0u l=0.5u ng=1 m=1 mm_ok=1
XM31 net2 net2 net2 VSS sg13_hv_nmos w=2.0u l=0.5u ng=1 m=1 mm_ok=1
XM32 VSS VSS VSS VSS sg13_hv_nmos w=2.0u l=0.5u ng=1 m=1 mm_ok=1
XM33 vout vout vout VSS sg13_hv_nmos w=0.5u l=0.5u ng=1 m=1 mm_ok=1
XM34 VSS VSS VSS VSS sg13_hv_nmos w=0.5u l=0.5u ng=1 m=1 mm_ok=1
XM35 net5 net5 net5 VSS sg13_hv_nmos w=0.5u l=0.5u ng=1 m=1 mm_ok=1
XM36 VSS VSS VSS VSS sg13_hv_nmos w=0.5u l=0.5u ng=1 m=1 mm_ok=1
XM37 vout vout vout VSS sg13_hv_nmos w=1.0u l=0.5u ng=1 m=1 mm_ok=1
XM38 net6 net6 net6 VSS sg13_hv_nmos w=1.0u l=0.5u ng=1 m=1 mm_ok=1
XM39 net6 net6 net6 VSS sg13_hv_nmos w=1.0u l=0.5u ng=1 m=1 mm_ok=1
XM40 VSS VSS VSS VSS sg13_hv_nmos w=1.0u l=0.5u ng=1 m=1 mm_ok=1
XM41 net1 net1 net1 VSS sg13_hv_nmos w=1.00u l=0.5u ng=1 m=1 mm_ok=1
XM42 VSS VSS VSS VSS sg13_hv_nmos w=1.00u l=0.5u ng=1 m=1 mm_ok=1
.ends

.end
