* Extracted by KLayout with SG13CMOS5L LVS runset on : 28/09/2026 06:59

.SUBCKT heichips26_ook_top VAPWR VGND VPWR analog_0 analog_1 analog_2 clk_ref
+ q0 q1 q2 q3 rst_n vctrl_b_in vctrl_in
X$759 VPWR \$2967 VGND \$2528 \$2648 \$3217 \$2755 sg13cmos5l_nand4_1
X$763 VPWR VGND \$2468 \$2415 \$2465 \$2528 \$2481 sg13cmos5l_or4_1
X$767 VGND \$1932 VPWR \$1929 \$1975 sg13cmos5l_xor2_1
X$768 VGND \$1557 VPWR \$1531 \$457 sg13cmos5l_xor2_1
X$769 VGND \$1774 VPWR \$1776 \$1928 sg13cmos5l_xor2_1
X$770 VGND \$3763 VPWR \$4044 \$4045 sg13cmos5l_xor2_1
X$771 VGND \$3605 VPWR \$3485 \$2989 sg13cmos5l_xor2_1
X$772 VGND \$3570 VPWR \$3089 \$3393 sg13cmos5l_xor2_1
X$773 VGND \$3580 VPWR \$3690 \$2646 sg13cmos5l_xor2_1
X$774 VGND \$4023 VPWR \$3173 \$3917 sg13cmos5l_xor2_1
X$775 VGND \$3533 VPWR \$3121 \$2985 sg13cmos5l_xor2_1
X$776 VGND \$3115 VPWR \$3113 \$3114 sg13cmos5l_xor2_1
X$777 VGND \$2586 VPWR \$2592 \$2648 sg13cmos5l_xor2_1
X$778 VGND \$3781 VPWR \$3570 \$3569 sg13cmos5l_xor2_1
X$779 VGND \$3576 VPWR \$3268 \$2973 sg13cmos5l_xor2_1
X$780 VGND \$2866 VPWR \$2689 \$2647 sg13cmos5l_xor2_1
X$781 VGND \$3568 VPWR \$3675 \$2451 sg13cmos5l_xor2_1
X$782 VGND \$3817 VPWR \$2973 \$3617 sg13cmos5l_xor2_1
X$783 VGND \$2863 VPWR \$2736 \$2963 sg13cmos5l_xor2_1
X$784 VGND \$3592 VPWR \$3486 \$3065 sg13cmos5l_xor2_1
X$785 VGND \$3301 VPWR \$2698 \$2985 sg13cmos5l_xor2_1
X$786 VGND \$2114 VPWR \$2115 \$1790 sg13cmos5l_xor2_1
X$787 VGND \$4045 VPWR \$2989 \$3933 sg13cmos5l_xor2_1
X$788 VGND \$2727 VPWR \$2570 \$2336 sg13cmos5l_xor2_1
X$856 VPWR VGND \$3574 \$3686 \$2973 sg13cmos5l_xnor2_1
X$857 VPWR VGND \$2567 \$2045 \$2495 sg13cmos5l_xnor2_1
X$858 VPWR VGND \$3924 \$2695 \$3922 sg13cmos5l_xnor2_1
X$859 VPWR VGND \$3944 \$2768 \$3773 sg13cmos5l_xnor2_1
X$860 VPWR VGND \$2789 \$2694 \$2755 sg13cmos5l_xnor2_1
X$861 VPWR VGND \$2743 \$2586 \$2585 sg13cmos5l_xnor2_1
X$862 VPWR VGND \$3448 \$3197 \$2988 sg13cmos5l_xnor2_1
X$863 VPWR VGND \$1825 \$1826 \$1862 sg13cmos5l_xnor2_1
X$864 VPWR VGND \$2234 \$2232 \$2233 sg13cmos5l_xnor2_1
X$865 VPWR VGND \$2570 \$736 \$2457 sg13cmos5l_xnor2_1
X$866 VPWR VGND \$2088 \$2152 \$2233 sg13cmos5l_xnor2_1
X$867 VPWR VGND \$2689 \$2653 \$3173 sg13cmos5l_xnor2_1
X$868 VPWR VGND \$1546 \$1697 \$354 sg13cmos5l_xnor2_1
X$869 VPWR VGND \$2682 \$2742 \$2586 sg13cmos5l_xnor2_1
X$870 VPWR VGND \$2854 \$2055 \$3089 sg13cmos5l_xnor2_1
X$871 VPWR VGND \$3420 \$3464 \$3217 sg13cmos5l_xnor2_1
X$872 VPWR VGND \$457 \$990 \$964 sg13cmos5l_xnor2_1
X$873 VPWR VGND \$3825 \$3783 \$3824 sg13cmos5l_xnor2_1
X$874 VPWR VGND \$3634 \$3522 \$3283 sg13cmos5l_xnor2_1
X$875 VPWR VGND \$3940 \$3943 \$3937 sg13cmos5l_xnor2_1
X$876 VPWR VGND \$3740 \$2646 \$3909 sg13cmos5l_xnor2_1
X$877 VPWR VGND \$4002 \$4041 \$4038 sg13cmos5l_xnor2_1
X$878 VPWR VGND \$2736 \$2970 \$2967 sg13cmos5l_xnor2_1
X$879 VPWR VGND \$1899 \$1934 \$290 sg13cmos5l_xnor2_1
X$880 VPWR VGND \$3668 \$3488 \$2437 sg13cmos5l_xnor2_1
X$881 VPWR VGND \$2482 \$736 \$2084 sg13cmos5l_xnor2_1
X$882 VPWR VGND \$1869 \$1873 \$1871 sg13cmos5l_xnor2_1
X$883 VPWR VGND \$3090 \$2854 \$2734 sg13cmos5l_xnor2_1
X$884 VPWR VGND \$2449 \$2288 \$2225 sg13cmos5l_xnor2_1
X$885 VPWR VGND \$3857 \$3562 \$3668 sg13cmos5l_xnor2_1
X$886 VPWR VGND \$3312 \$3313 \$3114 sg13cmos5l_xnor2_1
X$887 VPWR VGND \$3177 \$2789 \$2840 sg13cmos5l_xnor2_1
X$888 VPWR VGND \$3675 \$2517 \$3616 sg13cmos5l_xnor2_1
X$931 VPWR VGND \$1064 \$251 \$525 \$455 sg13cmos5l_or3_1
X$932 VPWR VGND \$3522 \$3173 \$2695 \$3486 sg13cmos5l_or3_1
X$950 VGND VPWR \$818 \$698 \$252 \$52 sg13cmos5l_nand3_1
X$951 VGND VPWR \$2660 \$2701 \$2698 \$2768 sg13cmos5l_nand3_1
X$952 VGND VPWR \$2983 \$2789 \$2836 \$2932 sg13cmos5l_nand3_1
X$953 VGND VPWR \$3260 \$3257 \$2500 \$3029 sg13cmos5l_nand3_1
X$954 VGND VPWR \$1804 \$859 \$1628 \$1748 sg13cmos5l_nand3_1
X$955 VGND VPWR \$2916 \$2854 \$2618 \$2457 sg13cmos5l_nand3_1
X$956 VGND VPWR \$2693 \$2555 \$2581 \$2695 sg13cmos5l_nand3_1
X$957 VPWR \$2252 VGND \$2415 \$2691 \$2768 \$2701 sg13cmos5l_nand4_1
X$958 VGND VPWR \$2749 \$2689 \$2685 \$2687 sg13cmos5l_nand3_1
X$959 VGND VPWR \$2259 \$2368 \$2374 \$2373 sg13cmos5l_nand3_1
X$960 VGND VPWR \$2928 \$1789 \$2581 \$2973 sg13cmos5l_nand3_1
X$961 VGND VPWR \$680 \$903 \$354 \$580 sg13cmos5l_nand3_1
X$962 VGND VPWR \$247 \$525 \$354 \$251 sg13cmos5l_nand3_1
X$963 VGND VPWR \$2676 \$2736 \$2677 \$2737 sg13cmos5l_nand3_1
X$964 VGND VPWR \$3464 \$2646 \$3268 \$2967 sg13cmos5l_nand3_1
X$965 VGND VPWR \$1422 \$1329 \$1207 \$1358 sg13cmos5l_nand3_1
X$966 VGND VPWR \$2588 \$2250 \$2104 \$2646 sg13cmos5l_nand3_1
X$970 VPWR VGND \$2739 \$2740 \$2638 \$2682 sg13cmos5l_a21o_1
X$971 VPWR VGND \$1960 \$1535 \$1566 \$136 sg13cmos5l_a21o_1
X$972 VPWR VGND \$2003 \$1913 \$859 \$1628 sg13cmos5l_a21o_1
X$973 VPWR VGND \$3579 \$2241 \$3464 \$3338 sg13cmos5l_a21o_1
X$974 VPWR VGND \$2244 \$2300 \$2054 \$1665 sg13cmos5l_a21o_1
X$975 VPWR VGND \$2734 \$2457 \$2045 \$1987 sg13cmos5l_a21o_1
X$976 VPWR VGND \$3452 \$3374 \$3454 \$3235 sg13cmos5l_a21o_1
X$977 VPWR VGND \$2002 \$1566 \$1810 \$2094 sg13cmos5l_a21o_1
X$978 VPWR VGND \$2025 \$2179 \$2106 \$2105 sg13cmos5l_a21o_1
X$979 VPWR VGND \$3937 \$4046 \$4045 \$4044 sg13cmos5l_a21o_1
X$980 VPWR VGND \$2374 \$2439 \$2484 \$2483 sg13cmos5l_a21o_1
X$981 VPWR VGND \$3338 \$2646 \$2967 \$3268 sg13cmos5l_a21o_1
X$982 VPWR VGND \$2836 \$2689 \$2687 \$2685 sg13cmos5l_a21o_1
X$983 VPWR VGND \$2677 \$2854 \$2457 \$2618 sg13cmos5l_a21o_1
X$984 VPWR VGND \$2228 \$2235 \$2106 \$2237 sg13cmos5l_a21o_1
X$985 VPWR VGND \$3708 \$3937 \$3773 \$2768 sg13cmos5l_a21o_1
X$986 VPWR VGND \$568 \$641 \$593 \$462 sg13cmos5l_a21o_1
X$987 VPWR VGND \$252 \$457 \$456 \$455 sg13cmos5l_a21o_1
X$1001 VPWR VGND \$2197 \$1996 \$1961 \$2069 sg13cmos5l_nand3b_1
X$1002 VPWR VGND \$1901 \$1628 \$2204 \$2070 sg13cmos5l_nand3b_1
X$1003 VPWR VGND \$491 \$1064 \$525 \$903 sg13cmos5l_nand3b_1
X$1019 VGND clk_ref \$620 VPWR sg13cmos5l_buf_8
X$1020 VGND \$1658 \$1435 VPWR sg13cmos5l_buf_8
X$1021 VGND \$1703 \$1656 VPWR sg13cmos5l_buf_8
X$1022 VGND \$1212 \$1260 VPWR sg13cmos5l_buf_8
X$1023 VGND \$1169 \$1701 VPWR sg13cmos5l_buf_8
X$1024 VGND \$1125 \$1710 VPWR sg13cmos5l_buf_8
X$1025 VGND \$1487 \$512 VPWR sg13cmos5l_buf_8
X$1026 VGND \$620 \$2086 VPWR sg13cmos5l_buf_8
X$1027 VGND \$1658 \$1884 VPWR sg13cmos5l_buf_8
X$1028 VGND \$620 \$3510 VPWR sg13cmos5l_buf_8
X$1029 VGND \$1315 \$1703 VPWR sg13cmos5l_buf_8
X$1030 VGND \$1606 \$1125 VPWR sg13cmos5l_buf_8
X$1031 VGND \$620 \$1970 VPWR sg13cmos5l_buf_8
X$1032 VGND \$1718 \$1658 VPWR sg13cmos5l_buf_8
X$1033 VGND \$1662 VPWR \$1535 \$990 sg13cmos5l_xor2_1
X$1034 VGND \$620 \$80 VPWR sg13cmos5l_buf_8
X$1035 VGND \$1125 \$484 VPWR sg13cmos5l_buf_8
X$1036 VGND \$1315 \$1214 VPWR sg13cmos5l_buf_8
X$1037 VGND \$1169 \$655 VPWR sg13cmos5l_buf_8
X$1038 VGND \$1370 \$1212 VPWR sg13cmos5l_buf_8
X$1039 VGND \$620 \$1572 VPWR sg13cmos5l_buf_8
X$1040 VGND \$1370 \$1718 VPWR sg13cmos5l_buf_8
X$1041 VGND \$1214 \$1169 VPWR sg13cmos5l_buf_8
X$1042 VGND \$1261 \$1606 VPWR sg13cmos5l_buf_8
X$1043 VGND \$620 \$3539 VPWR sg13cmos5l_buf_8
X$1044 VGND \$620 \$1176 VPWR sg13cmos5l_buf_8
X$1045 VGND \$1261 \$1487 VPWR sg13cmos5l_buf_8
X$1046 VPWR VGND \$2989 \$2985 \$2760 \$2875 \$2880 sg13cmos5l_nor4_1
X$1047 VPWR VGND \$964 \$580 \$990 \$1064 \$313 sg13cmos5l_nor4_1
X$1048 VPWR VGND \$2989 \$3065 \$2768 \$3486 \$2700 sg13cmos5l_nor4_1
X$1049 VPWR VGND \$3089 \$2517 \$2973 \$2727 \$3690 sg13cmos5l_nor4_1
X$1050 VPWR VGND \$2468 \$2465 \$2528 \$2415 \$2241 sg13cmos5l_nor4_1
X$1051 VPWR VGND \$775 \$1208 \$892 \$1033 \$1067 sg13cmos5l_nor4_1
X$1052 VPWR VGND \$917 \$1447 \$1362 \$775 \$1329 sg13cmos5l_nor4_1
X$1053 VPWR VGND \$1773 \$1924 \$1776 \$2104 \$2336 sg13cmos5l_nor4_1
X$1054 VPWR VGND \$736 \$303 \$509 \$630 \$735 sg13cmos5l_nor4_1
X$1055 VGND \$2707 \$2204 \$2254 \$2706 VPWR sg13cmos5l_mux2_1
X$1056 VGND \$941 \$251 \$96 \$356 VPWR sg13cmos5l_mux2_1
X$1057 VGND \$2615 \$1987 \$2567 \$2457 VPWR sg13cmos5l_mux2_1
X$1058 VGND \$2848 \$2204 \$2441 \$2700 VPWR sg13cmos5l_mux2_1
X$1059 VGND \$919 \$593 \$1230 \$641 VPWR sg13cmos5l_mux2_1
X$1060 VGND \$2618 \$2336 \$2570 \$2567 VPWR sg13cmos5l_mux2_1
X$1061 \$358 VGND VPWR \$462 \$103 \$936 \$156 sg13cmos5l_a22oi_1
X$1062 \$848 VGND VPWR \$849 \$1064 \$1050 \$836 sg13cmos5l_a22oi_1
X$1063 \$759 VGND VPWR \$827 \$452 \$489 \$17 sg13cmos5l_a22oi_1
X$1064 \$3085 VGND VPWR \$2441 \$2998 \$3000 \$2252 sg13cmos5l_a22oi_1
X$1065 \$1933 VGND VPWR \$2007 \$2025 \$1979 \$1980 sg13cmos5l_a22oi_1
X$1066 \$536 VGND VPWR \$641 \$593 \$961 \$903 sg13cmos5l_a22oi_1
X$1067 \$195 VGND VPWR \$836 \$990 \$641 \$593 sg13cmos5l_a22oi_1
X$1068 \$562 VGND VPWR \$195 \$685 \$639 \$363 sg13cmos5l_a22oi_1
X$1069 \$2607 VGND VPWR \$2707 \$2323 \$2668 \$2207 sg13cmos5l_a22oi_1
X$1070 \$2998 VGND VPWR \$2991 \$2437 \$2254 \$2889 sg13cmos5l_a22oi_1
X$1071 \$933 VGND VPWR \$462 \$872 \$936 \$934 sg13cmos5l_a22oi_1
X$1072 \$469 VGND VPWR \$313 \$16 \$595 \$137 sg13cmos5l_a22oi_1
X$1073 \$450 VGND VPWR \$568 \$452 \$708 \$17 sg13cmos5l_a22oi_1
X$1074 VPWR VGND \$775 \$618 \$776 \$857 sg13cmos5l_or3_1
X$1075 \$2222 VGND VPWR \$2002 \$2228 \$2331 \$2233 sg13cmos5l_a22oi_1
X$1228 \$2877 \$3758 \$3639 VPWR VGND sg13cmos5l_or2_1
X$1229 \$3029 \$2962 \$2055 VPWR VGND sg13cmos5l_or2_1
X$1230 \$2094 \$2483 \$2598 VPWR VGND sg13cmos5l_or2_1
X$1231 \$2457 \$2500 \$1987 VPWR VGND sg13cmos5l_or2_1
X$1232 \$917 \$1208 \$1305 VPWR VGND sg13cmos5l_or2_1
X$1233 \$17 \$448 \$568 VPWR VGND sg13cmos5l_or2_1
X$1234 \$964 \$1230 \$990 VPWR VGND sg13cmos5l_or2_1
X$1235 \$2333 \$2338 \$2148 VPWR VGND sg13cmos5l_or2_1
X$1236 \$2007 \$3599 \$3662 VPWR VGND sg13cmos5l_or2_1
X$1237 \$303 \$555 \$509 VPWR VGND sg13cmos5l_or2_1
X$1238 \$1005 \$782 \$849 VPWR VGND sg13cmos5l_or2_1
X$1239 \$290 \$2037 \$491 VPWR VGND sg13cmos5l_or2_1
X$1240 VGND VPWR \$3983 \$3741 \$4123 sg13cmos5l_nor2b_1
X$1241 VGND VPWR \$3986 \$4026 \$3923 sg13cmos5l_nor2b_1
X$1242 VGND VPWR \$3110 \$2875 \$2983 sg13cmos5l_nor2b_1
X$1243 VGND VPWR \$2826 \$2738 \$2676 sg13cmos5l_nor2b_1
X$1244 VGND VPWR \$321 \$525 \$903 sg13cmos5l_nor2b_1
X$1245 VGND VPWR \$3457 \$3686 \$3975 sg13cmos5l_nor2b_1
X$1246 VGND VPWR \$3121 \$2528 \$3268 sg13cmos5l_nor2b_1
X$1247 VGND VPWR \$1050 \$903 \$964 sg13cmos5l_nor2b_1
X$1248 VGND VPWR \$4041 \$4000 \$3998 sg13cmos5l_nor2b_1
X$1249 VGND VPWR \$2115 \$2054 \$1873 sg13cmos5l_nor2b_1
X$1250 VGND VPWR \$3334 \$3268 \$3260 sg13cmos5l_nor2b_1
X$1251 VGND VPWR \$1521 \$1447 \$805 sg13cmos5l_nor2b_1
X$1317 VGND \$3090 VPWR \$3250 \$2857 \$2936 \$2638 \$2959 sg13cmos5l_a221oi_1
X$1318 VGND \$2615 VPWR \$3015 \$2857 \$2936 \$2618 \$2638 sg13cmos5l_a221oi_1
X$1319 VGND \$2863 VPWR \$2960 \$2857 \$2936 \$2638 \$2826 sg13cmos5l_a221oi_1
X$1320 VGND \$2866 VPWR \$2976 \$2094 \$2936 \$2638 \$2871 sg13cmos5l_a221oi_1
X$1321 VGND \$590 VPWR \$529 \$555 \$630 \$52 \$422 sg13cmos5l_a221oi_1
X$1322 VGND \$3177 VPWR \$3299 \$2943 \$2936 \$2638 \$3110 sg13cmos5l_a221oi_1
X$1323 VGND \$3580 VPWR \$3514 \$2239 \$2349 \$2857 \$3579 sg13cmos5l_a221oi_1
X$1324 VGND \$1110 VPWR \$1628 \$882 \$136 \$1422 \$973 sg13cmos5l_a221oi_1
X$1325 VGND \$2239 VPWR \$2235 \$2234 \$2349 \$2133 \$2241 sg13cmos5l_a221oi_1
X$1326 VGND \$253 VPWR \$284 \$194 \$257 \$16 \$48 sg13cmos5l_a221oi_1
X$1327 VGND \$3301 VPWR \$3300 \$2943 \$2936 \$2879 \$3112 sg13cmos5l_a221oi_1
X$1328 VGND \$3312 VPWR \$3307 \$2943 \$2936 \$2879 \$3115 sg13cmos5l_a221oi_1
X$1329 VGND \$936 VPWR \$1490 \$1656 \$1652 \$1260 \$1050 sg13cmos5l_a221oi_1
X$1330 VGND \$464 VPWR \$722 \$1490 \$354 \$933 \$1180 sg13cmos5l_a221oi_1
X$1331 VGND \$1050 VPWR \$1180 \$1128 \$580 \$397 \$321 sg13cmos5l_a221oi_1
X$1332 VGND \$3641 VPWR \$3639 \$2239 \$2439 \$2943 \$3524 sg13cmos5l_a221oi_1
X$1333 VGND \$2099 VPWR \$2179 \$2239 \$2349 \$2094 \$2241 sg13cmos5l_a221oi_1
X$1334 VGND \$3605 VPWR \$3662 \$2239 \$2439 \$2943 \$3483 sg13cmos5l_a221oi_1
X$1335 VGND \$3569 VPWR \$3572 \$3570 \$3391 \$3617 \$2973 sg13cmos5l_a221oi_1
X$1336 VGND \$2254 VPWR \$2106 \$2252 \$2130 \$2003 \$1804 sg13cmos5l_a221oi_1
X$1337 VPWR VGND \$3690 \$2646 \$3522 sg13cmos5l_nand2b_1
X$1338 VPWR VGND \$1107 \$1071 \$1033 sg13cmos5l_nand2b_1
X$1339 VPWR VGND \$2338 \$2347 \$2288 sg13cmos5l_nand2b_1
X$1340 VPWR VGND \$990 \$964 \$836 sg13cmos5l_nand2b_1
X$1341 VPWR VGND \$632 \$25 \$590 sg13cmos5l_nand2b_1
X$1342 VPWR VGND \$2289 \$2232 \$2099 sg13cmos5l_nand2b_1
X$1343 VPWR VGND \$51 \$1720 \$1665 sg13cmos5l_nand2b_1
X$1344 VPWR VGND \$525 \$903 \$961 sg13cmos5l_nand2b_1
X$1345 VPWR VGND \$52 \$195 \$295 sg13cmos5l_nand2b_1
X$1346 VPWR VGND \$3485 \$2989 \$3606 sg13cmos5l_nand2b_1
X$1347 VPWR VGND \$1912 \$1748 \$1913 sg13cmos5l_nand2b_1
X$1348 VPWR VGND \$3064 \$3113 \$3112 sg13cmos5l_nand2b_1
X$1349 VPWR VGND \$3313 \$2985 \$2698 sg13cmos5l_nand2_1
X$1350 VPWR VGND \$2668 \$2207 \$2848 sg13cmos5l_nand2_1
X$1351 VPWR VGND \$2938 \$2252 \$2254 sg13cmos5l_nand2_1
X$1352 VPWR VGND \$2065 \$1961 \$1665 sg13cmos5l_nand2_1
X$1353 VPWR VGND \$2970 \$1789 \$2581 sg13cmos5l_nand2_1
X$1354 VPWR VGND \$2991 \$2701 \$2698 sg13cmos5l_nand2_1
X$1355 VPWR VGND \$1756 \$1887 \$1665 sg13cmos5l_nand2_1
X$1356 VPWR VGND \$2936 \$2439 \$2938 sg13cmos5l_nand2_1
X$1357 VPWR VGND \$2082 \$1776 \$2007 sg13cmos5l_nand2_1
X$1358 VPWR VGND \$2598 \$2702 \$2700 sg13cmos5l_nand2_1
X$1359 VPWR VGND \$2694 \$2555 \$2581 sg13cmos5l_nand2_1
X$1360 VPWR VGND \$3566 \$2252 \$3488 sg13cmos5l_nand2_1
X$1361 VPWR VGND \$3829 \$3173 \$2877 sg13cmos5l_nand2_1
X$1362 VPWR VGND \$1934 \$1535 \$2097 sg13cmos5l_nand2_1
X$1363 VPWR VGND \$2105 \$2099 \$2638 sg13cmos5l_nand2_1
X$1364 VPWR VGND \$1942 \$1873 \$1665 sg13cmos5l_nand2_1
X$1365 VPWR VGND \$2358 \$2301 \$1665 sg13cmos5l_nand2_1
X$1366 VPWR VGND \$827 \$698 \$898 sg13cmos5l_nand2_1
X$1367 VPWR VGND \$1898 \$1924 \$1773 sg13cmos5l_nand2_1
X$1368 VPWR VGND \$2554 \$2477 \$2598 sg13cmos5l_nand2_1
X$1369 VPWR VGND \$2424 \$2069 \$1665 sg13cmos5l_nand2_1
X$1370 VPWR VGND \$2098 \$1050 \$1531 sg13cmos5l_nand2_1
X$1371 VPWR VGND \$2653 \$1881 \$2581 sg13cmos5l_nand2_1
X$1372 VPWR VGND \$2592 \$2250 \$2104 sg13cmos5l_nand2_1
X$1373 VPWR VGND \$341 \$137 \$536 sg13cmos5l_nand2_1
X$1374 VPWR VGND \$349 \$363 \$252 sg13cmos5l_nand2_1
X$1375 VPWR VGND \$1810 \$859 \$1628 sg13cmos5l_nand2_1
X$1376 VPWR VGND \$2133 \$1628 \$1667 sg13cmos5l_nand2_1
X$1377 VPWR VGND \$1142 \$593 \$321 sg13cmos5l_nand2_1
X$1378 VPWR VGND \$3654 \$2989 \$2007 sg13cmos5l_nand2_1
X$1379 VPWR VGND \$456 \$580 \$354 sg13cmos5l_nand2_1
X$1380 VPWR VGND \$775 \$782 \$805 sg13cmos5l_nand2_1
X$1381 VPWR VGND \$3348 \$2646 \$2877 sg13cmos5l_nand2_1
X$1382 VPWR VGND \$2932 \$3173 \$2653 sg13cmos5l_nand2_1
X$1383 VPWR VGND \$2368 \$2482 \$2106 sg13cmos5l_nand2_1
X$1384 VPWR VGND \$3874 \$3917 \$3173 sg13cmos5l_nand2_1
X$1385 VPWR VGND \$323 \$355 \$321 sg13cmos5l_nand2_1
X$1387 VPWR VGND \$2237 \$2638 \$2234 sg13cmos5l_nand2_1
X$1388 VPWR VGND \$3698 \$2695 \$2877 sg13cmos5l_nand2_1
X$1389 VPWR VGND \$595 \$849 \$961 sg13cmos5l_nand2_1
X$1390 VPWR VGND \$244 \$98 \$247 sg13cmos5l_nand2_1
X$1391 VPWR VGND \$2132 \$2080 \$1665 sg13cmos5l_nand2_1
X$1392 VPWR VGND \$3641 \$3486 \$3523 sg13cmos5l_nand2_1
X$1393 VPWR VGND \$2227 \$1862 \$1826 sg13cmos5l_nand2_1
X$1394 VPWR VGND \$3384 \$3009 \$2877 sg13cmos5l_nand2_1
X$1395 VPWR VGND \$2933 \$2775 \$2877 sg13cmos5l_nand2_1
X$1396 VPWR VGND \$3456 \$2967 \$2877 sg13cmos5l_nand2_1
X$1397 VPWR VGND \$3978 \$3616 \$2517 sg13cmos5l_nand2_1
X$1398 VPWR VGND \$1975 \$1928 \$1776 sg13cmos5l_nand2_1
X$1399 VPWR VGND \$2687 \$2648 \$2592 sg13cmos5l_nand2_1
X$1400 VPWR VGND \$2737 \$3089 \$2055 sg13cmos5l_nand2_1
X$1401 VPWR VGND \$3439 \$2985 \$2877 sg13cmos5l_nand2_1
X$1402 VPWR VGND \$3998 \$3961 \$3065 sg13cmos5l_nand2_1
X$1403 VPWR VGND \$1875 \$1790 \$1665 sg13cmos5l_nand2_1
X$1404 VPWR VGND \$464 \$512 \$462 sg13cmos5l_nand2_1
X$1405 VPWR VGND \$3235 \$2439 \$3085 sg13cmos5l_nand2_1
X$1406 VPWR VGND \$489 \$455 \$491 sg13cmos5l_nand2_1
X$1407 VPWR VGND \$3257 \$2517 \$2581 sg13cmos5l_nand2_1
X$1408 VPWR VGND \$849 \$456 \$455 sg13cmos5l_nand2_1
X$1412 VPWR VGND \$985 \$593 \$457 sg13cmos5l_and2_1
X$1413 VPWR VGND \$328 \$448 \$314 sg13cmos5l_and2_1
X$1414 VPWR VGND \$2701 \$2985 \$2989 sg13cmos5l_and2_1
X$1415 VPWR VGND \$3138 \$3029 \$2055 sg13cmos5l_and2_1
X$1416 VPWR VGND \$2239 \$2477 \$2598 sg13cmos5l_and2_1
X$1417 VPWR VGND \$2959 \$2677 \$2916 sg13cmos5l_and2_1
X$1418 VPWR VGND \$2477 \$1628 \$1667 sg13cmos5l_and2_1
X$1419 VPWR VGND \$613 \$269 \$259 sg13cmos5l_and2_1
X$1420 VPWR VGND \$1562 \$1512 \$1177 sg13cmos5l_and2_1
X$1421 VPWR VGND \$3197 \$2701 \$3121 sg13cmos5l_and2_1
X$1422 VPWR VGND \$4046 \$3935 \$2989 sg13cmos5l_and2_1
X$1423 VPWR VGND \$3391 \$3393 \$3089 sg13cmos5l_and2_1
X$1424 VPWR VGND \$3705 \$2252 \$2700 sg13cmos5l_and2_1
X$1425 VPWR VGND \$2834 \$2973 \$2970 sg13cmos5l_and2_1
X$1426 VPWR VGND \$2871 \$2836 \$2749 sg13cmos5l_and2_1
X$1427 VPWR VGND \$259 \$453 \$88 sg13cmos5l_and2_1
X$1428 VPWR VGND \$462 \$525 \$903 sg13cmos5l_and2_1
X$1429 VPWR VGND \$630 \$25 \$680 sg13cmos5l_and2_1
X$1430 VPWR VGND \$310 \$580 \$354 sg13cmos5l_and2_1
X$1431 VPWR VGND \$966 \$1521 \$1518 sg13cmos5l_and2_1
X$1432 VPWR VGND \$4025 \$3909 \$2646 sg13cmos5l_and2_1
X$1433 VPWR VGND \$2760 \$2695 \$2694 sg13cmos5l_and2_1
X$1434 VPWR VGND \$2347 \$2333 \$2148 sg13cmos5l_and2_1
X$1435 VPWR VGND \$88 \$59 \$30 sg13cmos5l_and2_1
X$1436 VPWR VGND \$30 \$137 \$169 sg13cmos5l_and2_1
X$1437 VPWR VGND \$1334 \$572 \$1142 sg13cmos5l_and2_1
X$1438 VPWR VGND \$1667 \$777 \$966 sg13cmos5l_and2_1
X$1439 VPWR VGND \$1531 \$1422 \$973 sg13cmos5l_and2_1
X$1440 VGND \$2058 VPWR \$2197 \$1996 \$1961 sg13cmos5l_o21ai_1
X$1441 VGND \$2056 VPWR \$2358 \$2418 \$1901 sg13cmos5l_o21ai_1
X$1442 VGND \$3477 VPWR \$2373 \$3597 \$2439 sg13cmos5l_o21ai_1
X$1443 VGND \$3564 VPWR \$3566 \$3562 \$3565 sg13cmos5l_o21ai_1
X$1444 VGND \$530 VPWR \$349 \$595 \$16 sg13cmos5l_o21ai_1
X$1445 VGND \$2963 VPWR \$2962 \$3138 \$2734 sg13cmos5l_o21ai_1
X$1446 VGND \$472 VPWR \$469 \$530 \$529 sg13cmos5l_o21ai_1
X$1447 VGND \$3597 VPWR \$3649 \$3592 \$2554 sg13cmos5l_o21ai_1
X$1448 VGND \$914 VPWR \$137 \$736 \$985 sg13cmos5l_o21ai_1
X$1449 VGND \$3468 VPWR \$3345 \$3634 \$2554 sg13cmos5l_o21ai_1
X$1450 VGND \$1995 VPWR \$2065 \$2058 \$1901 sg13cmos5l_o21ai_1
X$1451 VGND \$3326 VPWR \$2373 \$3390 \$2349 sg13cmos5l_o21ai_1
X$1452 VGND \$2685 VPWR \$2586 \$2738 \$2834 sg13cmos5l_o21ai_1
X$1453 VGND \$20 VPWR \$136 \$169 \$137 sg13cmos5l_o21ai_1
X$1454 VGND \$3465 VPWR \$3348 \$3276 \$3514 sg13cmos5l_o21ai_1
X$1455 VGND \$640 VPWR \$16 \$641 \$706 sg13cmos5l_o21ai_1
X$1456 VGND VPWR \$643 \$698 \$640 \$341 sg13cmos5l_nand3_1
X$1457 VGND \$2647 VPWR \$2588 \$2586 \$2585 sg13cmos5l_o21ai_1
X$1458 VGND \$3390 VPWR \$3392 \$3457 \$2554 sg13cmos5l_o21ai_1
X$1459 VGND \$2698 VPWR \$2693 \$2837 \$2840 sg13cmos5l_o21ai_1
X$1460 VGND \$2262 VPWR \$2082 \$2259 \$2261 sg13cmos5l_o21ai_1
X$1461 VGND \$2484 VPWR \$2482 \$2481 \$2477 sg13cmos5l_o21ai_1
X$1462 VGND \$1911 VPWR \$1875 \$1956 \$1901 sg13cmos5l_o21ai_1
X$1463 VGND \$3562 VPWR \$3708 \$2768 \$3773 sg13cmos5l_o21ai_1
X$1464 VGND \$3502 VPWR \$2373 \$3621 \$2349 sg13cmos5l_o21ai_1
X$1465 VGND \$3483 VPWR \$2481 \$3362 \$3197 sg13cmos5l_o21ai_1
X$1466 VGND \$777 VPWR \$837 \$542 \$645 sg13cmos5l_o21ai_1
X$1467 VGND \$3649 VPWR \$2943 \$3533 \$2241 sg13cmos5l_o21ai_1
X$1468 VGND \$1697 VPWR \$1535 \$1543 \$1777 sg13cmos5l_o21ai_1
X$1469 VGND \$2097 VPWR \$2098 \$1531 \$836 sg13cmos5l_o21ai_1
X$1470 VGND \$2816 VPWR \$2933 \$3015 \$3132 sg13cmos5l_o21ai_1
X$1471 VGND \$3923 VPWR \$4023 \$3741 \$4025 sg13cmos5l_o21ai_1
X$1472 VGND \$3000 VPWR \$2477 \$2880 \$2889 sg13cmos5l_o21ai_1
X$1473 VGND \$2055 VPWR \$1902 \$491 \$290 sg13cmos5l_o21ai_1
X$1474 VGND \$2131 VPWR \$2132 \$2133 \$1720 sg13cmos5l_o21ai_1
X$1475 VGND \$3345 VPWR \$2857 \$3420 \$2241 sg13cmos5l_o21ai_1
X$1476 VGND \$3569 VPWR \$3978 \$3675 \$2451 sg13cmos5l_o21ai_1
X$1477 VGND \$3132 VPWR \$2373 \$2953 \$2349 sg13cmos5l_o21ai_1
X$1478 VGND \$2045 VPWR \$2049 \$491 \$290 sg13cmos5l_o21ai_1
X$1479 VGND \$1652 VPWR \$580 \$836 \$1465 sg13cmos5l_o21ai_1
X$1480 VGND \$3064 VPWR \$3065 \$2875 \$2760 sg13cmos5l_o21ai_1
X$1481 VGND \$3575 VPWR \$2857 \$3576 \$2241 sg13cmos5l_o21ai_1
X$1482 VGND \$1642 VPWR \$1561 \$1562 \$1558 sg13cmos5l_o21ai_1
X$1483 VGND \$3392 VPWR \$2857 \$3334 \$2241 sg13cmos5l_o21ai_1
X$1484 VGND \$4123 VPWR \$3740 \$3572 \$3739 sg13cmos5l_o21ai_1
X$1485 VGND \$916 VPWR \$572 \$836 \$456 sg13cmos5l_o21ai_1
X$1486 VGND \$3844 VPWR \$3698 \$3758 \$3299 sg13cmos5l_o21ai_1
X$1487 VGND \$3524 VPWR \$2481 \$3349 \$3121 sg13cmos5l_o21ai_1
X$1488 VGND \$3021 VPWR \$2857 \$2820 \$2241 sg13cmos5l_o21ai_1
X$1489 VGND \$1518 VPWR \$782 \$1362 \$1334 sg13cmos5l_o21ai_1
X$1490 VGND \$3500 VPWR \$3456 \$2960 \$3502 sg13cmos5l_o21ai_1
X$1491 VGND \$776 VPWR \$918 \$919 \$62 sg13cmos5l_o21ai_1
X$1492 VGND \$1638 VPWR \$1756 \$1810 \$1720 sg13cmos5l_o21ai_1
X$1493 VGND \$847 VPWR \$818 \$848 \$685 sg13cmos5l_o21ai_1
X$1494 VGND \$2289 VPWR \$1773 \$2104 \$1776 sg13cmos5l_o21ai_1
X$1495 VGND \$878 VPWR \$723 \$941 \$491 sg13cmos5l_o21ai_1
X$1496 VGND \$4044 VPWR \$3998 \$4000 \$4127 sg13cmos5l_o21ai_1
X$1497 VGND \$3242 VPWR \$3384 \$3250 \$3326 sg13cmos5l_o21ai_1
X$1498 VGND \$1782 VPWR \$1942 \$1905 \$1901 sg13cmos5l_o21ai_1
X$1499 VGND \$253 VPWR \$187 \$304 \$278 sg13cmos5l_o21ai_1
X$1500 VGND \$859 VPWR \$966 \$857 \$551 sg13cmos5l_o21ai_1
X$1501 VGND \$3975 VPWR \$3089 \$2727 \$2517 sg13cmos5l_o21ai_1
X$1502 VGND \$3830 VPWR \$3829 \$3637 \$2976 sg13cmos5l_o21ai_1
X$1503 VGND \$3700 VPWR \$3654 \$3307 \$3599 sg13cmos5l_o21ai_1
X$1504 VGND \$3523 VPWR \$2695 \$3522 \$3173 sg13cmos5l_o21ai_1
X$1505 VGND \$1207 VPWR \$1067 \$760 \$1044 sg13cmos5l_o21ai_1
X$1506 VGND \$2225 VPWR \$2227 \$1825 \$1975 sg13cmos5l_o21ai_1
X$1507 VGND \$306 VPWR \$295 \$304 \$278 sg13cmos5l_o21ai_1
X$1508 VGND \$1107 VPWR \$62 \$919 \$736 sg13cmos5l_o21ai_1
X$1509 VGND \$1358 VPWR \$916 \$776 \$761 sg13cmos5l_o21ai_1
X$1510 VGND \$3647 VPWR \$3439 \$3477 \$3300 sg13cmos5l_o21ai_1
X$1511 VGND \$3637 VPWR \$2373 \$3468 \$2349 sg13cmos5l_o21ai_1
X$1512 VGND \$852 VPWR \$850 \$847 \$819 sg13cmos5l_o21ai_1
X$1513 VGND \$3276 VPWR \$2373 \$2739 \$2936 sg13cmos5l_o21ai_1
X$1514 VGND \$861 VPWR \$860 \$613 \$650 sg13cmos5l_o21ai_1
X$1515 VGND \$2953 VPWR \$3021 \$2554 \$2727 sg13cmos5l_o21ai_1
X$1516 VGND \$3621 VPWR \$3575 \$3574 \$2554 sg13cmos5l_o21ai_1
X$1957 VPWR VGND \$2875 \$3113 \$2760 \$2985 sg13cmos5l_nor3_1
X$1958 VPWR VGND \$1562 \$1565 \$1536 \$51 sg13cmos5l_nor3_1
X$1959 VPWR VGND \$3572 \$3741 \$3740 \$3739 sg13cmos5l_nor3_1
X$1960 VPWR VGND \$2104 \$2232 \$1776 \$1773 sg13cmos5l_nor3_1
X$1961 VPWR VGND \$1305 \$1362 \$917 \$1107 sg13cmos5l_nor3_1
X$1962 VPWR VGND \$1177 \$1074 \$1075 \$51 sg13cmos5l_nor3_1
X$1963 VPWR VGND \$684 \$819 \$696 \$735 sg13cmos5l_nor3_1
X$1964 VPWR VGND \$259 \$114 \$274 \$12 sg13cmos5l_nor3_1
X$1965 VPWR VGND \$736 \$909 \$985 \$137 sg13cmos5l_nor3_1
X$1966 VPWR VGND \$1531 \$1777 \$836 \$290 sg13cmos5l_nor3_1
X$1967 VPWR VGND \$613 \$449 \$535 \$12 sg13cmos5l_nor3_1
X$1968 VPWR VGND \$2727 \$3686 \$3089 \$2517 sg13cmos5l_nor3_1
X$1969 VPWR VGND \$1952 \$2300 \$1901 \$2054 sg13cmos5l_nor3_1
X$1970 VPWR VGND \$27 \$227 \$98 \$12 sg13cmos5l_nor3_1
X$1971 VGND \$244 VPWR \$304 \$338 \$303 \$14 \$234 sg13cmos5l_a221oi_1
X$1972 VPWR VGND \$3368 \$3610 \$3609 \$2439 sg13cmos5l_nor3_1
X$1973 VPWR VGND \$169 \$179 \$121 \$12 sg13cmos5l_nor3_1
X$1974 VPWR VGND \$313 \$440 \$310 \$137 sg13cmos5l_nor3_1
X$1975 \$75 \$314 \$313 VPWR VGND sg13cmos5l_or2_1
X$1976 VPWR VGND \$4023 \$4026 \$3741 \$4025 sg13cmos5l_nor3_1
X$1977 VPWR VGND \$60 \$193 \$119 \$12 sg13cmos5l_nor3_1
X$1978 VPWR VGND \$354 \$641 \$525 \$251 sg13cmos5l_nor3_1
X$1979 VPWR VGND \$919 \$1071 \$1068 \$62 sg13cmos5l_nor3_1
X$1980 VPWR VGND \$1004 \$1142 \$572 sg13cmos5l_xnor2_1
X$1981 VPWR VGND \$2104 \$2152 \$1704 \$1980 sg13cmos5l_nor3_1
X$1982 VPWR VGND \$2437 \$2441 \$2439 \$2261 sg13cmos5l_and3_1
X$1983 VPWR VGND \$2301 \$2115 \$1789 \$1996 sg13cmos5l_and3_1
X$1984 VPWR VGND \$580 \$354 \$903 \$632 sg13cmos5l_and3_1
X$1985 VPWR VGND \$580 \$1531 \$1050 \$1543 sg13cmos5l_and3_1
X$1986 VPWR VGND \$952 \$613 \$572 \$1177 sg13cmos5l_and3_1
X$1987 VPWR VGND \$2889 \$2880 \$2477 \$2441 sg13cmos5l_and3_1
X$1988 VPWR VGND \$3874 \$3924 \$3923 \$3994 sg13cmos5l_and3_1
X$1989 VPWR VGND \$1961 \$1996 \$2069 \$1952 sg13cmos5l_and3_1
X$1990 VPWR VGND \$2789 \$2837 sg13cmos5l_inv_1
X$1991 VPWR VGND \$759 \$760 sg13cmos5l_inv_1
X$1992 VPWR VGND \$1431 \$1465 sg13cmos5l_inv_1
X$1993 VPWR VGND \$2768 \$2889 sg13cmos5l_inv_1
X$1994 VPWR VGND \$1776 \$1704 sg13cmos5l_inv_1
X$1995 VPWR VGND \$405 \$356 sg13cmos5l_inv_1
X$1996 VPWR VGND \$397 \$399 sg13cmos5l_inv_1
X$1997 VPWR VGND \$2928 \$2926 sg13cmos5l_inv_1
X$1998 VPWR VGND \$156 \$393 sg13cmos5l_inv_1
X$1999 VPWR VGND \$52 \$363 sg13cmos5l_inv_1
X$2000 VPWR VGND \$1701 \$1609 sg13cmos5l_inv_1
X$2001 VPWR VGND \$1710 \$1611 sg13cmos5l_inv_1
X$2002 VPWR VGND \$934 \$1671 sg13cmos5l_inv_1
X$2003 VPWR VGND \$16 \$685 sg13cmos5l_inv_1
X$2004 VPWR VGND \$861 \$887 sg13cmos5l_inv_1
X$2005 VPWR VGND \$355 \$401 sg13cmos5l_inv_1
X$2006 VPWR VGND \$872 \$1541 sg13cmos5l_inv_1
X$2007 VPWR VGND \$67 \$82 sg13cmos5l_inv_1
X$2008 VPWR VGND \$1726 \$1812 sg13cmos5l_inv_1
X$2009 VPWR VGND \$1871 \$2049 sg13cmos5l_inv_1
X$2010 VPWR VGND \$103 \$403 sg13cmos5l_inv_1
X$2011 VPWR VGND \$1826 \$1980 sg13cmos5l_inv_1
X$2012 VPWR VGND \$3089 \$3029 sg13cmos5l_inv_1
X$2013 VPWR VGND \$450 \$451 sg13cmos5l_inv_1
X$2014 VPWR VGND \$50 \$163 sg13cmos5l_inv_1
X$2015 VPWR VGND \$252 \$422 sg13cmos5l_inv_1
X$2016 VPWR VGND \$1884 \$1715 sg13cmos5l_inv_1
X$2017 VPWR VGND \$2148 \$2233 sg13cmos5l_inv_1
X$2018 VPWR VGND \$191 \$189 sg13cmos5l_inv_1
X$2019 VPWR VGND \$1912 \$2128 sg13cmos5l_inv_1
X$2020 VPWR VGND \$2437 \$2323 sg13cmos5l_inv_1
X$2021 VPWR VGND \$3173 \$3283 sg13cmos5l_inv_1
X$2022 VPWR VGND \$2517 \$2457 sg13cmos5l_inv_1
X$2023 VPWR VGND \$1128 \$1677 sg13cmos5l_inv_1
X$2024 \$850 VGND \$848 VPWR \$685 \$909 sg13cmos5l_a21oi_1
X$2025 \$494 VGND \$358 VPWR \$323 \$456 sg13cmos5l_a21oi_1
X$2026 \$2130 VGND \$1667 VPWR \$1628 \$2128 sg13cmos5l_a21oi_1
X$2027 \$2204 VGND \$1804 VPWR \$2003 \$2130 sg13cmos5l_a21oi_1
X$2028 \$2172 VGND \$2104 VPWR \$1704 \$1898 sg13cmos5l_a21oi_1
X$2029 \$2451 VGND \$2338 VPWR \$2225 \$2347 sg13cmos5l_a21oi_1
X$2030 \$2820 VGND \$2570 VPWR \$1987 \$2778 sg13cmos5l_a21oi_1
X$2031 \$761 VGND \$677 VPWR \$615 \$645 sg13cmos5l_a21oi_1
X$2032 \$860 VGND \$613 VPWR \$650 \$51 sg13cmos5l_a21oi_1
X$2033 \$959 VGND \$613 VPWR \$572 \$952 sg13cmos5l_a21oi_1
X$2034 \$2875 VGND \$2836 VPWR \$2932 \$2789 sg13cmos5l_a21oi_1
X$2035 \$3268 VGND \$2500 VPWR \$3257 \$3029 sg13cmos5l_a21oi_1
X$2036 \$2840 VGND \$2689 VPWR \$2647 \$3108 sg13cmos5l_a21oi_1
X$2037 \$805 VGND \$849 VPWR \$1005 \$1181 sg13cmos5l_a21oi_1
X$2038 \$2207 VGND \$2094 VPWR \$1810 \$1566 sg13cmos5l_a21oi_1
X$2039 \$4127 VGND \$2695 VPWR \$3922 \$4029 sg13cmos5l_a21oi_1
X$2040 \$1305 VGND \$698 VPWR \$1142 \$572 sg13cmos5l_a21oi_1
X$2041 \$2313 VGND \$1996 VPWR \$1881 \$2069 sg13cmos5l_a21oi_1
X$2042 \$2951 VGND \$3197 VPWR \$2988 \$2323 sg13cmos5l_a21oi_1
X$2043 \$74 VGND \$27 VPWR \$25 \$52 sg13cmos5l_a21oi_1
X$2044 \$2465 VGND \$2581 VPWR \$2517 \$2172 sg13cmos5l_a21oi_1
X$2045 \$1561 VGND \$1562 VPWR \$1558 \$51 sg13cmos5l_a21oi_1
X$2046 \$1617 VGND \$1557 VPWR \$1535 \$1620 sg13cmos5l_a21oi_1
X$2047 \$2254 VGND \$1667 VPWR \$1628 \$2660 sg13cmos5l_a21oi_1
X$2048 \$696 VGND \$252 VPWR \$698 \$52 sg13cmos5l_a21oi_1
X$2049 \$3362 VGND \$3121 VPWR \$2985 \$3364 sg13cmos5l_a21oi_1
X$2050 \$2879 VGND \$2880 VPWR \$2886 \$2943 sg13cmos5l_a21oi_1
X$2051 \$1044 VGND \$852 VPWR \$914 \$829 sg13cmos5l_a21oi_1
X$2052 \$918 VGND \$919 VPWR \$62 \$1004 sg13cmos5l_a21oi_1
X$2053 \$4029 VGND \$3923 VPWR \$3874 \$3924 sg13cmos5l_a21oi_1
X$2054 \$3438 VGND \$3606 VPWR \$2768 \$3705 sg13cmos5l_a21oi_1
X$2055 \$3609 VGND \$3448 VPWR \$2481 \$2477 sg13cmos5l_a21oi_1
X$2056 \$2331 VGND \$2088 VPWR \$2133 \$2007 sg13cmos5l_a21oi_1
X$2057 \$303 VGND \$247 VPWR \$163 \$82 sg13cmos5l_a21oi_1
X$2058 \$2475 VGND \$2115 VPWR \$1789 \$2301 sg13cmos5l_a21oi_1
X$2059 \$2738 VGND \$2677 VPWR \$2737 \$2736 sg13cmos5l_a21oi_1
X$2060 \$2036 VGND \$736 VPWR \$1776 \$1826 sg13cmos5l_a21oi_1
X$2061 \$551 VGND \$328 VPWR \$472 \$451 sg13cmos5l_a21oi_1
X$2062 \$1580 VGND \$882 VPWR \$1110 \$1531 sg13cmos5l_a21oi_1
X$2063 \$2585 VGND \$2736 VPWR \$2963 \$2926 sg13cmos5l_a21oi_1
X$2064 \$1979 VGND \$2096 VPWR \$2094 \$2007 sg13cmos5l_a21oi_1
X$2065 \$708 VGND \$455 VPWR \$456 \$632 sg13cmos5l_a21oi_1
X$2066 \$2119 VGND \$2424 VPWR \$1901 \$2362 sg13cmos5l_a21oi_1
X$2067 \$3824 VGND \$3570 VPWR \$3569 \$3391 sg13cmos5l_a21oi_1
X$2068 \$898 VGND \$936 VPWR \$593 \$641 sg13cmos5l_a21oi_1
X$2069 VPWR VGND \$2036 \$2152 \$2096 sg13cmos5l_nor2_1
X$2070 VPWR VGND \$736 \$916 \$917 sg13cmos5l_nor2_1
X$2071 VPWR VGND \$456 \$525 \$234 sg13cmos5l_nor2_1
X$2072 VPWR VGND \$2653 \$3283 \$3108 sg13cmos5l_nor2_1
X$2073 VPWR VGND \$48 \$341 \$257 sg13cmos5l_nor2_1
X$2074 VPWR VGND \$1987 \$2457 \$2778 sg13cmos5l_nor2_1
X$2075 VPWR VGND \$313 \$310 \$48 sg13cmos5l_nor2_1
X$2076 VPWR VGND \$2973 \$3617 \$3739 sg13cmos5l_nor2_1
X$2077 VPWR VGND \$20 \$30 \$18 sg13cmos5l_nor2_1
X$2078 VPWR VGND \$990 \$964 \$936 sg13cmos5l_nor2_1
X$2079 VPWR VGND \$2743 \$2477 \$2740 sg13cmos5l_nor2_1
X$2080 VPWR VGND \$2738 \$2834 \$2742 sg13cmos5l_nor2_1
X$2081 VPWR VGND \$4029 \$3994 \$3995 sg13cmos5l_nor2_1
X$2082 VPWR VGND \$2114 \$1952 \$1956 sg13cmos5l_nor2_1
X$2083 VPWR VGND \$2581 \$2495 \$2468 sg13cmos5l_nor2_1
X$2084 VPWR VGND \$491 \$290 \$1068 sg13cmos5l_nor2_1
X$2085 VPWR VGND \$775 \$776 \$837 sg13cmos5l_nor2_1
X$2086 VPWR VGND \$3610 \$2007 \$3454 sg13cmos5l_nor2_1
X$2087 VPWR VGND \$536 \$137 \$473 sg13cmos5l_nor2_1
X$2088 VPWR VGND \$259 \$269 \$535 sg13cmos5l_nor2_1
X$2089 VPWR VGND \$2988 \$2252 \$2886 sg13cmos5l_nor2_1
X$2090 VPWR VGND \$1580 \$1566 \$1535 sg13cmos5l_nor2_1
X$2091 VPWR VGND \$836 \$456 \$706 sg13cmos5l_nor2_1
X$2092 VPWR VGND \$859 \$777 \$882 sg13cmos5l_nor2_1
X$2093 VPWR VGND \$195 \$15 \$238 sg13cmos5l_nor2_1
X$2094 VPWR VGND \$1068 \$136 \$1110 sg13cmos5l_nor2_1
X$2095 VPWR VGND \$3438 \$2943 \$3368 sg13cmos5l_nor2_1
X$2096 VPWR VGND \$313 \$136 \$973 sg13cmos5l_nor2_1
X$2097 VPWR VGND \$2373 \$2889 \$3374 sg13cmos5l_nor2_1
X$2098 VPWR VGND \$1177 \$1512 \$1450 sg13cmos5l_nor2_1
X$2099 VPWR VGND \$3488 \$2252 \$3565 sg13cmos5l_nor2_1
X$2100 VPWR VGND \$88 \$453 \$274 sg13cmos5l_nor2_1
X$2101 VPWR VGND \$1869 \$1952 \$1905 sg13cmos5l_nor2_1
X$2102 VPWR VGND \$494 \$722 \$723 sg13cmos5l_nor2_1
X$2103 VPWR VGND \$3469 \$2695 \$3349 sg13cmos5l_nor2_1
X$2104 VPWR VGND \$3065 \$3961 \$4000 sg13cmos5l_nor2_1
X$2105 VPWR VGND \$641 \$706 \$639 sg13cmos5l_nor2_1
X$2106 VPWR VGND \$2475 \$1996 \$2473 sg13cmos5l_nor2_1
X$2107 VPWR VGND \$30 \$59 \$68 sg13cmos5l_nor2_1
X$2108 VPWR VGND \$2951 \$2477 \$2706 sg13cmos5l_nor2_1
X$2109 VPWR VGND \$618 \$450 \$645 sg13cmos5l_nor2_1
X$2110 VPWR VGND \$1535 \$964 \$1620 sg13cmos5l_nor2_1
X$2111 VPWR VGND \$3486 \$3065 \$3485 sg13cmos5l_nor2_1
X$2112 VPWR VGND \$708 \$452 \$618 sg13cmos5l_nor2_1
X$2113 VPWR VGND \$474 \$473 \$615 sg13cmos5l_nor2_1
X$2114 VPWR VGND \$163 \$82 \$27 sg13cmos5l_nor2_1
X$2115 VPWR VGND \$2473 \$1952 \$2418 sg13cmos5l_nor2_1
X$2116 VPWR VGND \$827 \$17 \$829 sg13cmos5l_nor2_1
X$2117 VPWR VGND \$680 \$25 \$684 sg13cmos5l_nor2_1
X$2118 VPWR VGND \$3464 \$3283 \$3469 sg13cmos5l_nor2_1
X$2119 VPWR VGND \$48 \$16 \$49 sg13cmos5l_nor2_1
X$2120 VPWR VGND \$60 \$70 \$61 sg13cmos5l_nor2_1
X$2121 VPWR VGND \$50 \$67 \$98 sg13cmos5l_nor2_1
X$2122 VPWR VGND \$234 \$25 \$278 sg13cmos5l_nor2_1
X$2123 VPWR VGND \$489 \$452 \$892 sg13cmos5l_nor2_1
X$2124 VPWR VGND \$238 \$49 \$194 sg13cmos5l_nor2_1
X$2125 VPWR VGND sg13cmos5l_decap_8
X$2126 VPWR VGND sg13cmos5l_decap_8
X$2127 VPWR VGND sg13cmos5l_decap_8
X$2128 VPWR VGND sg13cmos5l_decap_8
X$2129 VPWR VGND sg13cmos5l_decap_8
X$2130 VPWR VGND sg13cmos5l_decap_8
X$2131 VPWR VGND sg13cmos5l_decap_8
X$2132 VPWR VGND sg13cmos5l_decap_8
X$2133 VPWR VGND sg13cmos5l_decap_8
X$2134 VPWR VGND sg13cmos5l_decap_8
X$2135 VPWR VGND sg13cmos5l_decap_8
X$2136 VPWR VGND sg13cmos5l_decap_8
X$2137 VPWR VGND sg13cmos5l_decap_8
X$2138 VPWR VGND sg13cmos5l_decap_8
X$2139 VPWR VGND sg13cmos5l_decap_8
X$2140 VPWR VGND sg13cmos5l_decap_8
X$2141 VPWR VGND sg13cmos5l_decap_8
X$2142 VPWR VGND sg13cmos5l_decap_8
X$2143 VPWR VGND sg13cmos5l_decap_8
X$2144 VPWR VGND sg13cmos5l_decap_8
X$2145 VPWR VGND sg13cmos5l_decap_8
X$2146 VPWR VGND sg13cmos5l_decap_8
X$2147 VPWR VGND sg13cmos5l_decap_8
X$2148 VPWR VGND sg13cmos5l_decap_8
X$2149 VPWR VGND sg13cmos5l_decap_8
X$2150 VPWR VGND sg13cmos5l_decap_8
X$2151 VPWR VGND sg13cmos5l_decap_8
X$2152 VPWR VGND sg13cmos5l_decap_8
X$2153 VPWR VGND sg13cmos5l_decap_8
X$2154 VPWR VGND sg13cmos5l_decap_8
X$2155 VPWR VGND sg13cmos5l_decap_8
X$2156 VPWR VGND sg13cmos5l_decap_8
X$2157 VPWR VGND sg13cmos5l_decap_8
X$2158 VPWR VGND sg13cmos5l_decap_8
X$2159 VPWR VGND sg13cmos5l_decap_8
X$2160 VPWR VGND sg13cmos5l_decap_8
X$2161 VPWR VGND sg13cmos5l_decap_8
X$2162 VPWR VGND sg13cmos5l_decap_8
X$2163 VPWR VGND sg13cmos5l_decap_8
X$2164 VPWR VGND sg13cmos5l_decap_8
X$2165 VPWR VGND sg13cmos5l_decap_8
X$2166 VPWR VGND sg13cmos5l_decap_8
X$2167 VPWR VGND sg13cmos5l_decap_8
X$2168 VPWR VGND sg13cmos5l_decap_8
X$2169 VPWR VGND sg13cmos5l_decap_8
X$2170 VPWR VGND sg13cmos5l_decap_8
X$2171 VGND \$620 \$87 VPWR sg13cmos5l_buf_8
X$2172 VPWR VGND sg13cmos5l_decap_8
X$2173 VPWR VGND sg13cmos5l_decap_8
X$2174 VPWR VGND sg13cmos5l_decap_8
X$2175 VPWR VGND \$474 \$473 \$284 \$440 \$542 sg13cmos5l_nor4_1
X$2176 VPWR VGND \$474 \$448 \$450 \$618 sg13cmos5l_nand3b_1
X$2177 VPWR VGND sg13cmos5l_decap_8
X$2178 VPWR VGND sg13cmos5l_decap_8
X$2179 VPWR VGND sg13cmos5l_decap_8
X$2180 VPWR VGND sg13cmos5l_decap_8
X$2181 VPWR VGND sg13cmos5l_decap_8
X$2182 VPWR VGND sg13cmos5l_decap_8
X$2183 VPWR VGND sg13cmos5l_decap_8
X$2184 VPWR VGND sg13cmos5l_decap_8
X$2185 VPWR VGND sg13cmos5l_decap_8
X$2186 VPWR VGND sg13cmos5l_decap_8
X$2187 VPWR VGND sg13cmos5l_decap_8
X$2188 VPWR VGND sg13cmos5l_decap_8
X$2189 VPWR VGND sg13cmos5l_decap_8
X$2190 VPWR VGND sg13cmos5l_decap_8
X$2191 VPWR VGND sg13cmos5l_decap_8
X$2192 VPWR VGND sg13cmos5l_decap_8
X$7116 VPWR VGND \$677 \$643 \$306 \$562 sg13cmos5l_a21o_1
X$7260 VGND \$3796 \$3436 \$3647 \$1970 VPWR sg13cmos5l_dfrbpq_1
X$7261 VGND \$45 \$355 \$401 \$103 VPWR sg13cmos5l_dfrbpq_1
X$7262 VGND \$1716 \$1720 \$1960 \$1176 VPWR sg13cmos5l_dfrbpq_1
X$7263 VGND \$1573 \$1443 \$1662 \$1176 VPWR sg13cmos5l_dfrbpq_1
X$7264 VGND \$3796 \$2755 \$3844 \$3539 VPWR sg13cmos5l_dfrbpq_1
X$7265 VGND \$3615 \$3828 \$3983 \$3510 VPWR sg13cmos5l_dfrbpq_1
X$7266 VGND \$3615 \$3791 \$3986 \$3510 VPWR sg13cmos5l_dfrbpq_1
X$7267 VGND \$3796 \$3364 \$3700 \$3539 VPWR sg13cmos5l_dfrbpq_1
X$7268 VGND \$1480 \$1261 \$1611 \$1435 VPWR sg13cmos5l_dfrbpq_1
X$7269 VGND \$1480 \$1128 \$1677 \$1431 VPWR sg13cmos5l_dfrbpq_1
X$7270 VGND \$1480 \$1431 \$1465 \$655 VPWR sg13cmos5l_dfrbpq_1
X$7271 VGND \$1475 \$1773 \$1892 \$1572 VPWR sg13cmos5l_dfrbpq_1
X$7272 VGND \$1573 \$1325 \$1617 \$1572 VPWR sg13cmos5l_dfrbpq_1
X$7273 VGND \$128 \$14 \$189 \$80 VPWR sg13cmos5l_dfrbpq_1
X$7275 VPWR VGND \$52 \$27 \$25 \$60 sg13cmos5l_and3_1
X$7276 VGND \$191 VPWR \$46 \$27 \$25 sg13cmos5l_o21ai_1
X$7277 VGND \$44 \$17 \$116 \$87 VPWR sg13cmos5l_dfrbpq_1
X$7278 VPWR VGND \$88 \$116 \$117 \$12 sg13cmos5l_nor3_1
X$7279 VGND \$128 \$106 \$268 \$80 VPWR sg13cmos5l_dfrbpq_1
X$7280 VGND \$1716 \$1447 \$1812 \$1176 VPWR sg13cmos5l_dfrbpq_1
X$7281 VGND \$3322 \$3088 \$3500 \$2086 VPWR sg13cmos5l_dfrbpq_1
X$7282 VGND \$45 \$625 \$878 \$80 VPWR sg13cmos5l_dfrbpq_1
X$7283 VGND \$1716 \$1789 \$1739 \$1572 VPWR sg13cmos5l_dfrbpq_1
X$7284 VGND \$1716 \$2250 \$1907 \$1970 VPWR sg13cmos5l_dfrbpq_1
X$7285 VGND \$1716 \$1912 \$1883 \$1970 VPWR sg13cmos5l_dfrbpq_1
X$7286 VGND \$1475 \$1902 \$1784 \$1572 VPWR sg13cmos5l_dfrbpq_1
X$7287 VGND \$3615 \$3971 \$3778 \$3510 VPWR sg13cmos5l_dfrbpq_1
X$7288 VGND \$128 \$409 \$500 \$80 VPWR sg13cmos5l_dfrbpq_1
X$7289 \$509 VGND VPWR \$247 \$310 \$457 \$98 sg13cmos5l_a22oi_1
X$7290 VGND \$2248 \$2702 \$2436 \$1970 VPWR sg13cmos5l_dfrbpq_1
X$7291 VGND \$44 \$75 \$18 \$87 VPWR sg13cmos5l_dfrbpq_1
X$7292 VGND \$2310 \$2555 \$2312 \$1970 VPWR sg13cmos5l_dfrbpq_1
X$7293 VGND \$3796 \$3961 \$3846 \$3539 VPWR sg13cmos5l_dfrbpq_1
X$7294 VGND \$3796 \$3935 \$3850 \$3539 VPWR sg13cmos5l_dfrbpq_1
X$7295 VGND \$1475 \$1889 \$1769 \$1572 VPWR sg13cmos5l_dfrbpq_1
X$7296 VGND \$1716 \$1881 \$1793 \$1176 VPWR sg13cmos5l_dfrbpq_1
X$7297 VGND \$3615 \$2648 \$3465 \$3510 VPWR sg13cmos5l_dfrbpq_1
X$7298 VGND \$2248 \$1871 \$2244 \$2086 VPWR sg13cmos5l_dfrbpq_1
X$7299 VGND \$1475 \$872 \$1541 \$934 VPWR sg13cmos5l_dfrbpq_1
X$7300 VGND \$1475 \$1294 \$1899 \$1572 VPWR sg13cmos5l_dfrbpq_1
X$7301 VGND \$3615 \$3217 \$3830 \$3510 VPWR sg13cmos5l_dfrbpq_1
X$7302 VGND \$211 \$1005 \$1335 \$1176 VPWR sg13cmos5l_dfrbpq_1
X$7303 VGND \$3322 \$2988 \$3452 \$1970 VPWR sg13cmos5l_dfrbpq_1
X$7304 VGND \$2248 \$2495 \$2816 \$2086 VPWR sg13cmos5l_dfrbpq_1
X$7305 VGND \$128 \$103 \$403 \$156 VPWR sg13cmos5l_dfrbpq_1
X$7306 VGND \$45 \$405 \$356 \$355 VPWR sg13cmos5l_dfrbpq_1
X$7307 VGND \$1475 \$934 \$1671 \$1128 VPWR sg13cmos5l_dfrbpq_1
X$7308 VGND \$3796 \$3838 \$3995 \$3539 VPWR sg13cmos5l_dfrbpq_1
X$7309 VGND \$1475 \$1315 \$1609 \$484 VPWR sg13cmos5l_dfrbpq_1
X$7310 VGND \$3615 \$3321 \$3672 \$2086 VPWR sg13cmos5l_dfrbpq_1
X$7311 VGND \$2248 \$2691 \$3242 \$2086 VPWR sg13cmos5l_dfrbpq_1
X$7312 VGND \$3796 \$3611 \$3857 \$3539 VPWR sg13cmos5l_dfrbpq_1
X$7313 VGND \$1573 \$1181 \$1588 \$1176 VPWR sg13cmos5l_dfrbpq_1
X$7314 VGND \$45 \$9 \$227 \$80 VPWR sg13cmos5l_dfrbpq_1
X$7315 VGND \$44 \$16 \$179 \$87 VPWR sg13cmos5l_dfrbpq_1
X$7316 VGND \$45 \$97 \$96 \$397 VPWR sg13cmos5l_dfrbpq_1
X$7317 VGND \$44 \$62 \$449 \$87 VPWR sg13cmos5l_dfrbpq_1
X$7318 VGND \$3796 \$3804 \$3964 \$3539 VPWR sg13cmos5l_dfrbpq_1
X$7319 VGND \$1480 \$767 \$1546 \$80 VPWR sg13cmos5l_dfrbpq_1
X$7320 VGND \$44 \$15 \$193 \$87 VPWR sg13cmos5l_dfrbpq_1
X$7321 VPWR VGND \$169 \$70 \$60 sg13cmos5l_and2_1
X$7322 VGND \$211 \$572 \$887 \$87 VPWR sg13cmos5l_dfrbpq_1
X$7323 VGND \$1716 \$1370 \$1715 \$368 VPWR sg13cmos5l_dfrbpq_1
X$7324 VGND \$2248 \$1918 \$2262 \$1970 VPWR sg13cmos5l_dfrbpq_1
X$7325 VGND \$2248 \$1924 \$2222 \$2086 VPWR sg13cmos5l_dfrbpq_1
X$7326 VGND \$45 \$397 \$399 \$872 VPWR sg13cmos5l_dfrbpq_1
X$7327 VGND \$1716 \$1748 \$1725 \$1176 VPWR sg13cmos5l_dfrbpq_1
X$7328 VGND \$2248 \$2498 \$2449 \$2086 VPWR sg13cmos5l_dfrbpq_1
X$7329 VGND \$3615 \$3896 \$3787 \$3510 VPWR sg13cmos5l_dfrbpq_1
X$7330 VGND \$45 \$156 \$393 \$97 VPWR sg13cmos5l_dfrbpq_1
X$7331 VGND \$44 \$452 \$114 \$87 VPWR sg13cmos5l_dfrbpq_1
X$7332 VGND \$3615 \$3868 \$3781 \$3510 VPWR sg13cmos5l_dfrbpq_1
X$7333 VGND \$1475 \$1925 \$1771 \$1572 VPWR sg13cmos5l_dfrbpq_1
X$7334 VPWR VGND \$2069 \$2555 sg13cmos5l_dlygate4sd3_1
X$7335 VPWR VGND \$1883 \$2131 sg13cmos5l_dlygate4sd3_1
X$7336 VPWR VGND \$1793 \$1995 sg13cmos5l_dlygate4sd3_1
X$7337 VPWR VGND \$1769 \$1932 sg13cmos5l_dlygate4sd3_1
X$7338 VPWR VGND \$50 \$83 sg13cmos5l_dlygate4sd3_1
X$7339 VPWR VGND \$894 \$1325 sg13cmos5l_dlygate4sd3_1
X$7340 VPWR VGND \$1784 \$1782 sg13cmos5l_dlygate4sd3_1
X$7341 VPWR VGND \$1037 \$1443 sg13cmos5l_dlygate4sd3_1
X$7342 VPWR VGND \$500 \$625 sg13cmos5l_dlygate4sd3_1
X$7343 VPWR VGND \$1075 \$959 sg13cmos5l_dlygate4sd3_1
X$7344 VPWR VGND \$3846 \$4002 sg13cmos5l_dlygate4sd3_1
X$7345 VPWR VGND \$4038 \$4127 sg13cmos5l_dlygate4sd3_1
X$7346 VPWR VGND \$1873 \$1902 sg13cmos5l_dlygate4sd3_1
X$7347 VPWR VGND \$1907 \$2056 sg13cmos5l_dlygate4sd3_1
X$7348 VPWR VGND \$1739 \$1911 sg13cmos5l_dlygate4sd3_1
X$7349 VPWR VGND \$2436 \$2607 sg13cmos5l_dlygate4sd3_1
X$7350 VPWR VGND \$1961 \$1881 sg13cmos5l_dlygate4sd3_1
X$7351 VPWR VGND \$1566 \$1720 sg13cmos5l_dlygate4sd3_1
X$7352 VPWR VGND \$2312 \$2119 sg13cmos5l_dlygate4sd3_1
X$7353 VPWR VGND \$1826 \$1773 sg13cmos5l_dlygate4sd3_1
X$7354 VPWR VGND \$3909 \$3828 sg13cmos5l_dlygate4sd3_1
X$7355 VPWR VGND \$3943 \$3944 sg13cmos5l_dlygate4sd3_1
X$7356 VPWR VGND \$2775 \$2495 sg13cmos5l_dlygate4sd3_1
X$7357 VPWR VGND \$3750 \$2755 sg13cmos5l_dlygate4sd3_1
X$7358 VPWR VGND \$2148 \$1924 sg13cmos5l_dlygate4sd3_1
X$7359 VPWR VGND \$3204 \$3088 sg13cmos5l_dlygate4sd3_1
X$7360 VPWR VGND \$59 \$17 sg13cmos5l_dlygate4sd3_1
X$7361 VPWR VGND \$1887 \$1748 sg13cmos5l_dlygate4sd3_1
X$7362 VPWR VGND \$3850 \$3763 sg13cmos5l_dlygate4sd3_1
X$7363 VPWR VGND \$2301 \$2250 sg13cmos5l_dlygate4sd3_1
X$7364 VPWR VGND \$1771 \$1774 sg13cmos5l_dlygate4sd3_1
X$7365 VPWR VGND \$1725 \$1638 sg13cmos5l_dlygate4sd3_1
X$7366 VPWR VGND \$3783 \$3817 sg13cmos5l_dlygate4sd3_1
X$7367 VPWR VGND \$1928 \$1925 sg13cmos5l_dlygate4sd3_1
X$7368 VPWR VGND \$269 \$62 sg13cmos5l_dlygate4sd3_1
X$7369 VPWR VGND \$1335 \$1074 sg13cmos5l_dlygate4sd3_1
X$7370 VPWR VGND \$3917 \$3791 sg13cmos5l_dlygate4sd3_1
X$7371 VPWR VGND \$2084 \$1918 sg13cmos5l_dlygate4sd3_1
X$7372 VPWR VGND \$3737 \$2648 sg13cmos5l_dlygate4sd3_1
X$7373 VPWR VGND \$2070 \$1720 sg13cmos5l_dlygate4sd3_1
X$7374 VPWR VGND \$1588 \$1565 sg13cmos5l_dlygate4sd3_1
X$7375 VPWR VGND \$3787 \$3825 sg13cmos5l_dlygate4sd3_1
X$7376 VPWR VGND \$28 \$14 sg13cmos5l_dlygate4sd3_1
X$7377 VPWR VGND \$117 \$68 sg13cmos5l_dlygate4sd3_1
X$7378 VPWR VGND \$268 \$409 sg13cmos5l_dlygate4sd3_1
X$7379 VGND VPWR \$53 \$167 \$268 sg13cmos5l_nor2b_1
X$7380 VPWR VGND \$2333 \$2498 sg13cmos5l_dlygate4sd3_1
X$7381 VPWR VGND \$3393 \$3868 sg13cmos5l_dlygate4sd3_1
X$7382 VPWR VGND \$3488 \$3611 sg13cmos5l_dlygate4sd3_1
X$7383 VPWR VGND \$3114 \$3364 sg13cmos5l_dlygate4sd3_1
X$7384 VPWR VGND \$1892 \$1933 sg13cmos5l_dlygate4sd3_1
X$7385 VPWR VGND \$1704 \$1898 \$290 \$491 \$1987 sg13cmos5l_or4_1
X$7386 VPWR VGND \$1929 \$1825 sg13cmos5l_dlygate4sd3_1
X$7387 VPWR VGND \$1233 \$1294 sg13cmos5l_dlygate4sd3_1
X$7388 VPWR VGND \$322 \$767 sg13cmos5l_dlygate4sd3_1
X$7389 VPWR VGND \$3617 \$3896 sg13cmos5l_dlygate4sd3_1
X$7390 VPWR VGND \$3672 \$3568 sg13cmos5l_dlygate4sd3_1
X$7391 VPWR VGND \$124 \$75 sg13cmos5l_dlygate4sd3_1
X$7392 VPWR VGND \$453 \$452 sg13cmos5l_dlygate4sd3_1
X$7393 VPWR VGND \$119 \$74 sg13cmos5l_dlygate4sd3_1
X$7394 VPWR VGND \$1862 \$1889 sg13cmos5l_dlygate4sd3_1
X$7395 VPWR VGND \$2080 \$1912 sg13cmos5l_dlygate4sd3_1
X$7396 VPWR VGND \$3009 \$2691 sg13cmos5l_dlygate4sd3_1
X$7397 VPWR VGND \$1726 \$1642 sg13cmos5l_dlygate4sd3_1
X$7398 VPWR VGND \$121 \$61 sg13cmos5l_dlygate4sd3_1
X$7399 VPWR VGND \$3748 \$3217 sg13cmos5l_dlygate4sd3_1
X$7400 VPWR VGND \$2437 \$2702 sg13cmos5l_dlygate4sd3_1
X$7401 VPWR VGND \$1558 \$1447 sg13cmos5l_dlygate4sd3_1
X$7402 VPWR VGND \$1512 \$1181 sg13cmos5l_dlygate4sd3_1
X$7403 VPWR VGND \$3922 \$3838 sg13cmos5l_dlygate4sd3_1
X$7404 VPWR VGND \$3616 \$3321 sg13cmos5l_dlygate4sd3_1
X$7405 VPWR VGND \$650 \$572 sg13cmos5l_dlygate4sd3_1
X$7406 VPWR VGND \$167 \$106 sg13cmos5l_dlygate4sd3_1
X$7407 VPWR VGND \$952 \$1005 sg13cmos5l_dlygate4sd3_1
X$7408 VPWR VGND \$2054 \$1871 sg13cmos5l_dlygate4sd3_1
X$7409 VPWR VGND \$1536 \$1450 sg13cmos5l_dlygate4sd3_1
X$7410 VPWR VGND \$3778 \$3564 sg13cmos5l_dlygate4sd3_1
X$7411 VPWR VGND \$70 \$16 sg13cmos5l_dlygate4sd3_1
X$7412 VPWR VGND \$3773 \$3804 sg13cmos5l_dlygate4sd3_1
X$7413 VPWR VGND \$54 \$15 sg13cmos5l_dlygate4sd3_1
X$7414 VPWR VGND \$3933 \$3935 sg13cmos5l_dlygate4sd3_1
X$7415 VPWR VGND \$3964 \$3940 sg13cmos5l_dlygate4sd3_1
X$7416 VPWR VGND \$1790 \$1789 sg13cmos5l_dlygate4sd3_1
X$7417 VPWR VGND \$2362 \$2313 sg13cmos5l_dlygate4sd3_1
X$7586 VGND \$426 VPWR \$36 sg13cmos5l_buf_1
X$7587 VPWR VGND sg13cmos5l_decap_4
X$7589 VPWR VGND \$67 \$9 sg13cmos5l_dlygate4sd3_1
X$7590 VGND \$45 \$83 \$13 \$80 VPWR sg13cmos5l_dfrbpq_1
X$7594 VPWR VGND sg13cmos5l_decap_8
X$7595 VPWR VGND \$12 \$50 \$13 sg13cmos5l_nor2_1
X$7596 \$46 VGND \$27 VPWR \$25 \$12 sg13cmos5l_a21oi_1
X$7597 VPWR VGND \$97 \$96 sg13cmos5l_inv_1
X$7599 VPWR VGND \$268 \$167 \$136 sg13cmos5l_nand2b_1
X$7600 VPWR VGND sg13cmos5l_decap_4
X$7601 VPWR VGND sg13cmos5l_decap_4
X$7602 VPWR VGND sg13cmos5l_decap_4
X$7603 VPWR VGND sg13cmos5l_decap_4
X$7604 VPWR VGND sg13cmos5l_decap_4
X$7605 VPWR VGND sg13cmos5l_decap_4
X$7606 VPWR VGND sg13cmos5l_decap_4
X$7607 VPWR VGND sg13cmos5l_decap_4
X$7608 VPWR VGND sg13cmos5l_decap_4
X$7609 VPWR VGND sg13cmos5l_decap_4
X$7610 VGND \$338 \$593 \$457 \$455 VPWR sg13cmos5l_mux2_1
X$7611 VPWR VGND sg13cmos5l_decap_4
X$7612 VPWR VGND sg13cmos5l_decap_4
X$7613 VPWR VGND sg13cmos5l_decap_4
X$7614 VPWR VGND sg13cmos5l_decap_4
X$7615 VPWR VGND sg13cmos5l_decap_4
X$7616 VPWR VGND sg13cmos5l_decap_4
X$7617 VPWR VGND sg13cmos5l_decap_4
X$7618 VPWR VGND sg13cmos5l_decap_4
X$7619 VPWR VGND sg13cmos5l_decap_4
X$7620 VPWR VGND sg13cmos5l_decap_4
X$7621 VPWR VGND sg13cmos5l_decap_4
X$7622 VPWR VGND sg13cmos5l_decap_4
X$7623 VPWR VGND sg13cmos5l_decap_4
X$7624 VPWR VGND sg13cmos5l_decap_4
X$7625 VPWR VGND sg13cmos5l_decap_4
X$7626 VPWR VGND sg13cmos5l_decap_4
X$7627 VPWR VGND sg13cmos5l_decap_4
X$7628 VPWR VGND sg13cmos5l_decap_4
X$7629 VPWR VGND sg13cmos5l_decap_4
X$7630 VPWR VGND sg13cmos5l_decap_4
X$7631 VPWR VGND sg13cmos5l_decap_4
X$7632 VPWR VGND sg13cmos5l_decap_4
X$7633 VPWR VGND sg13cmos5l_decap_4
X$7634 VPWR VGND sg13cmos5l_decap_4
X$7635 VPWR VGND sg13cmos5l_decap_4
X$7636 VPWR VGND sg13cmos5l_decap_4
X$7637 VPWR VGND sg13cmos5l_decap_4
X$7638 VPWR VGND sg13cmos5l_decap_4
X$7639 VPWR VGND sg13cmos5l_decap_4
X$7640 VGND \$3065 VPWR \$3436 sg13cmos5l_buf_1
X$7641 VGND \$698 VPWR \$2037 sg13cmos5l_buf_1
X$7642 VGND \$3796 VPWR \$3322 sg13cmos5l_buf_1
X$7643 VGND \$2985 VPWR \$3065 sg13cmos5l_buf_1
X$7644 VGND \$1776 VPWR \$2084 sg13cmos5l_buf_1
X$7645 VGND \$290 VPWR \$1233 sg13cmos5l_buf_1
X$7646 VGND \$2967 VPWR \$3204 sg13cmos5l_buf_1
X$7647 VGND \$3615 VPWR \$3322 sg13cmos5l_buf_1
X$7648 VGND \$2877 VPWR \$2007 sg13cmos5l_buf_1
X$7649 VGND \$1475 VPWR \$1573 sg13cmos5l_buf_1
X$7650 VGND \$2768 VPWR \$2988 sg13cmos5l_buf_1
X$7651 VGND \$1716 VPWR \$1573 sg13cmos5l_buf_1
X$7652 VGND \$2373 VPWR \$2207 sg13cmos5l_buf_1
X$7653 VGND \$52 VPWR \$54 sg13cmos5l_buf_1
X$7654 VGND \$25 VPWR \$28 sg13cmos5l_buf_1
X$7655 VGND \$964 VPWR \$894 sg13cmos5l_buf_1
X$7656 VGND \$251 VPWR \$290 sg13cmos5l_buf_1
X$7657 VGND \$I12082 VPWR \$1435 sg13cmos5l_buf_1
X$7658 VGND \$128 VPWR \$44 sg13cmos5l_buf_1
X$7659 VGND \$1573 VPWR \$211 sg13cmos5l_buf_1
X$7660 VGND \$1064 VPWR \$322 sg13cmos5l_buf_1
X$7661 VGND \$2517 VPWR \$2495 sg13cmos5l_buf_1
X$7662 VGND \$990 VPWR \$1037 sg13cmos5l_buf_1
X$7663 VGND \$2638 VPWR \$2879 sg13cmos5l_buf_1
X$7664 VGND \$45 VPWR \$44 sg13cmos5l_buf_1
X$7665 VGND \$2989 VPWR \$3114 sg13cmos5l_buf_1
X$7666 VGND \$3322 VPWR \$2248 sg13cmos5l_buf_1
X$7667 VGND \$525 VPWR \$964 sg13cmos5l_buf_1
X$7668 VGND \$2349 VPWR \$2204 sg13cmos5l_buf_1
X$7669 VGND \$3173 VPWR \$3748 sg13cmos5l_buf_1
X$7670 VGND \$2943 VPWR \$2094 sg13cmos5l_buf_1
X$7671 VGND \$2439 VPWR \$2349 sg13cmos5l_buf_1
X$7672 VGND \$211 VPWR \$2310 sg13cmos5l_buf_1
X$7673 VGND \$2252 VPWR \$2323 sg13cmos5l_buf_1
X$7674 VGND \$580 VPWR \$1294 sg13cmos5l_buf_1
X$7675 VGND \$903 VPWR \$990 sg13cmos5l_buf_1
X$7676 VGND \$40 VPWR vctrl_b_in sg13cmos5l_buf_1
X$7677 VGND \$I12062 VPWR \$655 sg13cmos5l_buf_1
X$7678 VGND \$I12061 VPWR \$484 sg13cmos5l_buf_1
X$7679 VGND \$44 VPWR \$211 sg13cmos5l_buf_1
X$7680 VPWR VGND \$187 \$52 \$195 sg13cmos5l_nand2_1
X$7681 VGND \$36 VPWR vctrl_in sg13cmos5l_buf_1
X$7682 VGND \$3866 VPWR \$3971 sg13cmos5l_buf_1
X$7683 VGND \$593 VPWR \$310 sg13cmos5l_buf_1
X$7684 VGND \$1480 VPWR \$1573 sg13cmos5l_buf_1
X$7685 VGND \$371 VPWR \$40 sg13cmos5l_buf_1
X$7686 VGND \$2248 VPWR \$2310 sg13cmos5l_buf_1
X$7687 VGND \$736 VPWR \$1068 sg13cmos5l_buf_1
X$7688 VGND \$2007 VPWR \$2002 sg13cmos5l_buf_1
X$7689 VGND \$354 VPWR \$322 sg13cmos5l_buf_1
X$7690 VGND \$137 VPWR \$124 sg13cmos5l_buf_1
X$7691 VGND \$2310 VPWR rst_n sg13cmos5l_buf_1
X$7692 VGND \$2104 VPWR \$698 sg13cmos5l_buf_1
X$7693 VGND \$2695 VPWR \$3750 sg13cmos5l_buf_1
X$7694 VGND \$2646 VPWR \$3737 sg13cmos5l_buf_1
X$7695 VGND \$2581 VPWR \$2104 sg13cmos5l_buf_1
X$7696 VGND \$2857 VPWR \$2094 sg13cmos5l_buf_1
X$7697 VGND \$2973 VPWR \$3088 sg13cmos5l_buf_1
X$7698 VGND \$51 VPWR \$53 sg13cmos5l_buf_1
X$7699 VGND \$3089 VPWR \$2691 sg13cmos5l_buf_1
X$7700 VGND \$2094 VPWR \$2133 sg13cmos5l_buf_1
X$7701 VGND \$12 VPWR \$51 sg13cmos5l_buf_1
R$1 VGND \$207 VGND rhigh w=2u l=12.9u ps=0u b=0 m=1
M$2 \$378 \$378 \$378 VGND sg13_hv_nmos L=0.5u W=2u AS=0.68p AD=0.68p PS=4.68u
+ PD=4.68u rfmode=0
M$3 \$318 \$318 \$318 VGND sg13_hv_nmos L=0.5u W=2u AS=0.68p AD=0.68p PS=4.68u
+ PD=4.68u rfmode=0
M$4 \$318 \$207 \$319 VAPWR sg13_hv_pmos L=0.5u W=16u AS=5.44p AD=5.44p
+ PS=34.72u PD=34.72u rfmode=0
M$5 \$319 \$319 \$319 VAPWR sg13_hv_pmos L=0.5u W=12u AS=4.08p AD=4.08p
+ PS=26.04u PD=26.04u rfmode=0
R$6 \$1152 VGND VGND rhigh w=2u l=4.25u ps=0u b=0 m=1
M$7 VGND VGND VGND VGND sg13_hv_nmos L=0.5u W=38.5u AS=13.09p AD=13.09p
+ PS=96.72u PD=96.72u rfmode=0
M$9 \$318 \$378 VGND VGND sg13_hv_nmos L=0.5u W=8u AS=2.72p AD=2.72p PS=18.72u
+ PD=18.72u rfmode=0
M$10 \$378 analog_1 \$319 VAPWR sg13_hv_pmos L=0.5u W=16u AS=5.44p AD=5.44p
+ PS=34.72u PD=34.72u rfmode=0
M$11 \$318 \$318 \$318 VAPWR sg13_hv_pmos L=0.5u W=4u AS=1.36p AD=1.36p
+ PS=8.68u PD=8.68u rfmode=0
M$12 \$378 \$378 VGND VGND sg13_hv_nmos L=0.5u W=8u AS=2.72p AD=2.72p PS=18.72u
+ PD=18.72u rfmode=0
M$21 \$1339 \$1389 VGND VGND sg13_hv_nmos L=0.5u W=8u AS=2.72p AD=2.72p
+ PS=18.72u PD=18.72u rfmode=0
M$24 \$1340 \$1340 \$1340 VAPWR sg13_hv_pmos L=0.5u W=12u AS=4.08p AD=4.08p
+ PS=26.04u PD=26.04u rfmode=0
M$25 \$1389 \$1389 VGND VGND sg13_hv_nmos L=0.5u W=8u AS=2.72p AD=2.72p
+ PS=18.72u PD=18.72u rfmode=0
M$26 \$1339 \$1339 \$1339 VGND sg13_hv_nmos L=0.5u W=2u AS=0.68p AD=0.68p
+ PS=4.68u PD=4.68u rfmode=0
M$28 \$1389 analog_1 \$1340 VAPWR sg13_hv_pmos L=0.5u W=16u AS=5.44p AD=5.44p
+ PS=34.72u PD=34.72u rfmode=0
M$29 \$1389 \$1389 \$1389 VGND sg13_hv_nmos L=0.5u W=2u AS=0.68p AD=0.68p
+ PS=4.68u PD=4.68u rfmode=0
M$32 \$1339 \$1339 \$1339 VAPWR sg13_hv_pmos L=0.5u W=4u AS=1.36p AD=1.36p
+ PS=8.68u PD=8.68u rfmode=0
M$33 \$1922 \$1922 \$1922 VAPWR sg13_hv_pmos L=0.5u W=12u AS=4.08p AD=4.08p
+ PS=26.04u PD=26.04u rfmode=0
M$34 \$1921 \$1921 VGND VGND sg13_hv_nmos L=0.5u W=8u AS=2.72p AD=2.72p
+ PS=18.72u PD=18.72u rfmode=0
M$35 \$1921 analog_1 \$1922 VAPWR sg13_hv_pmos L=0.5u W=16u AS=5.44p AD=5.44p
+ PS=34.72u PD=34.72u rfmode=0
M$37 \$1919 \$1848 \$1922 VAPWR sg13_hv_pmos L=0.5u W=16u AS=5.44p AD=5.44p
+ PS=34.72u PD=34.72u rfmode=0
M$41 \$1919 \$1921 VGND VGND sg13_hv_nmos L=0.5u W=8u AS=2.72p AD=2.72p
+ PS=18.72u PD=18.72u rfmode=0
M$45 \$1919 \$1919 \$1919 VGND sg13_hv_nmos L=0.5u W=2u AS=0.68p AD=0.68p
+ PS=4.68u PD=4.68u rfmode=0
M$46 \$1921 \$1921 \$1921 VGND sg13_hv_nmos L=0.5u W=2u AS=0.68p AD=0.68p
+ PS=4.68u PD=4.68u rfmode=0
M$47 \$1339 \$1249 \$1340 VAPWR sg13_hv_pmos L=0.5u W=16u AS=5.44p AD=5.44p
+ PS=34.72u PD=34.72u rfmode=0
R$53 \$207 \$1249 VGND rhigh w=2u l=2.8u ps=0u b=0 m=1
M$55 \$378 \$378 \$378 VAPWR sg13_hv_pmos L=0.5u W=4u AS=1.36p AD=1.36p
+ PS=8.68u PD=8.68u rfmode=0
M$62 \$1389 \$1389 \$1389 VAPWR sg13_hv_pmos L=0.5u W=4u AS=1.36p AD=1.36p
+ PS=8.68u PD=8.68u rfmode=0
R$70 \$1537 \$1412 VGND rsil w=0.5u l=0.5u ps=0u b=0 m=1
R$71 \$3866 \$1537 VGND rhigh w=1u l=61.395u ps=0.18u b=2 m=1
R$72 \$1249 \$1848 VGND rhigh w=2u l=1.4u ps=0u b=0 m=1
R$73 \$1848 \$2712 VGND rhigh w=2u l=1.4u ps=0u b=0 m=1
M$74 \$2802 \$2802 VGND VGND sg13_hv_nmos L=0.5u W=8u AS=2.72p AD=2.72p
+ PS=18.72u PD=18.72u rfmode=0
M$75 \$2801 \$2801 \$2801 VGND sg13_hv_nmos L=0.5u W=2u AS=0.68p AD=0.68p
+ PS=4.68u PD=4.68u rfmode=0
M$76 \$2801 \$2802 VGND VGND sg13_hv_nmos L=0.5u W=8u AS=2.72p AD=2.72p
+ PS=18.72u PD=18.72u rfmode=0
M$79 \$2802 \$2802 \$2802 VGND sg13_hv_nmos L=0.5u W=2u AS=0.68p AD=0.68p
+ PS=4.68u PD=4.68u rfmode=0
R$82 \$204 VGND VGND rhigh w=2u l=13.71u ps=0.18u b=8 m=1
R$83 \$1845 VGND VGND rhigh w=2u l=13.71u ps=0.18u b=8 m=1
R$84 \$2709 VGND VGND rhigh w=2u l=13.71u ps=0.18u b=8 m=1
R$85 \$1246 VGND VGND rhigh w=2u l=13.71u ps=0.18u b=8 m=1
M$86 \$1919 \$1919 \$1919 VAPWR sg13_hv_pmos L=0.5u W=4u AS=1.36p AD=1.36p
+ PS=8.68u PD=8.68u rfmode=0
M$87 \$2801 \$2801 \$2801 VAPWR sg13_hv_pmos L=0.5u W=4u AS=1.36p AD=1.36p
+ PS=8.68u PD=8.68u rfmode=0
M$88 \$2803 \$2803 \$2803 VAPWR sg13_hv_pmos L=0.5u W=12u AS=4.08p AD=4.08p
+ PS=26.04u PD=26.04u rfmode=0
M$90 \$2802 analog_1 \$2803 VAPWR sg13_hv_pmos L=0.5u W=16u AS=5.44p AD=5.44p
+ PS=34.72u PD=34.72u rfmode=0
M$92 \$2801 \$2712 \$2803 VAPWR sg13_hv_pmos L=0.5u W=16u AS=5.44p AD=5.44p
+ PS=34.72u PD=34.72u rfmode=0
M$97 analog_1 analog_1 \$3711 \$3711 sg13_hv_pmos L=0.5u W=20u AS=4.1p AD=4.1p
+ PS=26.1u PD=26.1u rfmode=0
R$107 VGND \$3813 VGND rhigh w=2u l=10u ps=0u b=0 m=1
R$108 VGND \$3711 VGND rhigh w=2u l=8u ps=0u b=0 m=1
R$109 \$868 analog_2 VGND rhigh w=2u l=9.96u ps=0.18u b=3 m=1
R$110 \$3967 \$3131 VGND rhigh w=2u l=9.96u ps=0.18u b=3 m=1
R$111 \$2376 \$1602 VGND rhigh w=2u l=9.96u ps=0.18u b=3 m=1
M$112 \$1921 \$1921 \$1921 VAPWR sg13_hv_pmos L=0.5u W=4u AS=1.36p AD=1.36p
+ PS=8.68u PD=8.68u rfmode=0
R$113 VGND \$208 VGND rhigh w=2u l=9.27u ps=0.18u b=15 m=1
R$114 VGND \$1251 VGND rhigh w=2u l=9.27u ps=0.18u b=15 m=1
R$115 VGND \$1849 VGND rhigh w=2u l=9.27u ps=0.18u b=15 m=1
R$116 VGND \$2713 VGND rhigh w=2u l=9.27u ps=0.18u b=15 m=1
M$120 \$2802 \$2802 \$2802 VAPWR sg13_hv_pmos L=0.5u W=4u AS=1.36p AD=1.36p
+ PS=8.68u PD=8.68u rfmode=0
R$123 VGND \$262 VGND rhigh w=2u l=4.95u ps=0.18u b=2 m=1
R$124 VGND \$2807 VGND rhigh w=2u l=4.95u ps=0.18u b=2 m=1
R$125 VGND \$4178 VGND rhigh w=2u l=4.95u ps=0.18u b=2 m=1
R$126 VGND \$1396 VGND rhigh w=2u l=4.95u ps=0.18u b=2 m=1
R$127 VGND \$1852 VGND rhigh w=2u l=4.95u ps=0.18u b=2 m=1
R$128 VGND \$3613 VGND rhigh w=2u l=4.95u ps=0.18u b=2 m=1
R$129 VAPWR \$210 VGND rhigh w=2u l=19.995u ps=0.18u b=9 m=1
R$130 VAPWR \$3614 VGND rhigh w=2u l=19.995u ps=0.18u b=9 m=1
R$131 VAPWR \$1856 VGND rhigh w=2u l=19.995u ps=0.18u b=9 m=1
R$132 VAPWR \$2712 VGND rhigh w=2u l=28.8u ps=0u b=0 m=1
R$133 \$1256 VAPWR VGND rhigh w=2u l=22.72u ps=0.18u b=10 m=1
R$134 \$4135 VAPWR VGND rhigh w=2u l=22.72u ps=0.18u b=10 m=1
R$135 \$2722 VAPWR VGND rhigh w=2u l=22.72u ps=0.18u b=10 m=1
R$136 \$868 VAPWR VGND rhigh w=2u l=19.995u ps=0.18u b=9 m=1
R$137 \$2376 VAPWR VGND rhigh w=2u l=19.995u ps=0.18u b=9 m=1
R$138 \$3967 VAPWR VGND rhigh w=2u l=19.995u ps=0.18u b=9 m=1
M$143 VGND VGND VGND VGND sg13_lv_nmos L=0.13u W=11u AS=3.74p AD=3.74p
+ PS=28.12u PD=28.12u rfmode=0
M$144 \$39 \$39 \$39 VGND sg13_lv_nmos L=0.13u W=1.8u AS=0.612p AD=0.612p
+ PS=4.28u PD=4.28u rfmode=0
M$145 \$39 \$266 VGND VGND sg13_lv_nmos L=0.13u W=18u AS=3.69p AD=3.69p
+ PS=23.9u PD=23.9u rfmode=0
M$156 analog_0 analog_0 analog_0 VGND sg13_lv_nmos L=0.13u W=4u AS=1.36p
+ AD=1.36p PS=8.68u PD=8.68u rfmode=0
M$157 analog_0 \$39 VGND VGND sg13_lv_nmos L=0.13u W=80u AS=15.8p AD=15.8p
+ PS=91.9u PD=91.9u rfmode=0
M$177 \$368 \$368 \$368 VGND sg13_lv_nmos L=0.13u W=2.4u AS=0.816p AD=0.816p
+ PS=6.16u PD=6.16u rfmode=0
M$179 \$368 \$520 VGND VGND sg13_lv_nmos L=0.13u W=6u AS=1.32p AD=1.32p PS=9.4u
+ PD=9.4u rfmode=0
M$185 \$1008 \$1008 \$1008 VGND sg13_lv_nmos L=0.13u W=1u AS=0.34p AD=0.34p
+ PS=3.36u PD=3.36u rfmode=0
M$186 \$1008 \$1017 VGND VGND sg13_lv_nmos L=0.13u W=3u AS=0.66p AD=0.66p
+ PS=5.8u PD=5.8u rfmode=0
M$191 \$865 \$865 \$865 VGND sg13_lv_nmos L=0.13u W=0.4u AS=0.136p AD=0.136p
+ PS=1.48u PD=1.48u rfmode=0
M$193 \$865 \$1007 \$1008 VGND sg13_lv_nmos L=0.13u W=2u AS=0.44p AD=0.44p
+ PS=4.6u PD=4.6u rfmode=0
M$198 \$520 \$520 \$520 VGND sg13_lv_nmos L=0.13u W=0.4u AS=0.136p AD=0.136p
+ PS=1.48u PD=1.48u rfmode=0
M$200 \$520 \$865 VGND VGND sg13_lv_nmos L=0.13u W=2u AS=0.44p AD=0.44p PS=4.6u
+ PD=4.6u rfmode=0
M$205 VPWR VPWR VPWR VPWR sg13_hv_pmos L=4u W=8u AS=2.72p AD=2.72p PS=18.72u
+ PD=18.72u rfmode=0
M$206 q0 \$376 VPWR VPWR sg13_hv_pmos L=4u W=2u AS=0.68p AD=0.68p PS=4.68u
+ PD=4.68u rfmode=0
M$207 q0 q0 q0 VPWR sg13_hv_pmos L=4u W=2u AS=0.68p AD=0.68p PS=4.68u PD=4.68u
+ rfmode=0
M$208 VAPWR VAPWR VAPWR VAPWR sg13_hv_pmos L=4u W=8u AS=2.72p AD=2.72p
+ PS=18.72u PD=18.72u rfmode=0
M$209 \$376 \$318 VAPWR VAPWR sg13_hv_pmos L=4u W=2u AS=0.68p AD=0.68p PS=4.68u
+ PD=4.68u rfmode=0
M$210 \$376 \$376 \$376 VAPWR sg13_hv_pmos L=4u W=2u AS=0.68p AD=0.68p PS=4.68u
+ PD=4.68u rfmode=0
M$211 \$204 \$204 \$204 VGND sg13_hv_nmos L=4u W=2u AS=0.68p AD=0.68p PS=4.68u
+ PD=4.68u rfmode=0
M$212 \$376 \$318 \$204 VGND sg13_hv_nmos L=4u W=2u AS=0.68p AD=0.68p PS=4.68u
+ PD=4.68u rfmode=0
M$213 \$376 \$376 \$376 VGND sg13_hv_nmos L=4u W=2u AS=0.68p AD=0.68p PS=4.68u
+ PD=4.68u rfmode=0
M$214 \$266 \$266 \$266 VGND sg13_lv_nmos L=0.13u W=2.4u AS=0.816p AD=0.816p
+ PS=6.16u PD=6.16u rfmode=0
M$216 \$266 \$371 VGND VGND sg13_lv_nmos L=0.13u W=6u AS=1.32p AD=1.32p PS=9.4u
+ PD=9.4u rfmode=0
M$221 \$266 \$266 \$266 VPWR sg13_lv_pmos L=0.13u W=2.6u AS=0.884p AD=0.884p
+ PS=6.56u PD=6.56u rfmode=0
M$222 VGND VGND VGND VPWR sg13_lv_pmos L=0.13u W=1.3u AS=0.442p AD=0.442p
+ PS=3.28u PD=3.28u rfmode=0
M$223 \$266 \$426 VGND VPWR sg13_lv_pmos L=0.13u W=13.5u AS=2.7675p AD=2.7675p
+ PS=18.95u PD=18.95u rfmode=0
M$235 \$266 \$426 \$368 VGND sg13_lv_nmos L=0.13u W=6u AS=1.32p AD=1.32p
+ PS=9.4u PD=9.4u rfmode=0
M$240 VGND VGND VGND VGND sg13_hv_nmos L=4u W=8u AS=2.72p AD=2.72p PS=18.72u
+ PD=18.72u rfmode=0
M$241 q0 \$376 VGND VGND sg13_hv_nmos L=4u W=2u AS=0.68p AD=0.68p PS=4.68u
+ PD=4.68u rfmode=0
M$242 q0 q0 q0 VGND sg13_hv_nmos L=4u W=2u AS=0.68p AD=0.68p PS=4.68u PD=4.68u
+ rfmode=0
M$244 \$1244 \$1244 \$1244 VGND sg13_lv_nmos L=0.13u W=1u AS=0.34p AD=0.34p
+ PS=3.36u PD=3.36u rfmode=0
M$245 \$1244 \$1017 VGND VGND sg13_lv_nmos L=0.13u W=3u AS=0.66p AD=0.66p
+ PS=5.8u PD=5.8u rfmode=0
M$250 \$1025 \$1025 \$1025 VGND sg13_lv_nmos L=0.13u W=2u AS=0.68p AD=0.68p
+ PS=4.68u PD=4.68u rfmode=0
M$251 \$1152 \$1152 \$1152 VGND sg13_lv_nmos L=0.13u W=2u AS=0.68p AD=0.68p
+ PS=4.68u PD=4.68u rfmode=0
M$252 \$1152 \$1412 \$1025 VGND sg13_lv_nmos L=0.13u W=40u AS=7.9p AD=7.9p
+ PS=49.9u PD=49.9u rfmode=0
M$272 \$1078 \$1078 \$1078 VGND sg13_lv_nmos L=0.13u W=0.4u AS=0.136p AD=0.136p
+ PS=1.48u PD=1.48u rfmode=0
M$274 \$1078 \$865 \$1244 VGND sg13_lv_nmos L=0.13u W=2u AS=0.44p AD=0.44p
+ PS=4.6u PD=4.6u rfmode=0
M$280 \$1017 \$1017 \$1017 VGND sg13_lv_nmos L=0.13u W=0.6u AS=0.204p AD=0.204p
+ PS=1.88u PD=1.88u rfmode=0
M$281 \$1017 \$1017 VGND VGND sg13_lv_nmos L=0.13u W=3u AS=0.66p AD=0.66p
+ PS=5.8u PD=5.8u rfmode=0
M$286 \$1246 \$1246 \$1246 VGND sg13_hv_nmos L=4u W=2u AS=0.68p AD=0.68p
+ PS=4.68u PD=4.68u rfmode=0
M$287 \$1455 \$1339 \$1246 VGND sg13_hv_nmos L=4u W=2u AS=0.68p AD=0.68p
+ PS=4.68u PD=4.68u rfmode=0
M$288 \$1455 \$1455 \$1455 VGND sg13_hv_nmos L=4u W=2u AS=0.68p AD=0.68p
+ PS=4.68u PD=4.68u rfmode=0
M$290 q1 \$1455 VPWR VPWR sg13_hv_pmos L=4u W=2u AS=0.68p AD=0.68p PS=4.68u
+ PD=4.68u rfmode=0
M$291 q1 q1 q1 VPWR sg13_hv_pmos L=4u W=2u AS=0.68p AD=0.68p PS=4.68u PD=4.68u
+ rfmode=0
M$293 \$1455 \$1339 VAPWR VAPWR sg13_hv_pmos L=4u W=2u AS=0.68p AD=0.68p
+ PS=4.68u PD=4.68u rfmode=0
M$294 \$1455 \$1455 \$1455 VAPWR sg13_hv_pmos L=4u W=2u AS=0.68p AD=0.68p
+ PS=4.68u PD=4.68u rfmode=0
M$296 q1 \$1455 VGND VGND sg13_hv_nmos L=4u W=2u AS=0.68p AD=0.68p PS=4.68u
+ PD=4.68u rfmode=0
M$297 q1 q1 q1 VGND sg13_hv_nmos L=4u W=2u AS=0.68p AD=0.68p PS=4.68u PD=4.68u
+ rfmode=0
M$298 \$1007 \$1007 \$1007 VGND sg13_lv_nmos L=0.13u W=0.4u AS=0.136p AD=0.136p
+ PS=1.48u PD=1.48u rfmode=0
M$299 \$1151 \$1151 \$1151 VGND sg13_lv_nmos L=0.13u W=1u AS=0.34p AD=0.34p
+ PS=3.36u PD=3.36u rfmode=0
M$300 \$1007 \$1078 \$1151 VGND sg13_lv_nmos L=0.13u W=2u AS=0.44p AD=0.44p
+ PS=4.6u PD=4.6u rfmode=0
M$307 \$1151 \$1017 VGND VGND sg13_lv_nmos L=0.13u W=3u AS=0.66p AD=0.66p
+ PS=5.8u PD=5.8u rfmode=0
M$312 \$1006 \$1006 \$1006 VPWR sg13_lv_pmos L=0.13u W=0.95u AS=0.323p
+ AD=0.323p PS=3.26u PD=3.26u rfmode=0
M$313 VPWR VPWR VPWR VPWR sg13_lv_pmos L=0.13u W=10.25u AS=3.485p AD=3.485p
+ PS=26.62u PD=26.62u rfmode=0
M$314 \$1006 \$1025 VPWR VPWR sg13_lv_pmos L=0.13u W=5u AS=1.025p AD=1.025p
+ PS=9.6u PD=9.6u rfmode=0
M$324 \$1241 \$1241 \$1241 VPWR sg13_lv_pmos L=0.13u W=0.95u AS=0.323p
+ AD=0.323p PS=3.26u PD=3.26u rfmode=0
M$326 \$1241 \$1025 VPWR VPWR sg13_lv_pmos L=0.13u W=5u AS=1.025p AD=1.025p
+ PS=9.6u PD=9.6u rfmode=0
M$336 \$1149 \$1149 \$1149 VPWR sg13_lv_pmos L=0.13u W=0.95u AS=0.323p
+ AD=0.323p PS=3.26u PD=3.26u rfmode=0
M$338 \$1149 \$1025 VPWR VPWR sg13_lv_pmos L=0.13u W=5u AS=1.025p AD=1.025p
+ PS=9.6u PD=9.6u rfmode=0
M$348 \$208 \$208 \$208 VAPWR sg13_hv_pmos L=0.5u W=4u AS=1.36p AD=1.36p
+ PS=8.68u PD=8.68u rfmode=0
M$349 \$1849 \$1849 \$1849 VAPWR sg13_hv_pmos L=0.5u W=4u AS=1.36p AD=1.36p
+ PS=8.68u PD=8.68u rfmode=0
M$350 \$1251 \$1251 \$1251 VAPWR sg13_hv_pmos L=0.5u W=4u AS=1.36p AD=1.36p
+ PS=8.68u PD=8.68u rfmode=0
M$351 \$2713 \$2713 \$2713 VAPWR sg13_hv_pmos L=0.5u W=4u AS=1.36p AD=1.36p
+ PS=8.68u PD=8.68u rfmode=0
M$352 \$208 \$208 VAPWR VAPWR sg13_hv_pmos L=0.5u W=4u AS=1.36p AD=1.36p
+ PS=8.68u PD=8.68u rfmode=0
M$353 \$1849 \$1849 VAPWR VAPWR sg13_hv_pmos L=0.5u W=4u AS=1.36p AD=1.36p
+ PS=8.68u PD=8.68u rfmode=0
M$354 \$1251 \$1251 VAPWR VAPWR sg13_hv_pmos L=0.5u W=4u AS=1.36p AD=1.36p
+ PS=8.68u PD=8.68u rfmode=0
M$355 \$2713 \$2713 VAPWR VAPWR sg13_hv_pmos L=0.5u W=4u AS=1.36p AD=1.36p
+ PS=8.68u PD=8.68u rfmode=0
M$356 VAPWR VAPWR VAPWR VAPWR sg13_hv_pmos L=0.5u W=60u AS=20.4p AD=20.4p
+ PS=134.96u PD=134.96u rfmode=0
M$361 q3 \$2893 VGND VGND sg13_hv_nmos L=4u W=2u AS=0.68p AD=0.68p PS=4.68u
+ PD=4.68u rfmode=0
M$362 q3 q3 q3 VGND sg13_hv_nmos L=4u W=2u AS=0.68p AD=0.68p PS=4.68u PD=4.68u
+ rfmode=0
M$364 \$2893 \$2801 VAPWR VAPWR sg13_hv_pmos L=4u W=2u AS=0.68p AD=0.68p
+ PS=4.68u PD=4.68u rfmode=0
M$365 \$2893 \$2893 \$2893 VAPWR sg13_hv_pmos L=4u W=2u AS=0.68p AD=0.68p
+ PS=4.68u PD=4.68u rfmode=0
M$366 \$2709 \$2709 \$2709 VGND sg13_hv_nmos L=4u W=2u AS=0.68p AD=0.68p
+ PS=4.68u PD=4.68u rfmode=0
M$367 \$2893 \$2801 \$2709 VGND sg13_hv_nmos L=4u W=2u AS=0.68p AD=0.68p
+ PS=4.68u PD=4.68u rfmode=0
M$368 \$2893 \$2893 \$2893 VGND sg13_hv_nmos L=4u W=2u AS=0.68p AD=0.68p
+ PS=4.68u PD=4.68u rfmode=0
M$370 q3 \$2893 VPWR VPWR sg13_hv_pmos L=4u W=2u AS=0.68p AD=0.68p PS=4.68u
+ PD=4.68u rfmode=0
M$371 q3 q3 q3 VPWR sg13_hv_pmos L=4u W=2u AS=0.68p AD=0.68p PS=4.68u PD=4.68u
+ rfmode=0
M$372 \$3813 \$3813 \$3813 VAPWR sg13_hv_pmos L=0.5u W=2u AS=0.68p AD=0.68p
+ PS=4.68u PD=4.68u rfmode=0
M$374 \$3813 \$3813 VAPWR VAPWR sg13_hv_pmos L=0.5u W=14u AS=2.96p AD=2.96p
+ PS=18.96u PD=18.96u rfmode=0
M$381 \$3711 \$3711 \$3711 VAPWR sg13_hv_pmos L=0.5u W=2u AS=0.68p AD=0.68p
+ PS=4.68u PD=4.68u rfmode=0
M$383 \$3711 \$3813 VAPWR VAPWR sg13_hv_pmos L=0.5u W=14u AS=2.96p AD=2.96p
+ PS=18.96u PD=18.96u rfmode=0
M$393 \$1153 \$1153 \$1153 VGND sg13_hv_nmos L=0.5u W=2u AS=0.68p AD=0.68p
+ PS=5.36u PD=5.36u rfmode=0
M$394 \$2716 \$2716 \$2716 VGND sg13_hv_nmos L=0.5u W=2u AS=0.68p AD=0.68p
+ PS=5.36u PD=5.36u rfmode=0
M$395 \$4129 \$4129 \$4129 VGND sg13_hv_nmos L=0.5u W=2u AS=0.68p AD=0.68p
+ PS=5.36u PD=5.36u rfmode=0
M$396 \$1153 analog_2 VGND VGND sg13_hv_nmos L=0.5u W=18u AS=3.57p AD=3.57p
+ PS=26.14u PD=26.14u rfmode=0
M$414 \$2716 \$1602 VGND VGND sg13_hv_nmos L=0.5u W=18u AS=3.57p AD=3.57p
+ PS=26.14u PD=26.14u rfmode=0
M$432 \$4129 \$3131 VGND VGND sg13_hv_nmos L=0.5u W=18u AS=3.57p AD=3.57p
+ PS=26.14u PD=26.14u rfmode=0
M$453 \$1156 \$1156 \$1156 VGND sg13_hv_nmos L=0.5u W=1.5u AS=0.51p AD=0.51p
+ PS=4.36u PD=4.36u rfmode=0
M$454 \$2613 \$2613 \$2613 VGND sg13_hv_nmos L=0.5u W=1.5u AS=0.51p AD=0.51p
+ PS=4.36u PD=4.36u rfmode=0
M$455 \$3966 \$3966 \$3966 VGND sg13_hv_nmos L=0.5u W=1.5u AS=0.51p AD=0.51p
+ PS=4.36u PD=4.36u rfmode=0
M$456 \$1156 VAPWR \$1153 VGND sg13_hv_nmos L=0.5u W=2u AS=0.53p AD=0.53p
+ PS=4.06u PD=4.06u rfmode=0
M$458 \$2613 VAPWR \$2716 VGND sg13_hv_nmos L=0.5u W=2u AS=0.53p AD=0.53p
+ PS=4.06u PD=4.06u rfmode=0
M$460 \$3966 VAPWR \$4129 VGND sg13_hv_nmos L=0.5u W=2u AS=0.53p AD=0.53p
+ PS=4.06u PD=4.06u rfmode=0
M$465 \$1156 \$1256 VGND VGND sg13_hv_nmos L=0.5u W=0.5u AS=0.17p AD=0.17p
+ PS=1.68u PD=1.68u rfmode=0
M$466 \$2613 \$2722 VGND VGND sg13_hv_nmos L=0.5u W=0.5u AS=0.17p AD=0.17p
+ PS=1.68u PD=1.68u rfmode=0
M$467 \$3966 \$4135 VGND VGND sg13_hv_nmos L=0.5u W=0.5u AS=0.17p AD=0.17p
+ PS=1.68u PD=1.68u rfmode=0
M$471 \$1156 \$1156 \$1156 VAPWR sg13_hv_pmos L=0.5u W=2.7u AS=0.918p AD=0.918p
+ PS=6.76u PD=6.76u rfmode=0
M$472 \$3966 \$3966 \$3966 VAPWR sg13_hv_pmos L=0.5u W=2.7u AS=0.918p AD=0.918p
+ PS=6.76u PD=6.76u rfmode=0
M$473 \$2613 \$2613 \$2613 VAPWR sg13_hv_pmos L=0.5u W=2.7u AS=0.918p AD=0.918p
+ PS=6.76u PD=6.76u rfmode=0
M$477 \$1156 \$1396 VAPWR VAPWR sg13_hv_pmos L=0.5u W=14u AS=2.96p AD=2.96p
+ PS=18.96u PD=18.96u rfmode=0
M$484 \$3966 \$4178 VAPWR VAPWR sg13_hv_pmos L=0.5u W=14u AS=2.96p AD=2.96p
+ PS=18.96u PD=18.96u rfmode=0
M$491 \$2613 \$2807 VAPWR VAPWR sg13_hv_pmos L=0.5u W=14u AS=2.96p AD=2.96p
+ PS=18.96u PD=18.96u rfmode=0
M$498 \$719 \$719 \$719 VGND sg13_hv_nmos L=0.5u W=0.5u AS=0.17p AD=0.17p
+ PS=1.68u PD=1.68u rfmode=0
M$499 \$2272 \$2272 \$2272 VGND sg13_hv_nmos L=0.5u W=0.5u AS=0.17p AD=0.17p
+ PS=1.68u PD=1.68u rfmode=0
M$500 \$3888 \$3888 \$3888 VGND sg13_hv_nmos L=0.5u W=0.5u AS=0.17p AD=0.17p
+ PS=1.68u PD=1.68u rfmode=0
M$501 \$719 \$1156 VGND VGND sg13_hv_nmos L=0.5u W=0.5u AS=0.17p AD=0.17p
+ PS=1.68u PD=1.68u rfmode=0
M$502 \$2272 \$2613 VGND VGND sg13_hv_nmos L=0.5u W=0.5u AS=0.17p AD=0.17p
+ PS=1.68u PD=1.68u rfmode=0
M$503 \$3888 \$3966 VGND VGND sg13_hv_nmos L=0.5u W=0.5u AS=0.17p AD=0.17p
+ PS=1.68u PD=1.68u rfmode=0
M$507 \$1256 \$1256 \$1256 VGND sg13_hv_nmos L=0.5u W=0.5u AS=0.17p AD=0.17p
+ PS=1.68u PD=1.68u rfmode=0
M$508 \$2722 \$2722 \$2722 VGND sg13_hv_nmos L=0.5u W=0.5u AS=0.17p AD=0.17p
+ PS=1.68u PD=1.68u rfmode=0
M$509 \$4135 \$4135 \$4135 VGND sg13_hv_nmos L=0.5u W=0.5u AS=0.17p AD=0.17p
+ PS=1.68u PD=1.68u rfmode=0
M$510 \$1256 \$1256 VGND VGND sg13_hv_nmos L=0.5u W=0.5u AS=0.17p AD=0.17p
+ PS=1.68u PD=1.68u rfmode=0
M$511 \$2722 \$2722 VGND VGND sg13_hv_nmos L=0.5u W=0.5u AS=0.17p AD=0.17p
+ PS=1.68u PD=1.68u rfmode=0
M$512 \$4135 \$4135 VGND VGND sg13_hv_nmos L=0.5u W=0.5u AS=0.17p AD=0.17p
+ PS=1.68u PD=1.68u rfmode=0
M$516 VGND VGND VGND VAPWR sg13_hv_pmos L=0.5u W=2.1u AS=0.714p AD=0.714p
+ PS=6.24u PD=6.24u rfmode=0
M$519 VGND \$390 \$1156 VAPWR sg13_hv_pmos L=0.5u W=0.7u AS=0.238p AD=0.238p
+ PS=2.08u PD=2.08u rfmode=0
M$520 VGND \$3715 \$3966 VAPWR sg13_hv_pmos L=0.5u W=0.7u AS=0.238p AD=0.238p
+ PS=2.08u PD=2.08u rfmode=0
M$521 VGND \$1855 \$2613 VAPWR sg13_hv_pmos L=0.5u W=0.7u AS=0.238p AD=0.238p
+ PS=2.08u PD=2.08u rfmode=0
M$525 \$1396 \$1396 \$1396 VAPWR sg13_hv_pmos L=0.5u W=2u AS=0.68p AD=0.68p
+ PS=4.68u PD=4.68u rfmode=0
M$526 \$4178 \$4178 \$4178 VAPWR sg13_hv_pmos L=0.5u W=2u AS=0.68p AD=0.68p
+ PS=4.68u PD=4.68u rfmode=0
M$527 \$2807 \$2807 \$2807 VAPWR sg13_hv_pmos L=0.5u W=2u AS=0.68p AD=0.68p
+ PS=4.68u PD=4.68u rfmode=0
M$531 \$1396 \$1396 VAPWR VAPWR sg13_hv_pmos L=0.5u W=14u AS=2.96p AD=2.96p
+ PS=18.96u PD=18.96u rfmode=0
M$538 \$4178 \$4178 VAPWR VAPWR sg13_hv_pmos L=0.5u W=14u AS=2.96p AD=2.96p
+ PS=18.96u PD=18.96u rfmode=0
M$545 \$2807 \$2807 VAPWR VAPWR sg13_hv_pmos L=0.5u W=14u AS=2.96p AD=2.96p
+ PS=18.96u PD=18.96u rfmode=0
M$552 \$868 \$868 \$868 VGND sg13_hv_nmos L=0.5u W=1u AS=0.34p AD=0.34p
+ PS=2.68u PD=2.68u rfmode=0
M$553 \$2376 \$2376 \$2376 VGND sg13_hv_nmos L=0.5u W=1u AS=0.34p AD=0.34p
+ PS=2.68u PD=2.68u rfmode=0
M$554 \$3967 \$3967 \$3967 VGND sg13_hv_nmos L=0.5u W=1u AS=0.34p AD=0.34p
+ PS=2.68u PD=2.68u rfmode=0
M$558 \$868 \$868 VGND VGND sg13_hv_nmos L=0.5u W=2u AS=0.53p AD=0.53p PS=4.06u
+ PD=4.06u rfmode=0
M$560 \$2376 \$2376 VGND VGND sg13_hv_nmos L=0.5u W=2u AS=0.53p AD=0.53p
+ PS=4.06u PD=4.06u rfmode=0
M$562 \$3967 \$3967 VGND VGND sg13_hv_nmos L=0.5u W=2u AS=0.53p AD=0.53p
+ PS=4.06u PD=4.06u rfmode=0
M$564 VAPWR VAPWR VAPWR VGND sg13_hv_nmos L=0.5u W=4.5u AS=1.53p AD=1.53p
+ PS=11.04u PD=11.04u rfmode=0
M$567 VAPWR \$3888 \$3715 VGND sg13_hv_nmos L=0.5u W=1.5u AS=0.51p AD=0.51p
+ PS=3.68u PD=3.68u rfmode=0
M$568 VAPWR \$2272 \$1855 VGND sg13_hv_nmos L=0.5u W=1.5u AS=0.51p AD=0.51p
+ PS=3.68u PD=3.68u rfmode=0
M$569 VAPWR \$719 \$390 VGND sg13_hv_nmos L=0.5u W=1.5u AS=0.51p AD=0.51p
+ PS=3.68u PD=3.68u rfmode=0
M$570 \$3715 \$3715 \$3715 VGND sg13_hv_nmos L=0.5u W=3.5u AS=1.19p AD=1.19p
+ PS=8.36u PD=8.36u rfmode=0
M$571 \$1855 \$1855 \$1855 VGND sg13_hv_nmos L=0.5u W=3.5u AS=1.19p AD=1.19p
+ PS=8.36u PD=8.36u rfmode=0
M$572 \$390 \$390 \$390 VGND sg13_hv_nmos L=0.5u W=3.5u AS=1.19p AD=1.19p
+ PS=8.36u PD=8.36u rfmode=0
M$579 \$390 \$210 VGND VGND sg13_hv_nmos L=0.5u W=10u AS=2.2p AD=2.2p PS=14.2u
+ PD=14.2u rfmode=0
M$584 \$1855 \$1856 VGND VGND sg13_hv_nmos L=0.5u W=10u AS=2.2p AD=2.2p
+ PS=14.2u PD=14.2u rfmode=0
M$589 \$3715 \$3614 VGND VGND sg13_hv_nmos L=0.5u W=10u AS=2.2p AD=2.2p
+ PS=14.2u PD=14.2u rfmode=0
M$597 \$210 \$210 \$210 VGND sg13_hv_nmos L=0.5u W=2u AS=0.68p AD=0.68p
+ PS=4.68u PD=4.68u rfmode=0
M$598 \$1856 \$1856 \$1856 VGND sg13_hv_nmos L=0.5u W=2u AS=0.68p AD=0.68p
+ PS=4.68u PD=4.68u rfmode=0
M$599 \$3614 \$3614 \$3614 VGND sg13_hv_nmos L=0.5u W=2u AS=0.68p AD=0.68p
+ PS=4.68u PD=4.68u rfmode=0
M$600 \$210 \$210 VGND VGND sg13_hv_nmos L=0.5u W=10u AS=2.2p AD=2.2p PS=14.2u
+ PD=14.2u rfmode=0
M$605 \$1856 \$1856 VGND VGND sg13_hv_nmos L=0.5u W=10u AS=2.2p AD=2.2p
+ PS=14.2u PD=14.2u rfmode=0
M$610 \$3614 \$3614 VGND VGND sg13_hv_nmos L=0.5u W=10u AS=2.2p AD=2.2p
+ PS=14.2u PD=14.2u rfmode=0
M$615 \$39 \$39 \$39 VPWR sg13_lv_pmos L=0.13u W=2u AS=0.68p AD=0.68p PS=4.68u
+ PD=4.68u rfmode=0
M$617 \$39 \$266 VPWR VPWR sg13_lv_pmos L=0.13u W=40u AS=7.9p AD=7.9p PS=49.9u
+ PD=49.9u rfmode=0
M$637 \$368 \$368 \$368 VPWR sg13_lv_pmos L=0.13u W=2.6u AS=0.884p AD=0.884p
+ PS=6.56u PD=6.56u rfmode=0
M$639 \$368 \$520 VPWR VPWR sg13_lv_pmos L=0.13u W=13.5u AS=2.7675p AD=2.7675p
+ PS=18.95u PD=18.95u rfmode=0
M$650 \$520 \$520 \$520 VPWR sg13_lv_pmos L=0.13u W=0.45u AS=0.153p AD=0.153p
+ PS=1.58u PD=1.58u rfmode=0
M$651 \$520 \$865 VPWR VPWR sg13_lv_pmos L=0.13u W=4.5u AS=0.9225p AD=0.9225p
+ PS=9.05u PD=9.05u rfmode=0
M$662 \$865 \$865 \$865 VPWR sg13_lv_pmos L=0.13u W=0.45u AS=0.153p AD=0.153p
+ PS=1.58u PD=1.58u rfmode=0
M$663 \$865 \$1007 \$1006 VPWR sg13_lv_pmos L=0.13u W=4.5u AS=0.9225p
+ AD=0.9225p PS=9.05u PD=9.05u rfmode=0
M$675 \$266 \$371 \$368 VPWR sg13_lv_pmos L=0.13u W=13.5u AS=2.7675p AD=2.7675p
+ PS=18.95u PD=18.95u rfmode=0
M$685 analog_0 analog_0 analog_0 VPWR sg13_lv_pmos L=0.13u W=4u AS=1.36p
+ AD=1.36p PS=8.68u PD=8.68u rfmode=0
M$687 analog_0 \$39 VPWR VPWR sg13_lv_pmos L=0.13u W=200u AS=38.6p AD=38.6p
+ PS=223.3u PD=223.3u rfmode=0
M$737 \$1017 \$1017 \$1017 VPWR sg13_lv_pmos L=0.13u W=0.5u AS=0.17p AD=0.17p
+ PS=1.68u PD=1.68u rfmode=0
M$739 \$1017 \$1025 VPWR VPWR sg13_lv_pmos L=0.13u W=5u AS=1.025p AD=1.025p
+ PS=9.6u PD=9.6u rfmode=0
M$750 \$1025 \$1025 \$1025 VPWR sg13_lv_pmos L=0.13u W=0.5u AS=0.17p AD=0.17p
+ PS=1.68u PD=1.68u rfmode=0
M$751 VPWR \$1025 \$1025 VPWR sg13_lv_pmos L=0.13u W=5u AS=1.025p AD=1.025p
+ PS=9.6u PD=9.6u rfmode=0
M$762 \$1078 \$1078 \$1078 VPWR sg13_lv_pmos L=0.13u W=0.45u AS=0.153p
+ AD=0.153p PS=1.58u PD=1.58u rfmode=0
M$763 \$1078 \$865 \$1241 VPWR sg13_lv_pmos L=0.13u W=4.5u AS=0.9225p
+ AD=0.9225p PS=9.05u PD=9.05u rfmode=0
M$774 \$1007 \$1007 \$1007 VPWR sg13_lv_pmos L=0.13u W=0.45u AS=0.153p
+ AD=0.153p PS=1.58u PD=1.58u rfmode=0
M$775 \$1007 \$1078 \$1149 VPWR sg13_lv_pmos L=0.13u W=4.5u AS=0.9225p
+ AD=0.9225p PS=9.05u PD=9.05u rfmode=0
M$788 \$719 \$719 \$719 VAPWR sg13_hv_pmos L=0.5u W=2u AS=0.68p AD=0.68p
+ PS=4.68u PD=4.68u rfmode=0
M$789 \$2272 \$2272 \$2272 VAPWR sg13_hv_pmos L=0.5u W=2u AS=0.68p AD=0.68p
+ PS=4.68u PD=4.68u rfmode=0
M$790 \$3888 \$3888 \$3888 VAPWR sg13_hv_pmos L=0.5u W=2u AS=0.68p AD=0.68p
+ PS=4.68u PD=4.68u rfmode=0
M$791 \$719 \$262 VAPWR VAPWR sg13_hv_pmos L=0.5u W=14u AS=2.96p AD=2.96p
+ PS=18.96u PD=18.96u rfmode=0
M$798 \$2272 \$1852 VAPWR VAPWR sg13_hv_pmos L=0.5u W=14u AS=2.96p AD=2.96p
+ PS=18.96u PD=18.96u rfmode=0
M$805 \$3888 \$3613 VAPWR VAPWR sg13_hv_pmos L=0.5u W=14u AS=2.96p AD=2.96p
+ PS=18.96u PD=18.96u rfmode=0
M$812 \$262 \$262 \$262 VAPWR sg13_hv_pmos L=0.5u W=2u AS=0.68p AD=0.68p
+ PS=4.68u PD=4.68u rfmode=0
M$813 \$1852 \$1852 \$1852 VAPWR sg13_hv_pmos L=0.5u W=2u AS=0.68p AD=0.68p
+ PS=4.68u PD=4.68u rfmode=0
M$814 \$3613 \$3613 \$3613 VAPWR sg13_hv_pmos L=0.5u W=2u AS=0.68p AD=0.68p
+ PS=4.68u PD=4.68u rfmode=0
M$818 \$262 \$262 VAPWR VAPWR sg13_hv_pmos L=0.5u W=14u AS=2.96p AD=2.96p
+ PS=18.96u PD=18.96u rfmode=0
M$825 \$1852 \$1852 VAPWR VAPWR sg13_hv_pmos L=0.5u W=14u AS=2.96p AD=2.96p
+ PS=18.96u PD=18.96u rfmode=0
M$832 \$3613 \$3613 VAPWR VAPWR sg13_hv_pmos L=0.5u W=14u AS=2.96p AD=2.96p
+ PS=18.96u PD=18.96u rfmode=0
M$840 q2 \$2008 VGND VGND sg13_hv_nmos L=4u W=2u AS=0.68p AD=0.68p PS=4.68u
+ PD=4.68u rfmode=0
M$841 q2 q2 q2 VGND sg13_hv_nmos L=4u W=2u AS=0.68p AD=0.68p PS=4.68u PD=4.68u
+ rfmode=0
M$842 \$1845 \$1845 \$1845 VGND sg13_hv_nmos L=4u W=2u AS=0.68p AD=0.68p
+ PS=4.68u PD=4.68u rfmode=0
M$843 \$2008 \$1919 \$1845 VGND sg13_hv_nmos L=4u W=2u AS=0.68p AD=0.68p
+ PS=4.68u PD=4.68u rfmode=0
M$844 \$2008 \$2008 \$2008 VGND sg13_hv_nmos L=4u W=2u AS=0.68p AD=0.68p
+ PS=4.68u PD=4.68u rfmode=0
M$846 q2 \$2008 VPWR VPWR sg13_hv_pmos L=4u W=2u AS=0.68p AD=0.68p PS=4.68u
+ PD=4.68u rfmode=0
M$847 q2 q2 q2 VPWR sg13_hv_pmos L=4u W=2u AS=0.68p AD=0.68p PS=4.68u PD=4.68u
+ rfmode=0
M$849 \$2008 \$1919 VAPWR VAPWR sg13_hv_pmos L=4u W=2u AS=0.68p AD=0.68p
+ PS=4.68u PD=4.68u rfmode=0
M$850 \$2008 \$2008 \$2008 VAPWR sg13_hv_pmos L=4u W=2u AS=0.68p AD=0.68p
+ PS=4.68u PD=4.68u rfmode=0
M$855 \$319 \$208 VAPWR VAPWR sg13_hv_pmos L=0.5u W=4u AS=1.36p AD=1.36p
+ PS=8.68u PD=8.68u rfmode=0
M$856 \$2803 \$2713 VAPWR VAPWR sg13_hv_pmos L=0.5u W=4u AS=1.36p AD=1.36p
+ PS=8.68u PD=8.68u rfmode=0
M$857 \$1922 \$1849 VAPWR VAPWR sg13_hv_pmos L=0.5u W=4u AS=1.36p AD=1.36p
+ PS=8.68u PD=8.68u rfmode=0
M$858 \$1340 \$1251 VAPWR VAPWR sg13_hv_pmos L=0.5u W=4u AS=1.36p AD=1.36p
+ PS=8.68u PD=8.68u rfmode=0
.ENDS heichips26_ook_top

.SUBCKT sg13cmos5l_or4_1 VDD VSS B D A C X
M$1 VSS D \$7 VSS sg13_lv_nmos L=0.13u W=0.55u AS=0.187p AD=0.1045p PS=1.78u
+ PD=0.93u rfmode=0
M$2 VSS C \$7 VSS sg13_lv_nmos L=0.13u W=0.55u AS=0.16755p AD=0.1045p PS=1.165u
+ PD=0.93u rfmode=0
M$3 VSS B \$7 VSS sg13_lv_nmos L=0.13u W=0.55u AS=0.16755p AD=0.1045p PS=1.165u
+ PD=0.93u rfmode=0
M$4 VSS A \$7 VSS sg13_lv_nmos L=0.13u W=0.55u AS=0.14135p AD=0.1045p PS=1.14u
+ PD=0.93u rfmode=0
M$5 VSS \$7 X VSS sg13_lv_nmos L=0.13u W=0.74u AS=0.14135p AD=0.2516p PS=1.14u
+ PD=2.16u rfmode=0
M$6 \$7 D \$11 VDD sg13_lv_pmos L=0.13u W=1u AS=0.34p AD=0.19p PS=2.68u
+ PD=1.38u rfmode=0
M$7 \$11 C \$10 VDD sg13_lv_pmos L=0.13u W=1u AS=0.19p AD=0.2925p PS=1.38u
+ PD=1.585u rfmode=0
M$8 \$10 B \$9 VDD sg13_lv_pmos L=0.13u W=1u AS=0.2925p AD=0.19p PS=1.585u
+ PD=1.38u rfmode=0
M$9 VDD A \$9 VDD sg13_lv_pmos L=0.13u W=1u AS=0.2144p AD=0.19p PS=1.52u
+ PD=1.38u rfmode=0
M$10 VDD \$7 X VDD sg13_lv_pmos L=0.13u W=1.12u AS=0.2144p AD=0.3808p PS=1.52u
+ PD=2.92u rfmode=0
.ENDS sg13cmos5l_or4_1

.SUBCKT sg13cmos5l_mux2_1 VSS X S A1 A0 VDD
M$1 VSS S \$2 VSS sg13_lv_nmos L=0.13u W=0.55u AS=0.18945p AD=0.187p PS=1.27u
+ PD=1.78u rfmode=0
M$2 VSS S \$8 VSS sg13_lv_nmos L=0.13u W=0.74u AS=0.18945p AD=0.13135p PS=1.27u
+ PD=1.095u rfmode=0
M$3 \$8 A1 \$3 VSS sg13_lv_nmos L=0.13u W=0.74u AS=0.13135p AD=0.1628p
+ PS=1.095u PD=1.18u rfmode=0
M$4 \$3 A0 \$9 VSS sg13_lv_nmos L=0.13u W=0.74u AS=0.1628p AD=0.3367p PS=1.18u
+ PD=1.65u rfmode=0
M$5 \$9 \$2 VSS VSS sg13_lv_nmos L=0.13u W=0.74u AS=0.3367p AD=0.148p PS=1.65u
+ PD=1.14u rfmode=0
M$6 VSS \$3 X VSS sg13_lv_nmos L=0.13u W=0.74u AS=0.148p AD=0.4033p PS=1.14u
+ PD=2.57u rfmode=0
M$7 \$2 S VDD VDD sg13_lv_pmos L=0.13u W=0.84u AS=0.2856p AD=0.253p PS=2.36u
+ PD=1.53u rfmode=0
M$8 VDD S \$10 VDD sg13_lv_pmos L=0.13u W=1u AS=0.253p AD=0.3325p PS=1.53u
+ PD=1.665u rfmode=0
M$9 \$10 A0 \$3 VDD sg13_lv_pmos L=0.13u W=1u AS=0.3325p AD=0.2225p PS=1.665u
+ PD=1.445u rfmode=0
M$10 \$3 A1 \$11 VDD sg13_lv_pmos L=0.13u W=1u AS=0.2225p AD=0.2975p PS=1.445u
+ PD=1.595u rfmode=0
M$11 \$11 \$2 VDD VDD sg13_lv_pmos L=0.13u W=1u AS=0.2975p AD=0.2198p PS=1.595u
+ PD=1.52u rfmode=0
M$12 VDD \$3 X VDD sg13_lv_pmos L=0.13u W=1.12u AS=0.2198p AD=0.6048p PS=1.52u
+ PD=3.32u rfmode=0
.ENDS sg13cmos5l_mux2_1

.SUBCKT sg13cmos5l_nand3_1 VSS VDD Y B C A
M$1 VSS C \$8 VSS sg13_lv_nmos L=0.13u W=0.74u AS=0.2886p AD=0.1406p PS=2.26u
+ PD=1.12u rfmode=0
M$2 \$8 B \$7 VSS sg13_lv_nmos L=0.13u W=0.74u AS=0.1406p AD=0.1406p PS=1.12u
+ PD=1.12u rfmode=0
M$3 \$7 A Y VSS sg13_lv_nmos L=0.13u W=0.74u AS=0.1406p AD=0.2516p PS=1.12u
+ PD=2.16u rfmode=0
M$4 VDD C Y VDD sg13_lv_pmos L=0.13u W=1.12u AS=0.3808p AD=0.2128p PS=2.92u
+ PD=1.5u rfmode=0
M$5 Y B VDD VDD sg13_lv_pmos L=0.13u W=1.12u AS=0.2128p AD=0.2128p PS=1.5u
+ PD=1.5u rfmode=0
M$6 VDD A Y VDD sg13_lv_pmos L=0.13u W=1.12u AS=0.2128p AD=0.3808p PS=1.5u
+ PD=2.92u rfmode=0
.ENDS sg13cmos5l_nand3_1

.SUBCKT sg13cmos5l_nand4_1 VDD A VSS Y B C D
M$1 VSS D \$10 VSS sg13_lv_nmos L=0.13u W=0.74u AS=0.2516p AD=0.1406p PS=2.16u
+ PD=1.12u rfmode=0
M$2 \$10 C \$9 VSS sg13_lv_nmos L=0.13u W=0.74u AS=0.1406p AD=0.1406p PS=1.12u
+ PD=1.12u rfmode=0
M$3 \$9 B \$8 VSS sg13_lv_nmos L=0.13u W=0.74u AS=0.1406p AD=0.1406p PS=1.12u
+ PD=1.12u rfmode=0
M$4 \$8 A Y VSS sg13_lv_nmos L=0.13u W=0.74u AS=0.1406p AD=0.2516p PS=1.12u
+ PD=2.16u rfmode=0
M$5 VDD D Y VDD sg13_lv_pmos L=0.13u W=1.12u AS=0.3808p AD=0.2128p PS=2.92u
+ PD=1.5u rfmode=0
M$6 Y C VDD VDD sg13_lv_pmos L=0.13u W=1.12u AS=0.2128p AD=0.2128p PS=1.5u
+ PD=1.5u rfmode=0
M$7 VDD B Y VDD sg13_lv_pmos L=0.13u W=1.12u AS=0.2128p AD=0.2128p PS=1.5u
+ PD=1.5u rfmode=0
M$8 Y A VDD VDD sg13_lv_pmos L=0.13u W=1.12u AS=0.2128p AD=0.3808p PS=1.5u
+ PD=2.92u rfmode=0
.ENDS sg13cmos5l_nand4_1

.SUBCKT sg13cmos5l_buf_8 VSS A X VDD
M$1 \$2 A VSS VSS sg13_lv_nmos L=0.13u W=2.22u AS=0.5365p AD=0.4218p PS=4.41u
+ PD=3.36u rfmode=0
M$4 VSS \$2 X VSS sg13_lv_nmos L=0.13u W=5.92u AS=1.1248p AD=1.2358p PS=8.96u
+ PD=10u rfmode=0
M$12 \$2 A VDD VDD sg13_lv_pmos L=0.13u W=3.36u AS=0.8064p AD=0.6384p PS=5.92u
+ PD=4.5u rfmode=0
M$15 VDD \$2 X VDD sg13_lv_pmos L=0.13u W=8.96u AS=1.7024p AD=1.876p PS=12u
+ PD=13.43u rfmode=0
.ENDS sg13cmos5l_buf_8

.SUBCKT sg13cmos5l_a22oi_1 Y VSS VDD A2 B2 B1 A1
M$1 VSS B1 \$10 VSS sg13_lv_nmos L=0.13u W=0.74u AS=0.2553p AD=0.13875p
+ PS=2.17u PD=1.115u rfmode=0
M$2 \$10 B2 Y VSS sg13_lv_nmos L=0.13u W=0.74u AS=0.13875p AD=0.2664p PS=1.115u
+ PD=1.46u rfmode=0
M$3 Y A1 \$9 VSS sg13_lv_nmos L=0.13u W=0.74u AS=0.2664p AD=0.0962p PS=1.46u
+ PD=1u rfmode=0
M$4 \$9 A2 VSS VSS sg13_lv_nmos L=0.13u W=0.74u AS=0.0962p AD=0.2516p PS=1u
+ PD=2.16u rfmode=0
M$5 VDD A1 \$5 VDD sg13_lv_pmos L=0.13u W=1.12u AS=0.3808p AD=0.2716p PS=2.92u
+ PD=1.605u rfmode=0
M$6 \$5 B1 Y VDD sg13_lv_pmos L=0.13u W=1.12u AS=0.2716p AD=0.2128p PS=1.605u
+ PD=1.5u rfmode=0
M$7 Y B2 \$5 VDD sg13_lv_pmos L=0.13u W=1.12u AS=0.2128p AD=0.2744p PS=1.5u
+ PD=1.61u rfmode=0
M$8 \$5 A2 VDD VDD sg13_lv_pmos L=0.13u W=1.12u AS=0.2744p AD=0.3808p PS=1.61u
+ PD=2.92u rfmode=0
.ENDS sg13cmos5l_a22oi_1

.SUBCKT sg13cmos5l_or2_1 A X B VDD VSS
M$1 VSS B \$6 VSS sg13_lv_nmos L=0.13u W=0.55u AS=0.187p AD=0.1045p PS=1.78u
+ PD=0.93u rfmode=0
M$2 \$6 A VSS VSS sg13_lv_nmos L=0.13u W=0.55u AS=0.1045p AD=0.1469p PS=0.93u
+ PD=1.155u rfmode=0
M$3 VSS \$6 X VSS sg13_lv_nmos L=0.13u W=0.74u AS=0.1469p AD=0.2516p PS=1.155u
+ PD=2.16u rfmode=0
M$4 \$6 B \$7 VDD sg13_lv_pmos L=0.13u W=0.84u AS=0.2856p AD=0.1596p PS=2.36u
+ PD=1.22u rfmode=0
M$5 VDD A \$7 VDD sg13_lv_pmos L=0.13u W=0.84u AS=0.2226p AD=0.1596p PS=1.535u
+ PD=1.22u rfmode=0
M$6 VDD \$6 X VDD sg13_lv_pmos L=0.13u W=1.12u AS=0.2226p AD=0.3976p PS=1.535u
+ PD=2.95u rfmode=0
.ENDS sg13cmos5l_or2_1

.SUBCKT sg13cmos5l_nor4_1 VDD VSS B A C D Y
M$1 VSS A Y VSS sg13_lv_nmos L=0.13u W=0.74u AS=0.2516p AD=0.1406p PS=2.16u
+ PD=1.12u rfmode=0
M$2 Y B VSS VSS sg13_lv_nmos L=0.13u W=0.74u AS=0.1406p AD=0.1406p PS=1.12u
+ PD=1.12u rfmode=0
M$3 VSS C Y VSS sg13_lv_nmos L=0.13u W=0.74u AS=0.1406p AD=0.1406p PS=1.12u
+ PD=1.12u rfmode=0
M$4 Y D VSS VSS sg13_lv_nmos L=0.13u W=0.74u AS=0.1406p AD=0.237575p PS=1.12u
+ PD=2.16u rfmode=0
M$5 VDD A \$9 VDD sg13_lv_pmos L=0.13u W=1.12u AS=0.3808p AD=0.2128p PS=2.92u
+ PD=1.5u rfmode=0
M$6 \$9 B \$8 VDD sg13_lv_pmos L=0.13u W=1.12u AS=0.2128p AD=0.2128p PS=1.5u
+ PD=1.5u rfmode=0
M$7 \$8 C \$10 VDD sg13_lv_pmos L=0.13u W=1.12u AS=0.2128p AD=0.2128p PS=1.5u
+ PD=1.5u rfmode=0
M$8 \$10 D Y VDD sg13_lv_pmos L=0.13u W=1.12u AS=0.2128p AD=0.4368p PS=1.5u
+ PD=3.02u rfmode=0
.ENDS sg13cmos5l_nor4_1

.SUBCKT sg13cmos5l_decap_4 VDD VSS
M$1 VSS VDD VSS VSS sg13_lv_nmos L=1u W=0.42u AS=0.1428p AD=0.1428p PS=1.52u
+ PD=1.52u rfmode=0
M$2 VDD VSS VDD VDD sg13_lv_pmos L=1u W=1u AS=0.34p AD=0.34p PS=2.68u PD=2.68u
+ rfmode=0
.ENDS sg13cmos5l_decap_4

.SUBCKT sg13cmos5l_nor2b_1 VSS VDD Y A B_N
M$1 VSS B_N \$5 VSS sg13_lv_nmos L=0.13u W=0.55u AS=0.17255p AD=0.187p PS=1.25u
+ PD=1.78u rfmode=0
M$2 VSS \$5 Y VSS sg13_lv_nmos L=0.13u W=0.74u AS=0.17255p AD=0.1406p PS=1.25u
+ PD=1.12u rfmode=0
M$3 Y A VSS VSS sg13_lv_nmos L=0.13u W=0.74u AS=0.1406p AD=0.2516p PS=1.12u
+ PD=2.16u rfmode=0
M$4 \$5 B_N VDD VDD sg13_lv_pmos L=0.13u W=0.84u AS=0.2856p AD=0.2618p PS=2.36u
+ PD=1.63u rfmode=0
M$5 VDD \$5 \$7 VDD sg13_lv_pmos L=0.13u W=1.12u AS=0.2618p AD=0.1176p PS=1.63u
+ PD=1.33u rfmode=0
M$6 \$7 A Y VDD sg13_lv_pmos L=0.13u W=1.12u AS=0.1176p AD=0.3808p PS=1.33u
+ PD=2.92u rfmode=0
.ENDS sg13cmos5l_nor2b_1

.SUBCKT sg13cmos5l_and2_1 VDD VSS X A B
M$1 \$4 A \$7 VSS sg13_lv_nmos L=0.13u W=0.64u AS=0.2176p AD=0.1216p PS=1.96u
+ PD=1.02u rfmode=0
M$2 VSS B \$7 VSS sg13_lv_nmos L=0.13u W=0.64u AS=0.1331p AD=0.1216p PS=1.12u
+ PD=1.02u rfmode=0
M$3 VSS \$4 X VSS sg13_lv_nmos L=0.13u W=0.74u AS=0.1331p AD=0.2516p PS=1.12u
+ PD=2.16u rfmode=0
M$4 VDD A \$4 VDD sg13_lv_pmos L=0.13u W=0.84u AS=0.2856p AD=0.1596p PS=2.36u
+ PD=1.22u rfmode=0
M$5 VDD B \$4 VDD sg13_lv_pmos L=0.13u W=0.84u AS=0.1918p AD=0.1596p PS=1.5u
+ PD=1.22u rfmode=0
M$6 VDD \$4 X VDD sg13_lv_pmos L=0.13u W=1.12u AS=0.1918p AD=0.3808p PS=1.5u
+ PD=2.92u rfmode=0
.ENDS sg13cmos5l_and2_1

.SUBCKT sg13cmos5l_or3_1 VDD VSS C A B X
M$1 \$6 C VSS VSS sg13_lv_nmos L=0.13u W=0.55u AS=0.187p AD=0.1045p PS=1.78u
+ PD=0.93u rfmode=0
M$2 VSS B \$6 VSS sg13_lv_nmos L=0.13u W=0.55u AS=0.1045p AD=0.198p PS=0.93u
+ PD=1.27u rfmode=0
M$3 \$6 A VSS VSS sg13_lv_nmos L=0.13u W=0.55u AS=0.198p AD=0.13395p PS=1.27u
+ PD=1.12u rfmode=0
M$4 VSS \$6 X VSS sg13_lv_nmos L=0.13u W=0.74u AS=0.13395p AD=0.2516p PS=1.12u
+ PD=2.16u rfmode=0
M$5 \$6 C \$9 VDD sg13_lv_pmos L=0.13u W=1u AS=0.34p AD=0.19p PS=2.68u PD=1.38u
+ rfmode=0
M$6 \$9 B \$8 VDD sg13_lv_pmos L=0.13u W=1u AS=0.19p AD=0.1575p PS=1.38u
+ PD=1.315u rfmode=0
M$7 \$8 A VDD VDD sg13_lv_pmos L=0.13u W=1u AS=0.1575p AD=0.3822p PS=1.315u
+ PD=1.84u rfmode=0
M$8 VDD \$6 X VDD sg13_lv_pmos L=0.13u W=1.12u AS=0.3822p AD=0.3808p PS=1.84u
+ PD=2.92u rfmode=0
.ENDS sg13cmos5l_or3_1

.SUBCKT sg13cmos5l_nand2_1 VDD VSS Y A B
M$1 VSS B \$6 VSS sg13_lv_nmos L=0.13u W=0.74u AS=0.2516p AD=0.1406p PS=2.16u
+ PD=1.12u rfmode=0
M$2 \$6 A Y VSS sg13_lv_nmos L=0.13u W=0.74u AS=0.1406p AD=0.2516p PS=1.12u
+ PD=2.16u rfmode=0
M$3 VDD B Y VDD sg13_lv_pmos L=0.13u W=1.12u AS=0.3808p AD=0.2128p PS=2.92u
+ PD=1.5u rfmode=0
M$4 Y A VDD VDD sg13_lv_pmos L=0.13u W=1.12u AS=0.2128p AD=0.3808p PS=1.5u
+ PD=2.92u rfmode=0
.ENDS sg13cmos5l_nand2_1

.SUBCKT sg13cmos5l_decap_8 VDD VSS
M$1 VSS VDD VSS VSS sg13_lv_nmos L=1u W=0.84u AS=0.2226p AD=0.2226p PS=2.32u
+ PD=2.32u rfmode=0
M$3 VDD VSS VDD VDD sg13_lv_pmos L=1u W=2u AS=0.53p AD=0.53p PS=4.06u PD=4.06u
+ rfmode=0
.ENDS sg13cmos5l_decap_8

.SUBCKT sg13cmos5l_a221oi_1 VSS B1 VDD Y B2 C1 A1 A2
M$1 Y A1 \$11 VSS sg13_lv_nmos L=0.13u W=0.74u AS=0.2516p AD=0.1406p PS=2.16u
+ PD=1.12u rfmode=0
M$2 \$11 A2 VSS VSS sg13_lv_nmos L=0.13u W=0.74u AS=0.1406p AD=0.2516p PS=1.12u
+ PD=2.16u rfmode=0
M$3 Y C1 VSS VSS sg13_lv_nmos L=0.13u W=0.74u AS=0.2516p AD=0.1406p PS=2.16u
+ PD=1.12u rfmode=0
M$4 VSS B2 \$12 VSS sg13_lv_nmos L=0.13u W=0.74u AS=0.1406p AD=0.1406p PS=1.12u
+ PD=1.12u rfmode=0
M$5 \$12 B1 Y VSS sg13_lv_nmos L=0.13u W=0.74u AS=0.1406p AD=0.2516p PS=1.12u
+ PD=2.16u rfmode=0
M$6 VDD A1 \$9 VDD sg13_lv_pmos L=0.13u W=1.12u AS=0.3808p AD=0.2128p PS=2.92u
+ PD=1.5u rfmode=0
M$7 \$9 A2 VDD VDD sg13_lv_pmos L=0.13u W=1.12u AS=0.2128p AD=0.3808p PS=1.5u
+ PD=2.92u rfmode=0
M$8 Y C1 \$6 VDD sg13_lv_pmos L=0.13u W=1.12u AS=0.3808p AD=0.2128p PS=2.92u
+ PD=1.5u rfmode=0
M$9 \$6 B2 \$9 VDD sg13_lv_pmos L=0.13u W=1.12u AS=0.2128p AD=0.2128p PS=1.5u
+ PD=1.5u rfmode=0
M$10 \$9 B1 \$6 VDD sg13_lv_pmos L=0.13u W=1.12u AS=0.2128p AD=0.3808p PS=1.5u
+ PD=2.92u rfmode=0
.ENDS sg13cmos5l_a221oi_1

.SUBCKT sg13cmos5l_xnor2_1 VDD VSS Y B A
M$1 VSS A \$8 VSS sg13_lv_nmos L=0.13u W=0.64u AS=0.2272p AD=0.0784p PS=1.99u
+ PD=0.885u rfmode=0
M$2 \$8 B \$7 VSS sg13_lv_nmos L=0.13u W=0.64u AS=0.0784p AD=0.2176p PS=0.885u
+ PD=1.96u rfmode=0
M$3 VSS A \$3 VSS sg13_lv_nmos L=0.13u W=0.74u AS=0.1898p AD=0.2516p PS=1.36u
+ PD=2.16u rfmode=0
M$4 VSS B \$3 VSS sg13_lv_nmos L=0.13u W=0.74u AS=0.1898p AD=0.1406p PS=1.36u
+ PD=1.12u rfmode=0
M$5 \$3 \$7 Y VSS sg13_lv_nmos L=0.13u W=0.74u AS=0.1406p AD=0.2516p PS=1.12u
+ PD=2.16u rfmode=0
M$6 VDD A \$7 VDD sg13_lv_pmos L=0.13u W=0.84u AS=0.4536p AD=0.1596p PS=2.76u
+ PD=1.22u rfmode=0
M$7 VDD B \$7 VDD sg13_lv_pmos L=0.13u W=0.84u AS=0.2891p AD=0.1596p PS=1.695u
+ PD=1.22u rfmode=0
M$8 VDD A \$9 VDD sg13_lv_pmos L=0.13u W=1.12u AS=0.2891p AD=0.1428p PS=1.695u
+ PD=1.375u rfmode=0
M$9 \$9 B Y VDD sg13_lv_pmos L=0.13u W=1.12u AS=0.1428p AD=0.2408p PS=1.375u
+ PD=1.55u rfmode=0
M$10 Y \$7 VDD VDD sg13_lv_pmos L=0.13u W=1.12u AS=0.2408p AD=0.3808p PS=1.55u
+ PD=2.92u rfmode=0
.ENDS sg13cmos5l_xnor2_1

.SUBCKT sg13cmos5l_nor3_1 VDD VSS C Y B A
M$1 VSS A Y VSS sg13_lv_nmos L=0.13u W=0.77u AS=0.2618p AD=0.1694p PS=2.22u
+ PD=1.21u rfmode=0
M$2 Y B VSS VSS sg13_lv_nmos L=0.13u W=0.77u AS=0.1694p AD=0.1463p PS=1.21u
+ PD=1.15u rfmode=0
M$3 VSS C Y VSS sg13_lv_nmos L=0.13u W=0.77u AS=0.1463p AD=0.2618p PS=1.15u
+ PD=2.22u rfmode=0
M$4 VDD A \$8 VDD sg13_lv_pmos L=0.13u W=1.12u AS=0.3808p AD=0.2464p PS=2.92u
+ PD=1.56u rfmode=0
M$5 \$8 B \$7 VDD sg13_lv_pmos L=0.13u W=1.12u AS=0.2464p AD=0.2128p PS=1.56u
+ PD=1.5u rfmode=0
M$6 \$7 C Y VDD sg13_lv_pmos L=0.13u W=1.12u AS=0.2128p AD=0.3808p PS=1.5u
+ PD=2.92u rfmode=0
.ENDS sg13cmos5l_nor3_1

.SUBCKT sg13cmos5l_dfrbpq_1 VSS RESET_B Q D CLK VDD
M$1 VSS \$4 \$18 VSS sg13_lv_nmos L=0.13u W=0.74u AS=0.317325p AD=0.2516p
+ PS=1.805u PD=2.16u rfmode=0
M$2 VSS CLK \$4 VSS sg13_lv_nmos L=0.13u W=0.74u AS=0.317325p AD=0.2516p
+ PS=1.805u PD=2.16u rfmode=0
M$3 \$14 \$4 \$7 VSS sg13_lv_nmos L=0.13u W=0.42u AS=0.12665p AD=0.1428p
+ PS=1.145u PD=1.52u rfmode=0
M$4 \$3 \$18 \$14 VSS sg13_lv_nmos L=0.13u W=0.74u AS=0.3473p AD=0.12665p
+ PS=2.71u PD=1.145u rfmode=0
M$5 \$5 D \$15 VSS sg13_lv_nmos L=0.13u W=0.42u AS=0.1428p AD=0.0609p PS=1.52u
+ PD=0.71u rfmode=0
M$6 \$15 RESET_B VSS VSS sg13_lv_nmos L=0.13u W=0.42u AS=0.0609p AD=0.1626p
+ PS=0.71u PD=1.415u rfmode=0
M$7 VSS \$12 \$3 VSS sg13_lv_nmos L=0.13u W=0.74u AS=0.1626p AD=0.2516p
+ PS=1.415u PD=2.16u rfmode=0
M$8 \$9 \$14 VSS VSS sg13_lv_nmos L=0.13u W=0.74u AS=0.2516p AD=0.1406p
+ PS=2.16u PD=1.12u rfmode=0
M$9 VSS \$9 Q VSS sg13_lv_nmos L=0.13u W=0.74u AS=0.1406p AD=0.2516p PS=1.12u
+ PD=2.16u rfmode=0
M$10 \$5 \$4 \$12 VSS sg13_lv_nmos L=0.13u W=0.42u AS=0.1296p AD=0.0798p
+ PS=1.52u PD=0.8u rfmode=0
M$11 \$12 \$18 \$6 VSS sg13_lv_nmos L=0.13u W=0.42u AS=0.0798p AD=0.2373p
+ PS=0.8u PD=1.97u rfmode=0
M$12 \$7 \$8 VSS VSS sg13_lv_nmos L=0.13u W=0.42u AS=0.1428p AD=0.0798p
+ PS=1.52u PD=0.8u rfmode=0
M$13 VSS RESET_B \$17 VSS sg13_lv_nmos L=0.13u W=0.42u AS=0.0798p AD=0.0378p
+ PS=0.8u PD=0.6u rfmode=0
M$14 \$17 \$14 \$8 VSS sg13_lv_nmos L=0.13u W=0.42u AS=0.0378p AD=0.1428p
+ PS=0.6u PD=1.52u rfmode=0
M$15 VSS RESET_B \$16 VSS sg13_lv_nmos L=0.13u W=0.42u AS=0.1701p AD=0.0378p
+ PS=1.65u PD=0.6u rfmode=0
M$16 \$16 \$3 \$6 VSS sg13_lv_nmos L=0.13u W=0.42u AS=0.0378p AD=0.1428p
+ PS=0.6u PD=1.52u rfmode=0
M$17 \$9 \$14 VDD VDD sg13_lv_pmos L=0.13u W=1.12u AS=0.3864p AD=0.2128p
+ PS=2.93u PD=1.5u rfmode=0
M$18 VDD \$9 Q VDD sg13_lv_pmos L=0.13u W=1.12u AS=0.2128p AD=0.3808p PS=1.5u
+ PD=2.92u rfmode=0
M$19 \$14 \$18 \$21 VDD sg13_lv_pmos L=0.13u W=0.42u AS=0.2048p AD=0.09345p
+ PS=1.63u PD=0.865u rfmode=0
M$20 \$21 \$8 VDD VDD sg13_lv_pmos L=0.13u W=0.42u AS=0.09345p AD=0.204p
+ PS=0.865u PD=1.835u rfmode=0
M$21 VDD RESET_B \$8 VDD sg13_lv_pmos L=0.13u W=0.42u AS=0.204p AD=0.0798p
+ PS=1.835u PD=0.8u rfmode=0
M$22 \$8 \$14 VDD VDD sg13_lv_pmos L=0.13u W=0.42u AS=0.0798p AD=0.4659p
+ PS=0.8u PD=3.65u rfmode=0
M$23 \$3 \$4 \$14 VDD sg13_lv_pmos L=0.13u W=1u AS=0.34p AD=0.2048p PS=2.68u
+ PD=1.63u rfmode=0
M$24 VDD D \$5 VDD sg13_lv_pmos L=0.13u W=0.42u AS=0.1428p AD=0.0798p PS=1.52u
+ PD=0.8u rfmode=0
M$25 VDD RESET_B \$5 VDD sg13_lv_pmos L=0.13u W=0.42u AS=0.3623875p AD=0.0798p
+ PS=2.605u PD=0.8u rfmode=0
M$26 VDD \$12 \$3 VDD sg13_lv_pmos L=0.13u W=1u AS=0.3623875p AD=0.34p
+ PS=2.605u PD=2.68u rfmode=0
M$27 \$12 RESET_B VDD VDD sg13_lv_pmos L=0.13u W=0.42u AS=0.147p AD=0.1563p
+ PS=1.54u PD=1.22u rfmode=0
M$28 VDD \$3 \$20 VDD sg13_lv_pmos L=0.13u W=0.42u AS=0.1563p AD=0.063p
+ PS=1.22u PD=0.72u rfmode=0
M$29 \$20 \$4 \$12 VDD sg13_lv_pmos L=0.13u W=0.42u AS=0.063p AD=0.0798p
+ PS=0.72u PD=0.8u rfmode=0
M$30 \$12 \$18 \$5 VDD sg13_lv_pmos L=0.13u W=0.42u AS=0.0798p AD=0.1428p
+ PS=0.8u PD=1.52u rfmode=0
M$31 \$18 \$4 VDD VDD sg13_lv_pmos L=0.13u W=1.12u AS=0.3864p AD=0.41165p
+ PS=2.93u PD=2.12u rfmode=0
M$32 VDD CLK \$4 VDD sg13_lv_pmos L=0.13u W=1.12u AS=0.41165p AD=0.4088p
+ PS=2.12u PD=2.97u rfmode=0
.ENDS sg13cmos5l_dfrbpq_1

.SUBCKT sg13cmos5l_o21ai_1 VSS Y VDD B1 A2 A1
M$1 \$2 A1 VSS VSS sg13_lv_nmos L=0.15u W=0.74u AS=0.2516p AD=0.1406p PS=2.16u
+ PD=1.12u rfmode=0
M$2 VSS A2 \$2 VSS sg13_lv_nmos L=0.15u W=0.74u AS=0.1406p AD=0.1406p PS=1.12u
+ PD=1.12u rfmode=0
M$3 \$2 B1 Y VSS sg13_lv_nmos L=0.15u W=0.74u AS=0.1406p AD=0.2516p PS=1.12u
+ PD=2.16u rfmode=0
M$4 VDD A1 \$8 VDD sg13_lv_pmos L=0.15u W=1.12u AS=0.3808p AD=0.2128p PS=2.92u
+ PD=1.5u rfmode=0
M$5 \$8 A2 Y VDD sg13_lv_pmos L=0.15u W=1.12u AS=0.2128p AD=0.2128p PS=1.5u
+ PD=1.5u rfmode=0
M$6 Y B1 VDD VDD sg13_lv_pmos L=0.15u W=1.12u AS=0.2128p AD=0.3808p PS=1.5u
+ PD=2.92u rfmode=0
.ENDS sg13cmos5l_o21ai_1

.SUBCKT sg13cmos5l_nand3b_1 VDD VSS Y B C A_N
M$1 VSS A_N \$6 VSS sg13_lv_nmos L=0.13u W=0.55u AS=0.18575p AD=0.187p PS=1.26u
+ PD=1.78u rfmode=0
M$2 VSS C \$9 VSS sg13_lv_nmos L=0.13u W=0.74u AS=0.18575p AD=0.1406p PS=1.26u
+ PD=1.12u rfmode=0
M$3 \$9 B \$8 VSS sg13_lv_nmos L=0.13u W=0.74u AS=0.1406p AD=0.1406p PS=1.12u
+ PD=1.12u rfmode=0
M$4 \$8 \$6 Y VSS sg13_lv_nmos L=0.13u W=0.74u AS=0.1406p AD=0.3404p PS=1.12u
+ PD=2.4u rfmode=0
M$5 \$6 A_N VDD VDD sg13_lv_pmos L=0.13u W=0.84u AS=0.2856p AD=0.2198p PS=2.36u
+ PD=1.53u rfmode=0
M$6 VDD C Y VDD sg13_lv_pmos L=0.13u W=1.12u AS=0.2198p AD=0.2128p PS=1.53u
+ PD=1.5u rfmode=0
M$7 Y B VDD VDD sg13_lv_pmos L=0.13u W=1.12u AS=0.2128p AD=0.2128p PS=1.5u
+ PD=1.5u rfmode=0
M$8 VDD \$6 Y VDD sg13_lv_pmos L=0.13u W=1.12u AS=0.2128p AD=0.3808p PS=1.5u
+ PD=2.92u rfmode=0
.ENDS sg13cmos5l_nand3b_1

.SUBCKT sg13cmos5l_inv_1 VDD VSS A Y
M$1 VSS A Y VSS sg13_lv_nmos L=0.13u W=0.74u AS=0.2516p AD=0.2516p PS=2.16u
+ PD=2.16u rfmode=0
M$2 VDD A Y VDD sg13_lv_pmos L=0.13u W=1.12u AS=0.3808p AD=0.3808p PS=2.92u
+ PD=2.92u rfmode=0
.ENDS sg13cmos5l_inv_1

.SUBCKT sg13cmos5l_nor2_1 VDD VSS B A Y
M$1 VSS A Y VSS sg13_lv_nmos L=0.13u W=0.74u AS=0.2516p AD=0.1406p PS=2.16u
+ PD=1.12u rfmode=0
M$2 Y B VSS VSS sg13_lv_nmos L=0.13u W=0.74u AS=0.1406p AD=0.2516p PS=1.12u
+ PD=2.16u rfmode=0
M$3 VDD A \$6 VDD sg13_lv_pmos L=0.13u W=1.12u AS=0.4032p AD=0.1176p PS=2.96u
+ PD=1.33u rfmode=0
M$4 \$6 B Y VDD sg13_lv_pmos L=0.13u W=1.12u AS=0.1176p AD=0.3808p PS=1.33u
+ PD=2.92u rfmode=0
.ENDS sg13cmos5l_nor2_1

.SUBCKT sg13cmos5l_dlygate4sd3_1 VDD VSS X A
M$1 VSS \$5 \$4 VSS sg13_lv_nmos L=0.5u W=0.42u AS=0.1426p AD=0.1428p PS=1.16u
+ PD=1.52u rfmode=0
M$2 VSS \$4 X VSS sg13_lv_nmos L=0.13u W=0.74u AS=0.1426p AD=0.2516p PS=1.16u
+ PD=2.16u rfmode=0
M$3 \$6 A VSS VSS sg13_lv_nmos L=0.13u W=0.42u AS=0.1428p AD=0.0798p PS=1.52u
+ PD=0.8u rfmode=0
M$4 VSS \$6 \$5 VSS sg13_lv_nmos L=0.5u W=0.42u AS=0.0798p AD=0.1428p PS=0.8u
+ PD=1.52u rfmode=0
M$5 \$4 \$5 VDD VDD sg13_lv_pmos L=0.5u W=1u AS=0.34p AD=0.2254p PS=2.68u
+ PD=1.53u rfmode=0
M$6 VDD \$4 X VDD sg13_lv_pmos L=0.13u W=1.12u AS=0.2254p AD=0.4256p PS=1.53u
+ PD=3u rfmode=0
M$7 VDD A \$6 VDD sg13_lv_pmos L=0.13u W=0.42u AS=0.1523p AD=0.1428p PS=1.38u
+ PD=1.52u rfmode=0
M$8 VDD \$6 \$5 VDD sg13_lv_pmos L=0.5u W=1u AS=0.1523p AD=0.34p PS=1.38u
+ PD=2.68u rfmode=0
.ENDS sg13cmos5l_dlygate4sd3_1

.SUBCKT sg13cmos5l_and3_1 VDD VSS A C B X
M$1 \$7 A \$9 VSS sg13_lv_nmos L=0.13u W=0.64u AS=0.2176p AD=0.1216p PS=1.96u
+ PD=1.02u rfmode=0
M$2 \$9 B \$8 VSS sg13_lv_nmos L=0.13u W=0.64u AS=0.1216p AD=0.1216p PS=1.02u
+ PD=1.02u rfmode=0
M$3 VSS C \$8 VSS sg13_lv_nmos L=0.13u W=0.64u AS=0.1371p AD=0.1216p PS=1.12u
+ PD=1.02u rfmode=0
M$4 VSS \$7 X VSS sg13_lv_nmos L=0.13u W=0.74u AS=0.1371p AD=0.2516p PS=1.12u
+ PD=2.16u rfmode=0
M$5 \$7 A VDD VDD sg13_lv_pmos L=0.13u W=0.84u AS=0.2856p AD=0.1596p PS=2.36u
+ PD=1.22u rfmode=0
M$6 VDD B \$7 VDD sg13_lv_pmos L=0.13u W=0.84u AS=0.1596p AD=0.1596p PS=1.22u
+ PD=1.22u rfmode=0
M$7 VDD C \$7 VDD sg13_lv_pmos L=0.13u W=0.84u AS=0.36195p AD=0.1596p PS=1.84u
+ PD=1.22u rfmode=0
M$8 VDD \$7 X VDD sg13_lv_pmos L=0.13u W=1.12u AS=0.36195p AD=0.3808p PS=1.84u
+ PD=2.92u rfmode=0
.ENDS sg13cmos5l_and3_1

.SUBCKT sg13cmos5l_a21oi_1 Y VSS A2 VDD A1 B1
M$1 VSS B1 Y VSS sg13_lv_nmos L=0.13u W=0.74u AS=0.2516p AD=0.1406p PS=2.16u
+ PD=1.12u rfmode=0
M$2 Y A1 \$8 VSS sg13_lv_nmos L=0.13u W=0.74u AS=0.1406p AD=0.1406p PS=1.12u
+ PD=1.12u rfmode=0
M$3 \$8 A2 VSS VSS sg13_lv_nmos L=0.13u W=0.74u AS=0.1406p AD=0.2516p PS=1.12u
+ PD=2.16u rfmode=0
M$4 Y B1 \$3 VDD sg13_lv_pmos L=0.13u W=1.12u AS=0.3808p AD=0.2128p PS=2.92u
+ PD=1.5u rfmode=0
M$5 \$3 A1 VDD VDD sg13_lv_pmos L=0.13u W=1.12u AS=0.2128p AD=0.2128p PS=1.5u
+ PD=1.5u rfmode=0
M$6 VDD A2 \$3 VDD sg13_lv_pmos L=0.13u W=1.12u AS=0.2128p AD=0.3808p PS=1.5u
+ PD=2.92u rfmode=0
.ENDS sg13cmos5l_a21oi_1

.SUBCKT sg13cmos5l_buf_1 VSS X VDD A
M$1 VSS A \$1 VSS sg13_lv_nmos L=0.13u W=0.55u AS=0.14875p AD=0.187p PS=1.16u
+ PD=1.78u rfmode=0
M$2 VSS \$1 X VSS sg13_lv_nmos L=0.13u W=0.74u AS=0.14875p AD=0.2886p PS=1.16u
+ PD=2.26u rfmode=0
M$3 VDD A \$1 VDD sg13_lv_pmos L=0.13u W=0.84u AS=0.2114p AD=0.2856p PS=1.54u
+ PD=2.36u rfmode=0
M$4 VDD \$1 X VDD sg13_lv_pmos L=0.13u W=1.12u AS=0.2114p AD=0.42p PS=1.54u
+ PD=2.99u rfmode=0
.ENDS sg13cmos5l_buf_1

.SUBCKT sg13cmos5l_a21o_1 VDD VSS X B1 A1 A2
M$1 X \$6 VSS VSS sg13_lv_nmos L=0.13u W=0.74u AS=0.2351p AD=0.15745p PS=2.16u
+ PD=1.175u rfmode=0
M$2 VSS B1 \$6 VSS sg13_lv_nmos L=0.13u W=0.64u AS=0.15745p AD=0.1216p
+ PS=1.175u PD=1.02u rfmode=0
M$3 \$6 A1 \$9 VSS sg13_lv_nmos L=0.13u W=0.64u AS=0.1216p AD=0.0816p PS=1.02u
+ PD=0.895u rfmode=0
M$4 \$9 A2 VSS VSS sg13_lv_nmos L=0.13u W=0.64u AS=0.0816p AD=0.2176p PS=0.895u
+ PD=1.96u rfmode=0
M$5 \$6 B1 \$5 VDD sg13_lv_pmos L=0.13u W=1u AS=0.35p AD=0.2125p PS=2.7u
+ PD=1.425u rfmode=0
M$6 \$5 A1 VDD VDD sg13_lv_pmos L=0.13u W=1u AS=0.2125p AD=0.19p PS=1.425u
+ PD=1.38u rfmode=0
M$7 VDD A2 \$5 VDD sg13_lv_pmos L=0.13u W=1u AS=0.19p AD=0.34p PS=1.38u
+ PD=2.68u rfmode=0
M$8 X \$6 VDD VDD sg13_lv_pmos L=0.13u W=1.12u AS=0.3808p AD=0.3808p PS=2.92u
+ PD=2.92u rfmode=0
.ENDS sg13cmos5l_a21o_1

.SUBCKT sg13cmos5l_nand2b_1 VDD VSS B A_N Y
M$1 VSS A_N \$6 VSS sg13_lv_nmos L=0.13u W=0.55u AS=0.14505p AD=0.187p PS=1.15u
+ PD=1.78u rfmode=0
M$2 VSS B \$7 VSS sg13_lv_nmos L=0.13u W=0.74u AS=0.14505p AD=0.1406p PS=1.15u
+ PD=1.12u rfmode=0
M$3 \$7 \$6 Y VSS sg13_lv_nmos L=0.13u W=0.74u AS=0.1406p AD=0.333p PS=1.12u
+ PD=2.38u rfmode=0
M$4 \$6 A_N VDD VDD sg13_lv_pmos L=0.13u W=0.84u AS=0.2856p AD=0.2198p PS=2.36u
+ PD=1.53u rfmode=0
M$5 VDD B Y VDD sg13_lv_pmos L=0.13u W=1.12u AS=0.2198p AD=0.2128p PS=1.53u
+ PD=1.5u rfmode=0
M$6 Y \$6 VDD VDD sg13_lv_pmos L=0.13u W=1.12u AS=0.2128p AD=0.3808p PS=1.5u
+ PD=2.92u rfmode=0
.ENDS sg13cmos5l_nand2b_1

.SUBCKT sg13cmos5l_xor2_1 VSS X VDD B A
M$1 VSS A \$1 VSS sg13_lv_nmos L=0.13u W=0.55u AS=0.374p AD=0.174625p PS=2.46u
+ PD=1.185u rfmode=0
M$2 VSS B \$1 VSS sg13_lv_nmos L=0.13u W=0.55u AS=0.15245p AD=0.174625p
+ PS=1.17u PD=1.185u rfmode=0
M$3 VSS A \$8 VSS sg13_lv_nmos L=0.13u W=0.74u AS=0.15245p AD=0.0888p PS=1.17u
+ PD=0.98u rfmode=0
M$4 \$8 B X VSS sg13_lv_nmos L=0.13u W=0.74u AS=0.0888p AD=0.1628p PS=0.98u
+ PD=1.18u rfmode=0
M$5 X \$1 VSS VSS sg13_lv_nmos L=0.13u W=0.74u AS=0.1628p AD=0.3108p PS=1.18u
+ PD=2.32u rfmode=0
M$6 \$3 A VDD VDD sg13_lv_pmos L=0.13u W=1.12u AS=0.3808p AD=0.2128p PS=2.92u
+ PD=1.5u rfmode=0
M$7 VDD B \$3 VDD sg13_lv_pmos L=0.13u W=1.12u AS=0.2128p AD=0.2128p PS=1.5u
+ PD=1.5u rfmode=0
M$8 \$3 \$1 X VDD sg13_lv_pmos L=0.13u W=1.12u AS=0.2128p AD=0.3808p PS=1.5u
+ PD=2.92u rfmode=0
M$9 VDD A \$9 VDD sg13_lv_pmos L=0.13u W=1u AS=0.36p AD=0.1225p PS=2.72u
+ PD=1.245u rfmode=0
M$10 \$9 B \$1 VDD sg13_lv_pmos L=0.13u W=1u AS=0.1225p AD=0.34p PS=1.245u
+ PD=2.68u rfmode=0
.ENDS sg13cmos5l_xor2_1
