** sch_path: /home/belal/HeiChips/heichips26-on-off/macros/heichips26_ook_top/schematic/xschem/ook_analgo_system.sch
.subckt ook_analgo_system

.ends
