** sch_path: /home/belal/HeiChips/heichips26-on-off/macros/heichips26_ook_top/schematic/xschem/heichips26_ook_top.sch
.subckt heichips26_ook_top ena uio_out[5] uio_oe[7] ui_in[7] uio_oe[6] uio_out[4] ui_in[6] uio_out[3] uio_oe[5] uio_out[2]
+ uio_oe[4] ui_in[5] ui_in[4] uio_oe[3] uio_out[1] uio_out[0] uio_oe[2] ui_in[3] VPWR VAPWR ui_in[2] uio_oe[1] uo_out[7] analog_2 analog_1
+ analog_0 uo_out[3] uo_out[2] uo_out[1] uo_out[0] ui_in[1] uo_out[6] uio_oe[0] rst_n clk ui_in[0] uo_out[5] uio_out[7] VGND uio_out[6]
+ uo_out[4] uio_in[7] uio_in[6] uio_in[5] uio_in[4] uio_in[3] uio_in[2] uio_in[1] uio_in[0]
*.PININFO VPWR:B VGND:B VAPWR:B analog_2:B analog_1:B analog_0:B uo_out[1]:O uo_out[2]:O uo_out[3]:O rst_n:I clk:I ui_in[0]:I
*+ uo_out[4]:O uo_out[5]:O uo_out[6]:O uo_out[7]:O uio_out[0]:O uio_out[1]:O uio_out[2]:O uio_out[3]:O uio_out[4]:O uio_out[5]:O uio_out[6]:O
*+ uio_out[7]:O uio_oe[0]:O uio_oe[1]:O uio_oe[2]:O uio_oe[3]:O uio_oe[4]:O uio_oe[5]:O uio_oe[6]:O uio_oe[7]:O ui_in[1]:I ui_in[2]:I ui_in[3]:I
*+ ui_in[4]:I ui_in[5]:I ui_in[6]:I ui_in[7]:I uo_out[0]:O ena:I
x1 VAPWR VPWR VGND analog_2 analog_1 analog_0 net1 net2 net3 net4 net5 net6 net7 net8 uo_out[3] uo_out[2] uo_out[1] uo_out[0]
+ rst_n clk ui_in[0] tie_off net9 heichips26_ook_soc
XR1 tie_off uio_out[5] VGND rsil w=0.5e-6 l=0.5e-6 m=1 mm_ok=1
XR2 tie_off uio_out[4] VGND rsil w=0.5e-6 l=0.5e-6 m=1 mm_ok=1
XR3 tie_off uio_out[3] VGND rsil w=0.5e-6 l=0.5e-6 m=1 mm_ok=1
XR4 tie_off uio_out[2] VGND rsil w=0.5e-6 l=0.5e-6 m=1 mm_ok=1
XR5 tie_off uio_out[1] VGND rsil w=0.5e-6 l=0.5e-6 m=1 mm_ok=1
XR6 tie_off uio_out[0] VGND rsil w=0.5e-6 l=0.5e-6 m=1 mm_ok=1
XR7 tie_off uo_out[7] VGND rsil w=0.5e-6 l=0.5e-6 m=1 mm_ok=1
XR8 tie_off uo_out[6] VGND rsil w=0.5e-6 l=0.5e-6 m=1 mm_ok=1
XR9 tie_off uo_out[5] VGND rsil w=0.5e-6 l=0.5e-6 m=1 mm_ok=1
XR10 tie_off uo_out[4] VGND rsil w=0.5e-6 l=0.5e-6 m=1 mm_ok=1
XR11 tie_off uio_out[6] VGND rsil w=0.5e-6 l=0.5e-6 m=1 mm_ok=1
XR12 tie_off uio_out[7] VGND rsil w=0.5e-6 l=0.5e-6 m=1 mm_ok=1
XR13 tie_off uio_oe[0] VGND rsil w=0.5e-6 l=0.5e-6 m=1 mm_ok=1
XR14 tie_off uio_oe[1] VGND rsil w=0.5e-6 l=0.5e-6 m=1 mm_ok=1
XR15 tie_off uio_oe[2] VGND rsil w=0.5e-6 l=0.5e-6 m=1 mm_ok=1
XR16 tie_off uio_oe[3] VGND rsil w=0.5e-6 l=0.5e-6 m=1 mm_ok=1
XR17 tie_off uio_oe[4] VGND rsil w=0.5e-6 l=0.5e-6 m=1 mm_ok=1
XR18 tie_off uio_oe[5] VGND rsil w=0.5e-6 l=0.5e-6 m=1 mm_ok=1
XR19 tie_off uio_oe[6] VGND rsil w=0.5e-6 l=0.5e-6 m=1 mm_ok=1
XR20 tie_off uio_oe[7] VGND rsil w=0.5e-6 l=0.5e-6 m=1 mm_ok=1
.ends

* expanding   symbol:  heichips26_ook_soc.sym # of pins=23
** sym_path: /home/belal/HeiChips/heichips26-on-off/macros/heichips26_ook_top/schematic/xschem/heichips26_ook_soc.sym
** sch_path: /home/belal/HeiChips/heichips26-on-off/macros/heichips26_ook_top/schematic/xschem/heichips26_ook_soc.sch
.subckt heichips26_ook_soc VAPWR VPWR VGND analog_2 analog_1 analog_0 rst_n clk_ref vctrl_in vctrl_b_in q0 q1 q2 q3 q3_d q2_d q1_d
+ q0_d rst_n_in clk data_in_tx in_tieoff in_tieon
*.PININFO VPWR:B VGND:B VAPWR:B analog_2:B analog_1:B analog_0:B q0:B q1:B q2:B q3:B vctrl_in:B vctrl_b_in:B rst_n:B clk_ref:B
*+ in_tieon:O q0_d:O q1_d:O q2_d:O q3_d:O in_tieoff:O data_in_tx:I clk:I rst_n_in:I
x2 VAPWR net1 VPWR q3 q2 analog_0 analog_2 q1 q0 vctrl_in net2 vctrl_b_in net3 analog_1 net4 net5 net6 net7 net8 clk_ref net9
+ net10 rst_n net11 VGND net12 net13 net14 net15 ook_analog_system
x1 VGND VPWR clk clk_ref data_in_tx in_tieoff in_tieon q0 q0_d q1 q1_d q2 q2_d q3 q3_d rst_n rst_n_in vctrl_in vctrl_b_in
+ ook_digital_system
.ends

* expanding   symbol:  ook_analog_system.sym # of pins=29
** sym_path: /home/belal/HeiChips/heichips26-on-off/macros/heichips26_ook_top/macros/ook_analog_system/schematic/xschem/ook_analog_system.sym
** sch_path: /home/belal/HeiChips/heichips26-on-off/macros/heichips26_ook_top/macros/ook_analog_system/schematic/xschem/ook_analog_system.sch
.subckt ook_analog_system VAPWR vcl VPWR q3 q2 tx_out rx_in q1 q0 vctrl_in vctrl_b_out vctrl_b_in vctrl_out ACC_CAP Cap_M2 Cap_M1
+ Cap_M21 Cap_M11 vref0 clk_ref vref1 clk_fb rst_ni dac_out VGND vref2 vref3 opm lnaf
*.PININFO tx_out:B VPWR:B VGND:B vcl:B dac_out:B clk_fb:B clk_ref:B rst_ni:B vctrl_in:B vctrl_b_in:B vctrl_out:B vctrl_b_out:B
*+ q0:B q1:B q2:B q3:B ACC_CAP:B rx_in:B VAPWR:B Cap_M2:B Cap_M1:B Cap_M21:B Cap_M11:B vref0:B vref1:B vref3:B vref2:B opm:B lnaf:B
x1 clk_ref rst_ni vctrl_in vctrl_b_in dac_out clk_fb vcl VGND VPWR tx_out vctrl_out vctrl_b_out ook_transmitter
x2 VPWR opm q0 vref0 q1 vref1 ACC_CAP q2 vref2 vref3 q3 VAPWR Cap_M11 Cap_M21 Cap_M1 Cap_M2 rx_in VGND lnaf ook_receiver
.ends

* expanding   symbol:  ook_transmitter.sym # of pins=12
** sym_path: /home/belal/HeiChips/heichips26-on-off/macros/heichips26_ook_top/macros/ook_analog_system/schematic/xschem/ook_transmitter.sym
** sch_path: /home/belal/HeiChips/heichips26-on-off/macros/heichips26_ook_top/macros/ook_analog_system/schematic/xschem/ook_transmitter.sch
.subckt ook_transmitter clk_ref rst_ni vctrl_in vctrl_b_in dac_out clk_fb vcl VGND VPWR vout vctrl_out vctrl_b_out
*.PININFO vout:B VPWR:B VGND:B vcl:B dac_out:B clk_fb:B clk_ref:B rst_ni:B vctrl_in:B vctrl_b_in:B vctrl_out:B vctrl_b_out:B
XR1 vcl dac_out VGND rhigh w=1e-6 l=61.395e-6 m=1 b=2 ps=0.18e-6 mm_ok=1
x1 net1 VPWR VGND net2 vco
x2 clk_fb vctrl_out VPWR net1 vout VGND vctrl_b_out output_buffer
XR2 net2 vcl VGND rsil w=0.5e-6 l=0.5e-6 m=1 mm_ok=1
x7 VGND VPWR clk_fb clk_ref dac_out rst_ni vctrl_b_in vctrl_b_out vctrl_in vctrl_out dac
.ends

* expanding   symbol:  ook_receiver.sym # of pins=19
** sym_path: /home/belal/HeiChips/heichips26-on-off/macros/heichips26_ook_top/macros/ook_analog_system/schematic/xschem/ook_receiver.sym
** sch_path: /home/belal/HeiChips/heichips26-on-off/macros/heichips26_ook_top/macros/ook_analog_system/schematic/xschem/ook_receiver.sch
.subckt ook_receiver VDD1_5 opm q0 vref0 q1 vref1 ACC_CAP q2 vref2 vref3 q3 VDD3_3 Cap_M11 Cap_M21 Cap_M1 Cap_M2 vin VSS lnaf
*.PININFO VSS:B vin:I q3:B VDD3_3:B VDD1_5:B q2:B q1:B q0:B ACC_CAP:B Cap_M2:B Cap_M1:B Cap_M21:B Cap_M11:B vref3:B vref2:B
*+ vref1:B vref0:B opm:B lnaf:B
x2 VDD1_5 VDD3_3 ACC_CAP q0 vref0 VSS q1 vref1 q2 vref2 q3 vref3 simple_comparator_stage
x1 Cap_M2 Cap_M1 VDD3_3 lnaf vin VSS Cap_M21 Cap_M11 lna_stage
XM24 net1 net1 VDD3_3 VDD3_3 sg13_hv_pmos w=14u l=0.5u ng=7 m=1 mm_ok=1
XM25 opm net1 VDD3_3 VDD3_3 sg13_hv_pmos w=14u l=0.5u ng=7 m=1 mm_ok=1
XR5 net1 VSS VSS rhigh w=2e-6 l=10e-6 m=1 b=0 ps=0 mm_ok=1
XM13 VDD3_3 VDD3_3 VDD3_3 VDD3_3 sg13_hv_pmos w=2u l=0.5u ng=1 m=1 mm_ok=1
XM26 VDD3_3 VDD3_3 VDD3_3 VDD3_3 sg13_hv_pmos w=2u l=0.5u ng=1 m=1 mm_ok=1
XM27 opm opm opm VDD3_3 sg13_hv_pmos w=2u l=0.5u ng=1 m=1 mm_ok=1
XM28 net1 net1 net1 VDD3_3 sg13_hv_pmos w=2u l=0.5u ng=1 m=1 mm_ok=1
XR3 opm VSS VSS rhigh w=2e-6 l=8e-6 m=1 b=0 ps=0 mm_ok=1
XM2 ACC_CAP ACC_CAP opm opm sg13_hv_pmos w=20u l=0.5u ng=10 m=1 mm_ok=1
.ends

* expanding   symbol:  vco.sym # of pins=4
** sym_path: /home/belal/HeiChips/heichips26-on-off/macros/heichips26_ook_top/macros/ook_analog_system/schematic/xschem/vco.sym
** sch_path: /home/belal/HeiChips/heichips26-on-off/macros/heichips26_ook_top/macros/ook_analog_system/schematic/xschem/vco.sch
.subckt vco vout VDD VSS VCL
*.PININFO vout:O VDD:B VSS:B VCL:I
XM1 net1 vosc net4 VDD sg13_lv_pmos w=4.5u l=0.13u ng=10 m=1 mm_ok=1
XM2 net1 vosc net7 VSS sg13_lv_nmos w=2u l=0.13u ng=5 m=1 mm_ok=1
XM3 net2 net1 net5 VDD sg13_lv_pmos w=4.5u l=0.13u ng=10 m=1 mm_ok=1
XM4 net2 net1 net8 VSS sg13_lv_nmos w=2u l=0.13u ng=5 m=1 mm_ok=1
XM5 vosc net2 net6 VDD sg13_lv_pmos w=4.5u l=0.13u ng=10 m=1 mm_ok=1
XM6 vosc net2 net9 VSS sg13_lv_nmos w=2u l=0.13u ng=5 m=1 mm_ok=1
XM7 vout vosc VDD VDD sg13_lv_pmos w=4.5u l=0.13u ng=10 m=1 mm_ok=1
XM8 vout vosc VSS VSS sg13_lv_nmos w=2u l=0.13u ng=5 m=1 mm_ok=1
XM9 net4 VCH VDD VDD sg13_lv_pmos w=5u l=0.13u ng=10 m=1 mm_ok=1
XM10 net5 VCH VDD VDD sg13_lv_pmos w=5u l=0.13u ng=10 m=1 mm_ok=1
XM11 net6 VCH VDD VDD sg13_lv_pmos w=5u l=0.13u ng=10 m=1 mm_ok=1
XM12 net7 VCL_L VSS VSS sg13_lv_nmos w=3u l=0.13u ng=5 m=1 mm_ok=1
XM13 net8 VCL_L VSS VSS sg13_lv_nmos w=3u l=0.13u ng=5 m=1 mm_ok=1
XM14 net9 VCL_L VSS VSS sg13_lv_nmos w=3u l=0.13u ng=5 m=1 mm_ok=1
XM15 VCH VCH VDD VDD sg13_lv_pmos w=5u l=0.13u ng=10 m=1 mm_ok=1
XM16 VCH VCL net3 VSS sg13_lv_nmos w=40u l=0.13u ng=20 m=1 mm_ok=1
XM17 VCL_L VCH VDD VDD sg13_lv_pmos w=5u l=0.13u ng=10 m=1 mm_ok=1
XM18 VCL_L VCL_L VSS VSS sg13_lv_nmos w=3u l=0.13u ng=5 m=1 mm_ok=1
XR1 net3 VSS VSS rhigh w=2e-6 l=4.25e-6 m=1 b=0 mm_ok=1
XM19 VDD VDD VDD VDD sg13_lv_pmos w=0.5u l=0.13u ng=1 m=1 mm_ok=1
XM20 VCH VCH VCH VDD sg13_lv_pmos w=0.5u l=0.13u ng=1 m=1 mm_ok=1
XM21 VCH VCH VCH VSS sg13_lv_nmos w=2u l=0.13u ng=1 m=1 mm_ok=1
XM22 net3 net3 net3 VSS sg13_lv_nmos w=2u l=0.13u ng=1 m=1 mm_ok=1
XM23 VDD VDD VDD VDD sg13_lv_pmos w=0.5u l=0.13u ng=1 m=1 mm_ok=1
XM24 VCL_L VCL_L VCL_L VDD sg13_lv_pmos w=0.5u l=0.13u ng=1 m=1 mm_ok=1
XM25 VCL_L VCL_L VCL_L VSS sg13_lv_nmos w=0.6u l=0.13u ng=1 m=1 mm_ok=1
XM26 VSS VSS VSS VSS sg13_lv_nmos w=0.6u l=0.13u ng=1 m=1 mm_ok=1
XM27 VDD VDD VDD VDD sg13_lv_pmos w=0.5u l=0.13u ng=1 m=1 mm_ok=1
XM28 VDD VDD VDD VDD sg13_lv_pmos w=0.5u l=0.13u ng=1 m=1 mm_ok=1
XM29 VDD VDD VDD VDD sg13_lv_pmos w=0.5u l=0.13u ng=1 m=1 mm_ok=1
XM30 net4 net4 net4 VDD sg13_lv_pmos w=0.5u l=0.13u ng=1 m=1 mm_ok=1
XM31 net5 net5 net5 VDD sg13_lv_pmos w=0.5u l=0.13u ng=1 m=1 mm_ok=1
XM32 net6 net6 net6 VDD sg13_lv_pmos w=0.5u l=0.13u ng=1 m=1 mm_ok=1
XM33 net7 net7 net7 VSS sg13_lv_nmos w=0.6u l=0.13u ng=1 m=1 mm_ok=1
XM34 net8 net8 net8 VSS sg13_lv_nmos w=0.6u l=0.13u ng=1 m=1 mm_ok=1
XM35 net9 net9 net9 VSS sg13_lv_nmos w=0.6u l=0.13u ng=1 m=1 mm_ok=1
XM36 VSS VSS VSS VSS sg13_lv_nmos w=0.6u l=0.13u ng=1 m=1 mm_ok=1
XM37 VSS VSS VSS VSS sg13_lv_nmos w=0.6u l=0.13u ng=1 m=1 mm_ok=1
XM38 VSS VSS VSS VSS sg13_lv_nmos w=0.6u l=0.13u ng=1 m=1 mm_ok=1
XM39 net7 net7 net7 VSS sg13_lv_nmos w=0.4u l=0.13u ng=1 m=1 mm_ok=1
XM40 net8 net8 net8 VSS sg13_lv_nmos w=0.4u l=0.13u ng=1 m=1 mm_ok=1
XM41 net9 net9 net9 VSS sg13_lv_nmos w=0.4u l=0.13u ng=1 m=1 mm_ok=1
XM42 net1 net1 net1 VSS sg13_lv_nmos w=0.4u l=0.13u ng=1 m=1 mm_ok=1
XM43 net2 net2 net2 VSS sg13_lv_nmos w=0.4u l=0.13u ng=1 m=1 mm_ok=1
XM44 vosc vosc vosc VSS sg13_lv_nmos w=0.4u l=0.13u ng=1 m=1 mm_ok=1
XM45 net1 net1 net1 VDD sg13_lv_pmos w=0.45u l=0.13u ng=1 m=1 mm_ok=1
XM46 net2 net2 net2 VDD sg13_lv_pmos w=0.45u l=0.13u ng=1 m=1 mm_ok=1
XM47 vosc vosc vosc VDD sg13_lv_pmos w=0.45u l=0.13u ng=1 m=1 mm_ok=1
XM48 net4 net4 net4 VDD sg13_lv_pmos w=0.45u l=0.13u ng=1 m=1 mm_ok=1
XM49 net5 net5 net5 VDD sg13_lv_pmos w=0.45u l=0.13u ng=1 m=1 mm_ok=1
XM50 net6 net6 net6 VDD sg13_lv_pmos w=0.45u l=0.13u ng=1 m=1 mm_ok=1
XM51 VSS VSS VSS VSS sg13_lv_nmos w=0.4u l=0.13u ng=1 m=1 mm_ok=1
XM52 vout vout vout VSS sg13_lv_nmos w=0.4u l=0.13u ng=1 m=1 mm_ok=1
XM53 vout vout vout VDD sg13_lv_pmos w=0.45u l=0.13u ng=1 m=1 mm_ok=1
XM54 VDD VDD VDD VDD sg13_lv_pmos w=0.45u l=0.13u ng=1 m=1 mm_ok=1
.ends

* expanding   symbol:  output_buffer.sym # of pins=7
** sym_path: /home/belal/HeiChips/heichips26-on-off/macros/heichips26_ook_top/macros/ook_analog_system/schematic/xschem/output_buffer.sym
** sch_path: /home/belal/HeiChips/heichips26-on-off/macros/heichips26_ook_top/macros/ook_analog_system/schematic/xschem/output_buffer.sch
.subckt output_buffer vout_fb vctrl VDD vin vout VSS vctrl_b
*.PININFO VDD:B VSS:B vin:I vout:O vctrl:I vout_fb:O vctrl_b:I
XM7 vout_fb vin VDD VDD sg13_lv_pmos w=13.5u l=0.13u ng=10 m=1 mm_ok=1
XM8 vout_fb vin VSS VSS sg13_lv_nmos w=6u l=0.13u ng=5 m=1 mm_ok=1
XM3 net2 net1 VDD VDD sg13_lv_pmos w=40u l=0.13u ng=20 m=1 mm_ok=1
XM4 net2 net1 VSS VSS sg13_lv_nmos w=18u l=0.13u ng=10 m=1 mm_ok=1
XM1 vout net2 VDD VDD sg13_lv_pmos w=200u l=0.13u ng=50 m=1 mm_ok=1
XM2 vout net2 VSS VSS sg13_lv_nmos w=80u l=0.13u ng=20 m=1 mm_ok=1
XM5 net1 vctrl_b vout_fb VDD sg13_lv_pmos w=13.5u l=0.13u ng=10 m=1 mm_ok=1
XM6 net1 vctrl vout_fb VSS sg13_lv_nmos w=6u l=0.13u ng=5 m=1 mm_ok=1
XM11 net1 vctrl VSS VDD sg13_lv_pmos w=13.5u l=0.13u ng=10 m=1 mm_ok=1
XM12 net1 vctrl_b VSS VSS sg13_lv_nmos w=6u l=0.13u ng=5 m=1 mm_ok=1
XM17 VDD VDD VDD VDD sg13_lv_pmos w=1.3u l=0.13u ng=1 m=1 mm_ok=1
XM18 vout_fb vout_fb vout_fb VDD sg13_lv_pmos w=1.3u l=0.13u ng=1 m=1 mm_ok=1
XM19 vout_fb vout_fb vout_fb VSS sg13_lv_nmos w=1.2u l=0.13u ng=1 m=1 mm_ok=1
XM20 VSS VSS VSS VSS sg13_lv_nmos w=1.2u l=0.13u ng=1 m=1 mm_ok=1
XM21 vout_fb vout_fb vout_fb VDD sg13_lv_pmos w=1.3u l=0.13u ng=1 m=1 mm_ok=1
XM22 vout_fb vout_fb vout_fb VSS sg13_lv_nmos w=1.2u l=0.13u ng=1 m=1 mm_ok=1
XM23 VSS VSS VSS VSS sg13_lv_nmos w=1.2u l=0.13u ng=1 m=1 mm_ok=1
XM24 VSS VSS VSS VDD sg13_lv_pmos w=1.3u l=0.13u ng=1 m=1 mm_ok=1
XM25 net1 net1 net1 VDD sg13_lv_pmos w=1.3u l=0.13u ng=1 m=1 mm_ok=1
XM26 net1 net1 net1 VSS sg13_lv_nmos w=1.2u l=0.13u ng=1 m=1 mm_ok=1
XM27 net1 net1 net1 VSS sg13_lv_nmos w=1.2u l=0.13u ng=1 m=1 mm_ok=1
XM28 net1 net1 net1 VDD sg13_lv_pmos w=1.3u l=0.13u ng=1 m=1 mm_ok=1
XM29 VDD VDD VDD VDD sg13_lv_pmos w=2u l=0.13u ng=1 m=1 mm_ok=1
XM30 net2 net2 net2 VDD sg13_lv_pmos w=2u l=0.13u ng=1 m=1 mm_ok=1
XM31 net2 net2 net2 VSS sg13_lv_nmos w=1.8u l=0.13u ng=1 m=1 mm_ok=1
XM32 VSS VSS VSS VSS sg13_lv_nmos w=1.8u l=0.13u ng=1 m=1 mm_ok=1
XM33 VDD VDD VDD VDD sg13_lv_pmos w=4u l=0.13u ng=1 m=1 mm_ok=1
XM34 vout vout vout VDD sg13_lv_pmos w=4u l=0.13u ng=1 m=1 mm_ok=1
XM35 vout vout vout VSS sg13_lv_nmos w=4u l=0.13u ng=1 m=1 mm_ok=1
XM36 VSS VSS VSS VSS sg13_lv_nmos w=4u l=0.13u ng=1 m=1 mm_ok=1
.ends

* expanding   symbol:  simple_comparator_stage.sym # of pins=12
** sym_path: /home/belal/HeiChips/heichips26-on-off/macros/heichips26_ook_top/macros/ook_analog_system/schematic/xschem/simple_comparator_stage.sym
** sch_path: /home/belal/HeiChips/heichips26-on-off/macros/heichips26_ook_top/macros/ook_analog_system/schematic/xschem/simple_comparator_stage.sch
.subckt simple_comparator_stage VDD1_5 VDD3_3 vin q0 vref0 VSS q1 vref1 q2 vref2 q3 vref3
*.PININFO VDD3_3:B VSS:B VDD1_5:B vin:I q0:O vref3:I vref2:I vref1:I vref0:I q1:O q2:O q3:O
x2 VDD1_5 VSS VDD3_3 vref0 vin q0 simple_comparator
XR1 VDD3_3 vref3 VSS rhigh w=2e-6 l=28.8e-6 m=1 b=0 mm_ok=1
XR5 vref0 VSS VSS rhigh w=2e-6 l=12.9e-6 m=1 b=0 mm_ok=1
x1 VDD1_5 VSS VDD3_3 vref1 vin q1 simple_comparator
x3 VDD1_5 VSS VDD3_3 vref2 vin q2 simple_comparator
x4 VDD1_5 VSS VDD3_3 vref3 vin q3 simple_comparator
XR4 vref1 vref0 VSS rhigh w=2e-6 l=2.8e-6 m=1 b=0 mm_ok=1
XR3 vref2 vref1 VSS rhigh w=2e-6 l=1.4e-6 m=1 b=0 mm_ok=1
XR2 vref3 vref2 VSS rhigh w=2e-6 l=1.4e-6 m=1 b=0 mm_ok=1
.ends

* expanding   symbol:  lna_stage.sym # of pins=8
** sym_path: /home/belal/HeiChips/heichips26-on-off/macros/heichips26_ook_top/macros/ook_analog_system/schematic/xschem/lna_stage.sym
** sch_path: /home/belal/HeiChips/heichips26-on-off/macros/heichips26_ook_top/macros/ook_analog_system/schematic/xschem/lna_stage.sch
.subckt lna_stage Cap_M2 Cap_M1 VDD vout vin VSS Cap_M21 Cap_M11
*.PININFO vin:I VSS:B VDD:B Cap_M2:B Cap_M1:B vout:B Cap_M21:B Cap_M11:B
x2 VDD Cap_M1 vin VSS lna
x1 VDD Cap_M11 Cap_M2 VSS lna
x3 VDD vout Cap_M21 VSS lna
.ends

* expanding   symbol:  simple_comparator.sym # of pins=6
** sym_path: /home/belal/HeiChips/heichips26-on-off/macros/heichips26_ook_top/macros/ook_analog_system/schematic/xschem/simple_comparator.sym
** sch_path: /home/belal/HeiChips/heichips26-on-off/macros/heichips26_ook_top/macros/ook_analog_system/schematic/xschem/simple_comparator.sch
.subckt simple_comparator VDDL VSS VDD vref vin comp_out
*.PININFO vin:I vref:I VDD:B VSS:B comp_out:O VDDL:B
XMBIAS vbias vbias VDD VDD sg13_hv_pmos w=4u l=0.5u ng=1 m=1 mm_ok=1
XRBIAS vbias VSS VSS rhigh w=2e-6 l=9.27e-6 m=1 b=15 ps=0.18e-6 mm_ok=1
XM3P net4 vbias VDD VDD sg13_hv_pmos w=4u l=0.5u ng=1 m=1 mm_ok=1
XM1P outn vin net4 VDD sg13_hv_pmos w=4u l=0.5u ng=1 m=4 mm_ok=1
XM2P net1 vref net4 VDD sg13_hv_pmos w=4u l=0.5u ng=1 m=4 mm_ok=1
XM4N outn outn VSS VSS sg13_hv_nmos w=2u l=0.5u ng=1 m=4 mm_ok=1
XM5N net1 outn VSS VSS sg13_hv_nmos w=2u l=0.5u ng=1 m=4 mm_ok=1
XMP1 net2 net1 VDD VDD sg13_hv_pmos w=2u l=4u ng=1 m=1 mm_ok=1
XMN1 net2 net1 net3 VSS sg13_hv_nmos w=2u l=4u ng=1 m=1 mm_ok=1
XMP2 comp_out net2 VDDL VDDL sg13_hv_pmos w=2u l=4u ng=1 m=1 mm_ok=1
XMBIAS1 vbias vbias vbias VDD sg13_hv_pmos w=4u l=0.5u ng=1 m=1 mm_ok=1
XMBIAS2 VDD VDD VDD VDD sg13_hv_pmos w=4u l=0.5u ng=1 m=1 mm_ok=1
XM1 VDD VDD VDD VDD sg13_hv_pmos w=4u l=0.5u ng=1 m=1 mm_ok=1
XM2 net4 net4 net4 VDD sg13_hv_pmos w=4u l=0.5u ng=1 m=1 mm_ok=1
XMP3 net2 net2 net2 VDD sg13_hv_pmos w=2u l=4u ng=1 m=1 mm_ok=1
XMP4 VDD VDD VDD VDD sg13_hv_pmos w=2u l=4u ng=1 m=1 mm_ok=1
XMP5 VDDL VDDL VDDL VDDL sg13_hv_pmos w=2u l=4u ng=1 m=1 mm_ok=1
XMP6 comp_out comp_out comp_out VDDL sg13_hv_pmos w=2u l=4u ng=1 m=1 mm_ok=1
XMN3 comp_out comp_out comp_out VSS sg13_hv_nmos w=2u l=4u ng=1 m=1 mm_ok=1
XMN4 VSS VSS VSS VSS sg13_hv_nmos w=2u l=4u ng=1 m=1 mm_ok=1
XMN5 net2 net2 net2 VSS sg13_hv_nmos w=2u l=4u ng=1 m=1 mm_ok=1
XMN6 net3 net3 net3 VSS sg13_hv_nmos w=2u l=4u ng=1 m=1 mm_ok=1
XM3 net4 net4 net4 VDD sg13_hv_pmos w=4u l=0.5u ng=1 m=1 mm_ok=1
XM4 outn outn outn VDD sg13_hv_pmos w=4u l=0.5u ng=1 m=1 mm_ok=1
XM5 net1 net1 net1 VSS sg13_hv_nmos w=2u l=0.5u ng=1 m=1 mm_ok=1
XM6 VSS VSS VSS VSS sg13_hv_nmos w=2u l=0.5u ng=1 m=1 mm_ok=1
XM7 net4 net4 net4 VDD sg13_hv_pmos w=4u l=0.5u ng=1 m=1 mm_ok=1
XM8 net1 net1 net1 VDD sg13_hv_pmos w=4u l=0.5u ng=1 m=1 mm_ok=1
XM9 outn outn outn VSS sg13_hv_nmos w=2u l=0.5u ng=1 m=1 mm_ok=1
XM10 VSS VSS VSS VSS sg13_hv_nmos w=2u l=0.5u ng=1 m=1 mm_ok=1
XRBIAS1 net3 VSS VSS rhigh w=2e-6 l=13.71e-6 m=1 b=8 ps=0.18e-6 mm_ok=1
XMN8 comp_out net2 VSS VSS sg13_hv_nmos w=2u l=4u ng=1 m=1 mm_ok=1
.ends

* expanding   symbol:  lna.sym # of pins=4
** sym_path: /home/belal/HeiChips/heichips26-on-off/macros/heichips26_ook_top/macros/ook_analog_system/schematic/xschem/lna.sym
** sch_path: /home/belal/HeiChips/heichips26-on-off/macros/heichips26_ook_top/macros/ook_analog_system/schematic/xschem/lna.sch
.subckt lna VDD vout vin VSS
*.PININFO VDD:B VSS:B vin:I vout:B
XM14 vout VDD net6 VSS sg13_hv_nmos w=2.0u l=0.5u ng=2 m=1 mm_ok=1
XM15 net6 vin VSS VSS sg13_hv_nmos w=18.0u l=0.5u ng=18 m=1 mm_ok=1
XM16 net1 net1 VSS VSS sg13_hv_nmos w=2.00u l=0.5u ng=2 m=1 mm_ok=1
XM17 isource1 vout VSS VSS sg13_hv_nmos w=0.5u l=0.5u ng=1 m=1 mm_ok=1
XM18 VDD isource1 isink1 VSS sg13_hv_nmos w=1.5u l=0.5u ng=1 m=1 mm_ok=1
XM19 VSS isink1 vout VDD sg13_hv_pmos w=0.7u l=0.5u ng=1 m=1 mm_ok=1
XM20 net2 net2 VSS VSS sg13_hv_nmos w=10.0u l=0.5u ng=5 m=1 mm_ok=1
XM21 isink1 net2 VSS VSS sg13_hv_nmos w=10.0u l=0.5u ng=5 m=1 mm_ok=1
XM22 net3 net3 VDD VDD sg13_hv_pmos w=14u l=0.5u ng=7 m=1 mm_ok=1
XM23 isource1 net3 VDD VDD sg13_hv_pmos w=14u l=0.5u ng=7 m=1 mm_ok=1
XM24 net4 net4 VDD VDD sg13_hv_pmos w=14u l=0.5u ng=7 m=1 mm_ok=1
XM25 vout net4 VDD VDD sg13_hv_pmos w=14u l=0.5u ng=7 m=1 mm_ok=1
XR2 net1 vin VSS rhigh w=2.0e-6 l=9.96e-6 m=1 b=3 ps=0.18e-6 mm_ok=1
XR5 net4 VSS VSS rhigh w=2e-6 l=4.95e-6 m=1 b=2 ps=0.18e-6 mm_ok=1
XR1 VDD net1 VSS rhigh w=2e-6 l=19.995e-6 m=1 b=9 ps=0.18e-6 mm_ok=1
XR6 VDD net2 VSS rhigh w=2.0e-6 l=19.995e-6 m=1 b=9 ps=0.18e-6 mm_ok=1
XM2 net5 net5 VSS VSS sg13_hv_nmos w=0.5u l=0.5u ng=1 m=1 mm_ok=1
XM3 vout net5 VSS VSS sg13_hv_nmos w=0.5u l=0.5u ng=1 m=1 mm_ok=1
XR4 net3 VSS VSS rhigh w=2e-6 l=4.95e-6 m=1 b=2 ps=0.18e-6 mm_ok=1
XR13 VDD net5 VSS rhigh w=2e-6 l=22.72e-6 m=1 b=10 ps=0.18e-6 mm_ok=1
XM1 VSS VSS VSS VDD sg13_hv_pmos w=0.7u l=0.5u ng=1 m=1 mm_ok=1
XM4 vout vout vout VDD sg13_hv_pmos w=0.7u l=0.5u ng=1 m=1 mm_ok=1
XM5 VSS VSS VSS VSS sg13_hv_nmos w=0.5u l=0.5u ng=1 m=1 mm_ok=1
XM6 isource1 isource1 isource1 VSS sg13_hv_nmos w=0.5u l=0.5u ng=1 m=1 mm_ok=1
XM7 isink1 isink1 isink1 VSS sg13_hv_nmos w=1.5u l=0.5u ng=1 m=1 mm_ok=1
XM8 VDD VDD VDD VSS sg13_hv_nmos w=1.5u l=0.5u ng=1 m=1 mm_ok=1
XM9 isource1 isource1 isource1 VDD sg13_hv_pmos w=2u l=0.5u ng=1 m=1 mm_ok=1
XM10 VDD VDD VDD VDD sg13_hv_pmos w=2u l=0.5u ng=1 m=1 mm_ok=1
XM11 VDD VDD VDD VDD sg13_hv_pmos w=2u l=0.5u ng=1 m=1 mm_ok=1
XM12 net3 net3 net3 VDD sg13_hv_pmos w=2u l=0.5u ng=1 m=1 mm_ok=1
XM13 VDD VDD VDD VDD sg13_hv_pmos w=2u l=0.5u ng=1 m=1 mm_ok=1
XM26 VDD VDD VDD VDD sg13_hv_pmos w=2u l=0.5u ng=1 m=1 mm_ok=1
XM27 vout vout vout VDD sg13_hv_pmos w=2u l=0.5u ng=1 m=1 mm_ok=1
XM28 net4 net4 net4 VDD sg13_hv_pmos w=2u l=0.5u ng=1 m=1 mm_ok=1
XM29 isink1 isink1 isink1 VSS sg13_hv_nmos w=2.0u l=0.5u ng=1 m=1 mm_ok=1
XM30 VSS VSS VSS VSS sg13_hv_nmos w=2.0u l=0.5u ng=1 m=1 mm_ok=1
XM31 net2 net2 net2 VSS sg13_hv_nmos w=2.0u l=0.5u ng=1 m=1 mm_ok=1
XM32 VSS VSS VSS VSS sg13_hv_nmos w=2.0u l=0.5u ng=1 m=1 mm_ok=1
XM33 vout vout vout VSS sg13_hv_nmos w=0.5u l=0.5u ng=1 m=1 mm_ok=1
XM34 VSS VSS VSS VSS sg13_hv_nmos w=0.5u l=0.5u ng=1 m=1 mm_ok=1
XM35 net5 net5 net5 VSS sg13_hv_nmos w=0.5u l=0.5u ng=1 m=1 mm_ok=1
XM36 VSS VSS VSS VSS sg13_hv_nmos w=0.5u l=0.5u ng=1 m=1 mm_ok=1
XM37 vout vout vout VSS sg13_hv_nmos w=1.0u l=0.5u ng=1 m=1 mm_ok=1
XM38 net6 net6 net6 VSS sg13_hv_nmos w=1.0u l=0.5u ng=1 m=1 mm_ok=1
XM39 net6 net6 net6 VSS sg13_hv_nmos w=1.0u l=0.5u ng=1 m=1 mm_ok=1
XM40 VSS VSS VSS VSS sg13_hv_nmos w=1.0u l=0.5u ng=1 m=1 mm_ok=1
XM41 net1 net1 net1 VSS sg13_hv_nmos w=1.00u l=0.5u ng=1 m=1 mm_ok=1
XM42 VSS VSS VSS VSS sg13_hv_nmos w=1.00u l=0.5u ng=1 m=1 mm_ok=1
.ends
