* NGSPICE file created from ook_digital_system.ext - technology: ihp-sg13cmos5l

.subckt ook_digital_system VGND VPWR clk clk_ref data_in_tx in_tieoff in_tieon q0
+ q0_d q1 q1_d q2 q2_d q3 q3_d rst rst_n_in vctrl vctrl_n
XFILLER_39_266 VPWR VGND sg13cmos5l_decap_8
XFILLER_22_133 VPWR VGND sg13cmos5l_decap_8
XFILLER_7_7 VPWR VGND sg13cmos5l_decap_8
XFILLER_45_203 VPWR VGND sg13cmos5l_decap_8
XFILLER_13_133 VPWR VGND sg13cmos5l_decap_8
XFILLER_26_63 VPWR VGND sg13cmos5l_decap_8
XFILLER_42_84 VPWR VGND sg13cmos5l_decap_8
XFILLER_9_126 VPWR VGND sg13cmos5l_decap_8
XFILLER_5_343 VPWR VGND sg13cmos5l_decap_8
XFILLER_3_56 VPWR VGND sg13cmos5l_decap_8
XFILLER_36_269 VPWR VGND sg13cmos5l_decap_8
XFILLER_36_203 VPWR VGND sg13cmos5l_decap_8
XFILLER_44_280 VPWR VGND sg13cmos5l_decap_8
XFILLER_42_217 VPWR VGND sg13cmos5l_decap_8
XFILLER_27_203 VPWR VGND sg13cmos5l_decap_8
XFILLER_10_147 VPWR VGND sg13cmos5l_decap_8
XFILLER_12_21 VPWR VGND sg13cmos5l_decap_8
XFILLER_12_98 VPWR VGND sg13cmos5l_decap_8
XFILLER_18_203 VPWR VGND sg13cmos5l_decap_8
XFILLER_37_95 VPWR VGND sg13cmos5l_decap_8
XFILLER_33_217 VPWR VGND sg13cmos5l_decap_8
XFILLER_26_280 VPWR VGND sg13cmos5l_decap_8
XFILLER_5_140 VPWR VGND sg13cmos5l_decap_8
XFILLER_49_350 VPWR VGND sg13cmos5l_decap_8
XFILLER_17_280 VPWR VGND sg13cmos5l_decap_8
XFILLER_24_217 VPWR VGND sg13cmos5l_decap_8
XFILLER_32_294 VPWR VGND sg13cmos5l_decap_8
XFILLER_15_217 VPWR VGND sg13cmos5l_decap_8
XFILLER_23_42 VPWR VGND sg13cmos5l_decap_8
X_062_ _062_/X _062_/A _076_/Q VPWR VGND sg13cmos5l_and2_1
XFILLER_2_165 VPWR VGND sg13cmos5l_decap_8
XFILLER_0_35 VPWR VGND sg13cmos5l_decap_8
XFILLER_9_77 VPWR VGND sg13cmos5l_decap_8
XFILLER_29_0 VPWR VGND sg13cmos5l_decap_8
XFILLER_20_242 VPWR VGND sg13cmos5l_fill_2
XFILLER_43_301 VPWR VGND sg13cmos5l_decap_8
XFILLER_28_331 VPWR VGND sg13cmos5l_decap_8
XFILLER_18_42 VPWR VGND sg13cmos5l_decap_8
XFILLER_34_63 VPWR VGND sg13cmos5l_decap_8
XFILLER_11_231 VPWR VGND sg13cmos5l_decap_8
XFILLER_7_224 VPWR VGND sg13cmos5l_decap_8
X_045_ _045_/Y _066_/A VPWR VGND sg13cmos5l_inv_1
XFILLER_22_7 VPWR VGND sg13cmos5l_decap_8
XFILLER_46_161 VPWR VGND sg13cmos5l_decap_8
XFILLER_34_356 VPWR VGND sg13cmos5l_fill_2
XFILLER_37_172 VPWR VGND sg13cmos5l_decap_8
XFILLER_40_326 VPWR VGND sg13cmos5l_decap_8
XFILLER_25_356 VPWR VGND sg13cmos5l_fill_2
XFILLER_4_238 VPWR VGND sg13cmos5l_decap_8
XFILLER_20_32 VPWR VGND sg13cmos5l_decap_8
Xhold41 _066_/A _078_/Q VPWR VGND sg13cmos5l_dlygate4sd3_1
XFILLER_29_63 VPWR VGND sg13cmos5l_decap_8
XFILLER_45_84 VPWR VGND sg13cmos5l_decap_8
XFILLER_43_175 VPWR VGND sg13cmos5l_decap_8
XFILLER_31_326 VPWR VGND sg13cmos5l_decap_8
XFILLER_16_301 VPWR VGND sg13cmos5l_decap_8
XFILLER_28_161 VPWR VGND sg13cmos5l_decap_8
XFILLER_6_56 VPWR VGND sg13cmos5l_decap_8
XFILLER_19_161 VPWR VGND sg13cmos5l_decap_8
XFILLER_20_4 VPWR VGND sg13cmos5l_decap_8
XFILLER_34_175 VPWR VGND sg13cmos5l_decap_8
XFILLER_13_315 VPWR VGND sg13cmos5l_decap_8
XFILLER_15_21 VPWR VGND sg13cmos5l_decap_8
XFILLER_40_189 VPWR VGND sg13cmos5l_decap_8
XFILLER_40_112 VPWR VGND sg13cmos5l_decap_8
XFILLER_31_53 VPWR VGND sg13cmos5l_decap_8
XFILLER_9_308 VPWR VGND sg13cmos5l_decap_8
XFILLER_15_98 VPWR VGND sg13cmos5l_decap_8
XFILLER_25_186 VPWR VGND sg13cmos5l_decap_8
Xoutput7 clk_ref output7/A VPWR VGND sg13cmos5l_buf_1
XFILLER_48_256 VPWR VGND sg13cmos5l_decap_8
XFILLER_0_252 VPWR VGND sg13cmos5l_decap_8
XFILLER_31_123 VPWR VGND sg13cmos5l_decap_8
XFILLER_16_175 VPWR VGND sg13cmos5l_decap_8
XFILLER_39_245 VPWR VGND sg13cmos5l_decap_8
XFILLER_11_0 VPWR VGND sg13cmos5l_decap_8
XFILLER_10_329 VPWR VGND sg13cmos5l_decap_8
XFILLER_22_112 VPWR VGND sg13cmos5l_decap_8
XFILLER_22_189 VPWR VGND sg13cmos5l_decap_8
XFILLER_45_259 VPWR VGND sg13cmos5l_decap_8
XFILLER_9_105 VPWR VGND sg13cmos5l_decap_8
XFILLER_13_112 VPWR VGND sg13cmos5l_decap_8
XFILLER_26_42 VPWR VGND sg13cmos5l_decap_8
XFILLER_42_63 VPWR VGND sg13cmos5l_decap_8
XFILLER_5_322 VPWR VGND sg13cmos5l_decap_8
XFILLER_13_189 VPWR VGND sg13cmos5l_decap_8
XFILLER_3_35 VPWR VGND sg13cmos5l_decap_8
XFILLER_36_248 VPWR VGND sg13cmos5l_decap_8
XFILLER_36_226 VPWR VGND sg13cmos5l_decap_8
XFILLER_8_193 VPWR VGND sg13cmos5l_decap_8
XFILLER_27_259 VPWR VGND sg13cmos5l_decap_8
XFILLER_6_119 VPWR VGND sg13cmos5l_decap_8
XFILLER_10_126 VPWR VGND sg13cmos5l_decap_8
XFILLER_12_77 VPWR VGND sg13cmos5l_decap_8
XFILLER_2_358 VPWR VGND sg13cmos5l_fill_1
XFILLER_2_347 VPWR VGND sg13cmos5l_decap_8
XFILLER_37_74 VPWR VGND sg13cmos5l_decap_8
XFILLER_18_259 VPWR VGND sg13cmos5l_decap_8
XFILLER_5_196 VPWR VGND sg13cmos5l_decap_8
XFILLER_32_273 VPWR VGND sg13cmos5l_decap_8
X_083__17 _083__17/L_HI VPWR VGND sg13cmos5l_tiehi
XFILLER_23_21 VPWR VGND sg13cmos5l_decap_8
XFILLER_23_273 VPWR VGND sg13cmos5l_fill_2
XFILLER_23_98 VPWR VGND sg13cmos5l_decap_8
X_061_ _076_/D _061_/A _059_/Y VPWR VGND sg13cmos5l_nor2b_1
XFILLER_48_95 VPWR VGND sg13cmos5l_decap_8
XFILLER_2_144 VPWR VGND sg13cmos5l_decap_8
XFILLER_46_343 VPWR VGND sg13cmos5l_decap_8
XFILLER_0_14 VPWR VGND sg13cmos5l_decap_8
XFILLER_9_56 VPWR VGND sg13cmos5l_decap_8
XFILLER_14_284 VPWR VGND sg13cmos5l_decap_8
XFILLER_37_354 VPWR VGND sg13cmos5l_decap_4
XFILLER_20_221 VPWR VGND sg13cmos5l_decap_8
XFILLER_43_357 VPWR VGND sg13cmos5l_fill_2
XFILLER_18_21 VPWR VGND sg13cmos5l_decap_8
XFILLER_18_98 VPWR VGND sg13cmos5l_decap_8
XFILLER_34_42 VPWR VGND sg13cmos5l_decap_8
XFILLER_7_203 VPWR VGND sg13cmos5l_decap_8
XFILLER_11_210 VPWR VGND sg13cmos5l_decap_8
XFILLER_11_287 VPWR VGND sg13cmos5l_decap_8
X_044_ _052_/A _044_/A VPWR VGND sg13cmos5l_inv_1
XFILLER_46_140 VPWR VGND sg13cmos5l_decap_8
XFILLER_15_7 VPWR VGND sg13cmos5l_decap_8
XFILLER_19_321 VPWR VGND sg13cmos5l_fill_1
XFILLER_34_335 VPWR VGND sg13cmos5l_decap_8
XFILLER_6_280 VPWR VGND sg13cmos5l_decap_8
XFILLER_41_0 VPWR VGND sg13cmos5l_decap_8
XFILLER_37_151 VPWR VGND sg13cmos5l_decap_8
XFILLER_25_335 VPWR VGND sg13cmos5l_decap_8
XFILLER_4_217 VPWR VGND sg13cmos5l_decap_8
XFILLER_20_11 VPWR VGND sg13cmos5l_decap_8
XFILLER_20_88 VPWR VGND sg13cmos5l_decap_8
Xhold42 _078_/D _069_/Y VPWR VGND sg13cmos5l_dlygate4sd3_1
XFILLER_29_42 VPWR VGND sg13cmos5l_decap_8
XFILLER_28_140 VPWR VGND sg13cmos5l_decap_8
XFILLER_45_63 VPWR VGND sg13cmos5l_decap_8
XFILLER_43_154 VPWR VGND sg13cmos5l_decap_8
XFILLER_31_305 VPWR VGND sg13cmos5l_decap_8
XFILLER_6_35 VPWR VGND sg13cmos5l_decap_8
XFILLER_3_294 VPWR VGND sg13cmos5l_decap_8
XFILLER_19_140 VPWR VGND sg13cmos5l_decap_8
XFILLER_34_154 VPWR VGND sg13cmos5l_decap_8
XFILLER_22_338 VPWR VGND sg13cmos5l_fill_2
XFILLER_25_165 VPWR VGND sg13cmos5l_decap_8
XFILLER_40_168 VPWR VGND sg13cmos5l_decap_8
XFILLER_31_32 VPWR VGND sg13cmos5l_decap_8
XFILLER_15_77 VPWR VGND sg13cmos5l_decap_8
XFILLER_0_231 VPWR VGND sg13cmos5l_decap_8
Xoutput8 q0_d _089_/Q VPWR VGND sg13cmos5l_buf_1
Xoutput10 q2_d _085_/Q VPWR VGND sg13cmos5l_buf_1
XFILLER_48_235 VPWR VGND sg13cmos5l_decap_8
XFILLER_31_179 VPWR VGND sg13cmos5l_decap_8
XFILLER_31_102 VPWR VGND sg13cmos5l_decap_8
XFILLER_16_154 VPWR VGND sg13cmos5l_decap_8
XFILLER_39_224 VPWR VGND sg13cmos5l_decap_8
XFILLER_10_308 VPWR VGND sg13cmos5l_decap_8
XFILLER_22_168 VPWR VGND sg13cmos5l_decap_8
XFILLER_45_238 VPWR VGND sg13cmos5l_decap_8
XFILLER_26_21 VPWR VGND sg13cmos5l_decap_8
XFILLER_42_42 VPWR VGND sg13cmos5l_decap_8
XFILLER_13_168 VPWR VGND sg13cmos5l_decap_8
XFILLER_26_98 VPWR VGND sg13cmos5l_decap_8
XFILLER_5_301 VPWR VGND sg13cmos5l_decap_8
XFILLER_3_14 VPWR VGND sg13cmos5l_decap_8
XFILLER_8_172 VPWR VGND sg13cmos5l_decap_8
XFILLER_27_238 VPWR VGND sg13cmos5l_decap_8
XFILLER_35_282 VPWR VGND sg13cmos5l_decap_8
XFILLER_10_105 VPWR VGND sg13cmos5l_decap_8
XFILLER_12_56 VPWR VGND sg13cmos5l_decap_8
XFILLER_2_326 VPWR VGND sg13cmos5l_decap_8
XFILLER_37_53 VPWR VGND sg13cmos5l_decap_8
XFILLER_18_238 VPWR VGND sg13cmos5l_decap_8
XFILLER_41_252 VPWR VGND sg13cmos5l_decap_8
X_077__26 _077__26/L_HI VPWR VGND sg13cmos5l_tiehi
XFILLER_45_7 VPWR VGND sg13cmos5l_decap_8
XFILLER_5_175 VPWR VGND sg13cmos5l_decap_8
XFILLER_32_252 VPWR VGND sg13cmos5l_decap_8
XFILLER_23_77 VPWR VGND sg13cmos5l_decap_8
XFILLER_23_252 VPWR VGND sg13cmos5l_decap_8
XFILLER_2_123 VPWR VGND sg13cmos5l_decap_8
X_060_ _060_/Y _059_/C _075_/Q _073_/A VPWR VGND sg13cmos5l_o21ai_1
XFILLER_48_74 VPWR VGND sg13cmos5l_decap_8
XFILLER_46_322 VPWR VGND sg13cmos5l_decap_8
XFILLER_9_35 VPWR VGND sg13cmos5l_decap_8
XFILLER_14_263 VPWR VGND sg13cmos5l_decap_8
XFILLER_49_182 VPWR VGND sg13cmos5l_decap_8
XFILLER_37_333 VPWR VGND sg13cmos5l_decap_8
XFILLER_20_200 VPWR VGND sg13cmos5l_decap_8
XFILLER_47_119 VPWR VGND sg13cmos5l_decap_8
XFILLER_43_336 VPWR VGND sg13cmos5l_decap_8
XFILLER_34_21 VPWR VGND sg13cmos5l_decap_8
XFILLER_18_77 VPWR VGND sg13cmos5l_decap_8
XFILLER_34_98 VPWR VGND sg13cmos5l_decap_8
XFILLER_7_259 VPWR VGND sg13cmos5l_decap_8
XFILLER_11_266 VPWR VGND sg13cmos5l_decap_8
XFILLER_1_0 VPWR VGND sg13cmos5l_decap_8
XFILLER_38_119 VPWR VGND sg13cmos5l_decap_8
XFILLER_34_314 VPWR VGND sg13cmos5l_decap_8
XFILLER_19_344 VPWR VGND sg13cmos5l_decap_8
XFILLER_46_196 VPWR VGND sg13cmos5l_decap_8
XFILLER_34_358 VPWR VGND sg13cmos5l_fill_1
XFILLER_34_0 VPWR VGND sg13cmos5l_decap_8
XFILLER_29_119 VPWR VGND sg13cmos5l_decap_8
XFILLER_37_130 VPWR VGND sg13cmos5l_decap_8
XFILLER_1_91 VPWR VGND sg13cmos5l_decap_8
XFILLER_25_358 VPWR VGND sg13cmos5l_fill_1
XFILLER_20_67 VPWR VGND sg13cmos5l_decap_8
Xhold32 _085_/D _084_/Q VPWR VGND sg13cmos5l_dlygate4sd3_1
Xhold43 _062_/A _077_/Q VPWR VGND sg13cmos5l_dlygate4sd3_1
XFILLER_29_21 VPWR VGND sg13cmos5l_decap_8
XFILLER_29_98 VPWR VGND sg13cmos5l_decap_8
XFILLER_45_42 VPWR VGND sg13cmos5l_decap_8
XFILLER_43_133 VPWR VGND sg13cmos5l_decap_8
XFILLER_16_336 VPWR VGND sg13cmos5l_decap_8
XFILLER_28_196 VPWR VGND sg13cmos5l_decap_8
XFILLER_6_14 VPWR VGND sg13cmos5l_decap_8
XFILLER_3_273 VPWR VGND sg13cmos5l_decap_8
XFILLER_34_133 VPWR VGND sg13cmos5l_decap_8
XFILLER_19_196 VPWR VGND sg13cmos5l_decap_8
XFILLER_30_350 VPWR VGND sg13cmos5l_decap_8
XFILLER_40_147 VPWR VGND sg13cmos5l_decap_8
XFILLER_15_56 VPWR VGND sg13cmos5l_decap_8
XFILLER_25_144 VPWR VGND sg13cmos5l_decap_8
XFILLER_31_88 VPWR VGND sg13cmos5l_decap_8
XFILLER_31_11 VPWR VGND sg13cmos5l_decap_8
XFILLER_48_214 VPWR VGND sg13cmos5l_decap_8
XFILLER_0_210 VPWR VGND sg13cmos5l_decap_8
XFILLER_0_287 VPWR VGND sg13cmos5l_decap_8
Xoutput9 q1_d _087_/Q VPWR VGND sg13cmos5l_buf_1
Xoutput11 q3_d _083_/Q VPWR VGND sg13cmos5l_buf_1
XFILLER_16_133 VPWR VGND sg13cmos5l_decap_8
XFILLER_31_158 VPWR VGND sg13cmos5l_decap_8
XFILLER_8_354 VPWR VGND sg13cmos5l_decap_4
XFILLER_12_350 VPWR VGND sg13cmos5l_decap_8
XFILLER_39_203 VPWR VGND sg13cmos5l_decap_8
XFILLER_47_280 VPWR VGND sg13cmos5l_decap_8
XFILLER_22_147 VPWR VGND sg13cmos5l_decap_8
XFILLER_45_217 VPWR VGND sg13cmos5l_decap_8
XFILLER_38_280 VPWR VGND sg13cmos5l_decap_8
XFILLER_42_21 VPWR VGND sg13cmos5l_decap_8
XFILLER_13_147 VPWR VGND sg13cmos5l_decap_8
XFILLER_26_77 VPWR VGND sg13cmos5l_decap_8
XFILLER_42_98 VPWR VGND sg13cmos5l_decap_8
XFILLER_5_357 VPWR VGND sg13cmos5l_fill_2
XFILLER_36_217 VPWR VGND sg13cmos5l_decap_4
XFILLER_44_294 VPWR VGND sg13cmos5l_decap_8
XFILLER_8_151 VPWR VGND sg13cmos5l_decap_8
XFILLER_27_217 VPWR VGND sg13cmos5l_decap_8
XFILLER_5_7 VPWR VGND sg13cmos5l_decap_8
XFILLER_2_305 VPWR VGND sg13cmos5l_decap_8
XFILLER_12_35 VPWR VGND sg13cmos5l_decap_8
XFILLER_37_32 VPWR VGND sg13cmos5l_decap_8
XFILLER_41_231 VPWR VGND sg13cmos5l_decap_8
XFILLER_18_217 VPWR VGND sg13cmos5l_decap_8
XFILLER_26_294 VPWR VGND sg13cmos5l_decap_8
XFILLER_41_297 VPWR VGND sg13cmos5l_decap_4
XFILLER_38_7 VPWR VGND sg13cmos5l_decap_8
XFILLER_5_154 VPWR VGND sg13cmos5l_decap_8
XFILLER_32_231 VPWR VGND sg13cmos5l_decap_8
XFILLER_17_294 VPWR VGND sg13cmos5l_fill_2
XFILLER_4_91 VPWR VGND sg13cmos5l_decap_8
XFILLER_23_231 VPWR VGND sg13cmos5l_decap_8
XFILLER_23_56 VPWR VGND sg13cmos5l_decap_8
XFILLER_23_275 VPWR VGND sg13cmos5l_fill_1
XFILLER_2_179 VPWR VGND sg13cmos5l_decap_8
XFILLER_2_102 VPWR VGND sg13cmos5l_decap_8
XFILLER_48_53 VPWR VGND sg13cmos5l_decap_8
XFILLER_46_301 VPWR VGND sg13cmos5l_decap_8
XFILLER_0_49 VPWR VGND sg13cmos5l_decap_8
XFILLER_9_14 VPWR VGND sg13cmos5l_decap_8
XFILLER_14_242 VPWR VGND sg13cmos5l_decap_8
XFILLER_49_161 VPWR VGND sg13cmos5l_decap_8
XFILLER_37_312 VPWR VGND sg13cmos5l_decap_8
XFILLER_28_345 VPWR VGND sg13cmos5l_decap_8
XFILLER_28_312 VPWR VGND sg13cmos5l_decap_8
XFILLER_28_301 VPWR VGND sg13cmos5l_decap_8
XFILLER_18_56 VPWR VGND sg13cmos5l_decap_8
XFILLER_43_315 VPWR VGND sg13cmos5l_decap_8
XFILLER_34_77 VPWR VGND sg13cmos5l_decap_8
XFILLER_7_238 VPWR VGND sg13cmos5l_decap_8
XFILLER_11_245 VPWR VGND sg13cmos5l_decap_8
XFILLER_46_175 VPWR VGND sg13cmos5l_decap_8
XFILLER_27_0 VPWR VGND sg13cmos5l_decap_8
XFILLER_37_186 VPWR VGND sg13cmos5l_decap_8
XFILLER_1_70 VPWR VGND sg13cmos5l_decap_8
XFILLER_20_46 VPWR VGND sg13cmos5l_decap_8
XFILLER_45_21 VPWR VGND sg13cmos5l_decap_8
XFILLER_43_112 VPWR VGND sg13cmos5l_decap_8
XFILLER_16_315 VPWR VGND sg13cmos5l_decap_8
Xhold44 _077_/D _065_/Y VPWR VGND sg13cmos5l_dlygate4sd3_1
Xhold33 _089_/D _088_/Q VPWR VGND sg13cmos5l_dlygate4sd3_1
XFILLER_29_77 VPWR VGND sg13cmos5l_decap_8
XFILLER_28_175 VPWR VGND sg13cmos5l_decap_8
XFILLER_45_98 VPWR VGND sg13cmos5l_decap_8
XFILLER_43_189 VPWR VGND sg13cmos5l_decap_8
XFILLER_3_252 VPWR VGND sg13cmos5l_decap_8
XFILLER_34_189 VPWR VGND sg13cmos5l_decap_8
XFILLER_34_112 VPWR VGND sg13cmos5l_decap_8
XFILLER_19_175 VPWR VGND sg13cmos5l_decap_8
XFILLER_25_123 VPWR VGND sg13cmos5l_decap_8
XFILLER_40_126 VPWR VGND sg13cmos5l_decap_8
XFILLER_13_329 VPWR VGND sg13cmos5l_decap_8
XFILLER_15_35 VPWR VGND sg13cmos5l_decap_8
XFILLER_31_67 VPWR VGND sg13cmos5l_decap_8
Xoutput12 rst output12/A VPWR VGND sg13cmos5l_buf_1
XFILLER_0_266 VPWR VGND sg13cmos5l_decap_8
XFILLER_16_112 VPWR VGND sg13cmos5l_decap_8
XFILLER_16_189 VPWR VGND sg13cmos5l_decap_8
XFILLER_31_137 VPWR VGND sg13cmos5l_decap_8
XFILLER_8_333 VPWR VGND sg13cmos5l_decap_8
XFILLER_39_259 VPWR VGND sg13cmos5l_decap_8
XFILLER_22_126 VPWR VGND sg13cmos5l_decap_8
XFILLER_7_91 VPWR VGND sg13cmos5l_decap_8
XFILLER_26_56 VPWR VGND sg13cmos5l_decap_8
XFILLER_42_77 VPWR VGND sg13cmos5l_decap_8
XFILLER_9_119 VPWR VGND sg13cmos5l_decap_8
XFILLER_13_126 VPWR VGND sg13cmos5l_decap_8
XFILLER_5_336 VPWR VGND sg13cmos5l_decap_8
XFILLER_3_49 VPWR VGND sg13cmos5l_decap_8
XFILLER_44_273 VPWR VGND sg13cmos5l_decap_8
XFILLER_8_130 VPWR VGND sg13cmos5l_decap_8
XFILLER_12_14 VPWR VGND sg13cmos5l_decap_8
XFILLER_37_11 VPWR VGND sg13cmos5l_decap_8
XFILLER_41_210 VPWR VGND sg13cmos5l_decap_8
XFILLER_37_88 VPWR VGND sg13cmos5l_decap_8
XFILLER_26_273 VPWR VGND sg13cmos5l_decap_8
XFILLER_5_133 VPWR VGND sg13cmos5l_decap_8
XFILLER_1_350 VPWR VGND sg13cmos5l_decap_8
XFILLER_49_343 VPWR VGND sg13cmos5l_decap_8
XFILLER_17_273 VPWR VGND sg13cmos5l_decap_8
XFILLER_32_287 VPWR VGND sg13cmos5l_decap_8
XFILLER_32_210 VPWR VGND sg13cmos5l_decap_8
XFILLER_4_70 VPWR VGND sg13cmos5l_decap_8
XFILLER_23_210 VPWR VGND sg13cmos5l_decap_8
XFILLER_23_35 VPWR VGND sg13cmos5l_decap_8
XFILLER_48_32 VPWR VGND sg13cmos5l_decap_8
XFILLER_2_158 VPWR VGND sg13cmos5l_decap_8
XFILLER_46_357 VPWR VGND sg13cmos5l_fill_2
XFILLER_0_28 VPWR VGND sg13cmos5l_decap_8
XFILLER_14_221 VPWR VGND sg13cmos5l_decap_8
XFILLER_14_298 VPWR VGND sg13cmos5l_decap_8
XFILLER_49_140 VPWR VGND sg13cmos5l_decap_8
XFILLER_9_280 VPWR VGND sg13cmos5l_decap_8
XFILLER_20_235 VPWR VGND sg13cmos5l_decap_8
XFILLER_18_35 VPWR VGND sg13cmos5l_decap_8
XFILLER_34_56 VPWR VGND sg13cmos5l_decap_8
XFILLER_11_224 VPWR VGND sg13cmos5l_decap_8
XFILLER_7_217 VPWR VGND sg13cmos5l_decap_8
XFILLER_46_154 VPWR VGND sg13cmos5l_decap_8
XFILLER_34_349 VPWR VGND sg13cmos5l_decap_8
XFILLER_6_294 VPWR VGND sg13cmos5l_decap_8
XFILLER_37_165 VPWR VGND sg13cmos5l_decap_8
XFILLER_40_319 VPWR VGND sg13cmos5l_decap_8
XFILLER_25_349 VPWR VGND sg13cmos5l_decap_8
XFILLER_20_25 VPWR VGND sg13cmos5l_decap_8
Xhold34 _087_/D _086_/Q VPWR VGND sg13cmos5l_dlygate4sd3_1
Xhold45 _059_/C _076_/Q VPWR VGND sg13cmos5l_dlygate4sd3_1
XFILLER_29_56 VPWR VGND sg13cmos5l_decap_8
XFILLER_45_77 VPWR VGND sg13cmos5l_decap_8
XFILLER_43_168 VPWR VGND sg13cmos5l_decap_8
XFILLER_28_154 VPWR VGND sg13cmos5l_decap_8
XFILLER_31_319 VPWR VGND sg13cmos5l_decap_8
XFILLER_6_49 VPWR VGND sg13cmos5l_decap_8
XFILLER_3_231 VPWR VGND sg13cmos5l_decap_8
XFILLER_10_91 VPWR VGND sg13cmos5l_decap_8
XFILLER_13_7 VPWR VGND sg13cmos5l_decap_8
XFILLER_19_154 VPWR VGND sg13cmos5l_decap_8
XFILLER_34_168 VPWR VGND sg13cmos5l_decap_8
XFILLER_15_14 VPWR VGND sg13cmos5l_decap_8
XFILLER_25_102 VPWR VGND sg13cmos5l_decap_8
XFILLER_40_105 VPWR VGND sg13cmos5l_decap_8
XFILLER_13_308 VPWR VGND sg13cmos5l_decap_8
XFILLER_25_179 VPWR VGND sg13cmos5l_decap_8
XFILLER_31_46 VPWR VGND sg13cmos5l_decap_8
Xoutput13 vctrl _049_/Y VPWR VGND sg13cmos5l_buf_1
XFILLER_48_249 VPWR VGND sg13cmos5l_decap_8
XFILLER_0_245 VPWR VGND sg13cmos5l_decap_8
XFILLER_31_116 VPWR VGND sg13cmos5l_decap_8
XFILLER_16_168 VPWR VGND sg13cmos5l_decap_8
XFILLER_8_312 VPWR VGND sg13cmos5l_decap_8
XFILLER_39_238 VPWR VGND sg13cmos5l_decap_8
XFILLER_30_182 VPWR VGND sg13cmos5l_decap_8
XFILLER_22_105 VPWR VGND sg13cmos5l_decap_8
XFILLER_7_70 VPWR VGND sg13cmos5l_decap_8
XFILLER_13_105 VPWR VGND sg13cmos5l_decap_8
XFILLER_26_35 VPWR VGND sg13cmos5l_decap_8
XFILLER_42_56 VPWR VGND sg13cmos5l_decap_8
XFILLER_5_315 VPWR VGND sg13cmos5l_decap_8
XFILLER_21_182 VPWR VGND sg13cmos5l_decap_8
XFILLER_3_28 VPWR VGND sg13cmos5l_decap_8
XFILLER_44_252 VPWR VGND sg13cmos5l_decap_8
XFILLER_8_186 VPWR VGND sg13cmos5l_decap_8
XFILLER_12_182 VPWR VGND sg13cmos5l_decap_8
XFILLER_35_296 VPWR VGND sg13cmos5l_decap_8
XFILLER_10_119 VPWR VGND sg13cmos5l_decap_8
XFILLER_37_67 VPWR VGND sg13cmos5l_decap_8
XFILLER_26_252 VPWR VGND sg13cmos5l_decap_8
XFILLER_5_189 VPWR VGND sg13cmos5l_decap_8
XFILLER_5_112 VPWR VGND sg13cmos5l_decap_8
XFILLER_49_322 VPWR VGND sg13cmos5l_decap_8
XFILLER_17_252 VPWR VGND sg13cmos5l_decap_8
XFILLER_32_266 VPWR VGND sg13cmos5l_decap_8
XFILLER_23_14 VPWR VGND sg13cmos5l_decap_8
XFILLER_23_266 VPWR VGND sg13cmos5l_decap_8
XFILLER_48_11 VPWR VGND sg13cmos5l_decap_8
XFILLER_2_137 VPWR VGND sg13cmos5l_decap_8
XFILLER_48_88 VPWR VGND sg13cmos5l_decap_8
XFILLER_46_336 VPWR VGND sg13cmos5l_decap_8
XFILLER_14_200 VPWR VGND sg13cmos5l_decap_8
XFILLER_9_49 VPWR VGND sg13cmos5l_decap_8
XFILLER_14_277 VPWR VGND sg13cmos5l_decap_8
XFILLER_43_7 VPWR VGND sg13cmos5l_decap_8
XFILLER_13_91 VPWR VGND sg13cmos5l_decap_8
XFILLER_49_196 VPWR VGND sg13cmos5l_decap_8
XFILLER_37_358 VPWR VGND sg13cmos5l_fill_1
XFILLER_37_347 VPWR VGND sg13cmos5l_decap_8
XFILLER_20_214 VPWR VGND sg13cmos5l_decap_8
XFILLER_18_14 VPWR VGND sg13cmos5l_decap_8
XFILLER_34_35 VPWR VGND sg13cmos5l_decap_8
XFILLER_11_203 VPWR VGND sg13cmos5l_decap_8
XFILLER_46_133 VPWR VGND sg13cmos5l_decap_8
XFILLER_34_328 VPWR VGND sg13cmos5l_decap_8
XFILLER_19_358 VPWR VGND sg13cmos5l_fill_1
XFILLER_10_280 VPWR VGND sg13cmos5l_decap_8
XFILLER_6_273 VPWR VGND sg13cmos5l_decap_8
XFILLER_37_144 VPWR VGND sg13cmos5l_decap_8
XFILLER_25_328 VPWR VGND sg13cmos5l_decap_8
XFILLER_33_350 VPWR VGND sg13cmos5l_decap_8
Xhold35 _083_/D _082_/Q VPWR VGND sg13cmos5l_dlygate4sd3_1
Xhold46 _061_/A _060_/Y VPWR VGND sg13cmos5l_dlygate4sd3_1
XFILLER_29_35 VPWR VGND sg13cmos5l_decap_8
XFILLER_45_56 VPWR VGND sg13cmos5l_decap_8
XFILLER_43_147 VPWR VGND sg13cmos5l_decap_8
XFILLER_28_133 VPWR VGND sg13cmos5l_decap_8
XFILLER_6_28 VPWR VGND sg13cmos5l_decap_8
XFILLER_3_287 VPWR VGND sg13cmos5l_decap_8
XFILLER_3_210 VPWR VGND sg13cmos5l_decap_8
XFILLER_10_70 VPWR VGND sg13cmos5l_decap_8
XFILLER_19_133 VPWR VGND sg13cmos5l_decap_8
XFILLER_34_147 VPWR VGND sg13cmos5l_decap_8
XFILLER_32_0 VPWR VGND sg13cmos5l_decap_8
XFILLER_25_158 VPWR VGND sg13cmos5l_decap_8
XFILLER_31_25 VPWR VGND sg13cmos5l_decap_8
Xoutput14 vctrl_n _050_/Y VPWR VGND sg13cmos5l_buf_1
XFILLER_0_224 VPWR VGND sg13cmos5l_decap_8
XFILLER_48_228 VPWR VGND sg13cmos5l_decap_8
XFILLER_16_147 VPWR VGND sg13cmos5l_decap_8
XFILLER_21_91 VPWR VGND sg13cmos5l_decap_8
XFILLER_39_217 VPWR VGND sg13cmos5l_decap_8
XFILLER_47_294 VPWR VGND sg13cmos5l_decap_8
XFILLER_30_161 VPWR VGND sg13cmos5l_decap_8
XFILLER_26_14 VPWR VGND sg13cmos5l_decap_8
XFILLER_42_35 VPWR VGND sg13cmos5l_decap_8
XFILLER_38_294 VPWR VGND sg13cmos5l_decap_8
X_089__16 _089__16/L_HI VPWR VGND sg13cmos5l_tiehi
XFILLER_21_161 VPWR VGND sg13cmos5l_decap_8
XFILLER_44_231 VPWR VGND sg13cmos5l_decap_8
XFILLER_29_283 VPWR VGND sg13cmos5l_fill_2
XFILLER_29_272 VPWR VGND sg13cmos5l_decap_8
XFILLER_12_161 VPWR VGND sg13cmos5l_decap_8
XFILLER_16_91 VPWR VGND sg13cmos5l_decap_8
XFILLER_8_165 VPWR VGND sg13cmos5l_decap_8
XFILLER_35_275 VPWR VGND sg13cmos5l_decap_8
XFILLER_35_231 VPWR VGND sg13cmos5l_decap_4
Xook_digital_system_31 in_tieon VPWR VGND sg13cmos5l_tiehi
XFILLER_12_49 VPWR VGND sg13cmos5l_decap_8
XFILLER_2_319 VPWR VGND sg13cmos5l_decap_8
XFILLER_37_46 VPWR VGND sg13cmos5l_decap_8
XFILLER_26_231 VPWR VGND sg13cmos5l_decap_8
XFILLER_41_245 VPWR VGND sg13cmos5l_decap_8
XFILLER_5_168 VPWR VGND sg13cmos5l_decap_8
XFILLER_49_301 VPWR VGND sg13cmos5l_decap_8
XFILLER_32_245 VPWR VGND sg13cmos5l_decap_8
XFILLER_17_231 VPWR VGND sg13cmos5l_decap_8
XFILLER_23_245 VPWR VGND sg13cmos5l_decap_8
XFILLER_3_7 VPWR VGND sg13cmos5l_decap_8
XFILLER_2_116 VPWR VGND sg13cmos5l_decap_8
XFILLER_48_67 VPWR VGND sg13cmos5l_decap_8
XFILLER_46_315 VPWR VGND sg13cmos5l_decap_8
XFILLER_14_256 VPWR VGND sg13cmos5l_decap_8
XFILLER_9_28 VPWR VGND sg13cmos5l_decap_8
XFILLER_13_70 VPWR VGND sg13cmos5l_decap_8
XFILLER_36_7 VPWR VGND sg13cmos5l_decap_8
XFILLER_49_175 VPWR VGND sg13cmos5l_decap_8
XFILLER_37_326 VPWR VGND sg13cmos5l_decap_8
XFILLER_1_182 VPWR VGND sg13cmos5l_decap_8
XFILLER_43_329 VPWR VGND sg13cmos5l_decap_8
XFILLER_34_14 VPWR VGND sg13cmos5l_decap_8
XFILLER_28_326 VPWR VGND sg13cmos5l_fill_1
XFILLER_11_259 VPWR VGND sg13cmos5l_decap_8
XFILLER_46_112 VPWR VGND sg13cmos5l_decap_8
XFILLER_34_307 VPWR VGND sg13cmos5l_decap_8
XFILLER_19_337 VPWR VGND sg13cmos5l_decap_8
XFILLER_46_189 VPWR VGND sg13cmos5l_decap_8
XFILLER_6_252 VPWR VGND sg13cmos5l_decap_8
XFILLER_24_91 VPWR VGND sg13cmos5l_decap_8
XFILLER_37_123 VPWR VGND sg13cmos5l_decap_8
XFILLER_1_84 VPWR VGND sg13cmos5l_decap_8
XFILLER_25_307 VPWR VGND sg13cmos5l_decap_4
Xhold36 _044_/A _079_/Q VPWR VGND sg13cmos5l_dlygate4sd3_1
XFILLER_29_14 VPWR VGND sg13cmos5l_decap_8
XFILLER_28_112 VPWR VGND sg13cmos5l_decap_8
XFILLER_45_35 VPWR VGND sg13cmos5l_decap_8
XFILLER_43_126 VPWR VGND sg13cmos5l_decap_8
XFILLER_16_329 VPWR VGND sg13cmos5l_decap_8
XFILLER_28_189 VPWR VGND sg13cmos5l_decap_8
XFILLER_3_266 VPWR VGND sg13cmos5l_decap_8
XFILLER_34_126 VPWR VGND sg13cmos5l_decap_8
XFILLER_19_91 VPWR VGND sg13cmos5l_decap_8
XFILLER_19_112 VPWR VGND sg13cmos5l_decap_8
XFILLER_19_189 VPWR VGND sg13cmos5l_decap_8
XFILLER_30_343 VPWR VGND sg13cmos5l_decap_8
XFILLER_15_49 VPWR VGND sg13cmos5l_decap_8
XFILLER_25_137 VPWR VGND sg13cmos5l_decap_8
XFILLER_21_332 VPWR VGND sg13cmos5l_decap_8
XFILLER_48_207 VPWR VGND sg13cmos5l_decap_8
XFILLER_0_203 VPWR VGND sg13cmos5l_decap_8
XFILLER_16_126 VPWR VGND sg13cmos5l_decap_8
XFILLER_12_343 VPWR VGND sg13cmos5l_decap_8
XFILLER_8_347 VPWR VGND sg13cmos5l_decap_8
XFILLER_8_358 VPWR VGND sg13cmos5l_fill_1
XFILLER_21_70 VPWR VGND sg13cmos5l_decap_8
XFILLER_47_273 VPWR VGND sg13cmos5l_decap_8
XFILLER_30_140 VPWR VGND sg13cmos5l_decap_8
XFILLER_38_273 VPWR VGND sg13cmos5l_decap_8
XFILLER_42_14 VPWR VGND sg13cmos5l_decap_8
XFILLER_21_140 VPWR VGND sg13cmos5l_decap_8
XFILLER_44_287 VPWR VGND sg13cmos5l_decap_8
XFILLER_44_210 VPWR VGND sg13cmos5l_decap_8
XFILLER_16_70 VPWR VGND sg13cmos5l_decap_8
XFILLER_32_91 VPWR VGND sg13cmos5l_decap_8
XFILLER_8_144 VPWR VGND sg13cmos5l_decap_8
XFILLER_12_140 VPWR VGND sg13cmos5l_decap_8
XFILLER_4_350 VPWR VGND sg13cmos5l_decap_8
XFILLER_35_210 VPWR VGND sg13cmos5l_decap_8
XFILLER_12_28 VPWR VGND sg13cmos5l_decap_8
XFILLER_41_224 VPWR VGND sg13cmos5l_decap_8
XFILLER_37_25 VPWR VGND sg13cmos5l_decap_8
XFILLER_26_210 VPWR VGND sg13cmos5l_decap_8
XFILLER_26_287 VPWR VGND sg13cmos5l_decap_8
XFILLER_5_147 VPWR VGND sg13cmos5l_decap_8
XFILLER_49_357 VPWR VGND sg13cmos5l_fill_2
XFILLER_17_210 VPWR VGND sg13cmos5l_decap_8
XFILLER_32_224 VPWR VGND sg13cmos5l_decap_8
XFILLER_17_287 VPWR VGND sg13cmos5l_decap_8
XFILLER_27_91 VPWR VGND sg13cmos5l_decap_8
XFILLER_4_84 VPWR VGND sg13cmos5l_decap_8
XFILLER_23_49 VPWR VGND sg13cmos5l_decap_8
XFILLER_23_224 VPWR VGND sg13cmos5l_decap_8
X_082__23 _082__23/L_HI VPWR VGND sg13cmos5l_tiehi
XFILLER_48_46 VPWR VGND sg13cmos5l_decap_8
XFILLER_14_235 VPWR VGND sg13cmos5l_decap_8
XFILLER_1_161 VPWR VGND sg13cmos5l_decap_8
XFILLER_29_7 VPWR VGND sg13cmos5l_decap_8
XFILLER_49_154 VPWR VGND sg13cmos5l_decap_8
XFILLER_37_305 VPWR VGND sg13cmos5l_decap_8
XFILLER_9_294 VPWR VGND sg13cmos5l_decap_8
XFILLER_28_338 VPWR VGND sg13cmos5l_decap_8
XFILLER_18_49 VPWR VGND sg13cmos5l_decap_8
XFILLER_43_308 VPWR VGND sg13cmos5l_decap_8
XFILLER_11_238 VPWR VGND sg13cmos5l_decap_8
XFILLER_46_168 VPWR VGND sg13cmos5l_decap_8
XFILLER_42_352 VPWR VGND sg13cmos5l_fill_2
XFILLER_24_70 VPWR VGND sg13cmos5l_decap_8
XFILLER_40_91 VPWR VGND sg13cmos5l_decap_8
XFILLER_6_231 VPWR VGND sg13cmos5l_decap_8
XFILLER_37_102 VPWR VGND sg13cmos5l_decap_8
XFILLER_37_179 VPWR VGND sg13cmos5l_decap_8
XFILLER_1_63 VPWR VGND sg13cmos5l_decap_8
XFILLER_20_39 VPWR VGND sg13cmos5l_decap_8
XFILLER_45_14 VPWR VGND sg13cmos5l_decap_8
XFILLER_43_105 VPWR VGND sg13cmos5l_decap_8
XFILLER_16_308 VPWR VGND sg13cmos5l_decap_8
Xhold37 _079_/D _071_/Y VPWR VGND sg13cmos5l_dlygate4sd3_1
XFILLER_28_168 VPWR VGND sg13cmos5l_decap_8
XFILLER_24_352 VPWR VGND sg13cmos5l_decap_8
XFILLER_3_245 VPWR VGND sg13cmos5l_decap_8
XFILLER_34_105 VPWR VGND sg13cmos5l_decap_8
XFILLER_19_70 VPWR VGND sg13cmos5l_decap_8
XFILLER_19_168 VPWR VGND sg13cmos5l_decap_8
XFILLER_42_182 VPWR VGND sg13cmos5l_decap_8
XFILLER_35_91 VPWR VGND sg13cmos5l_decap_8
XFILLER_30_322 VPWR VGND sg13cmos5l_decap_8
XFILLER_18_0 VPWR VGND sg13cmos5l_decap_8
XFILLER_40_119 VPWR VGND sg13cmos5l_decap_8
XFILLER_33_182 VPWR VGND sg13cmos5l_decap_8
XFILLER_15_28 VPWR VGND sg13cmos5l_decap_8
XFILLER_25_116 VPWR VGND sg13cmos5l_decap_8
XFILLER_0_259 VPWR VGND sg13cmos5l_decap_8
XFILLER_16_105 VPWR VGND sg13cmos5l_decap_8
XFILLER_8_326 VPWR VGND sg13cmos5l_decap_8
XFILLER_12_322 VPWR VGND sg13cmos5l_decap_8
XFILLER_24_182 VPWR VGND sg13cmos5l_decap_8
XFILLER_47_252 VPWR VGND sg13cmos5l_decap_8
XFILLER_11_7 VPWR VGND sg13cmos5l_decap_8
XFILLER_15_182 VPWR VGND sg13cmos5l_decap_8
Xclkbuf_0_clk clkbuf_0_clk/X clk VPWR VGND sg13cmos5l_buf_8
XFILLER_22_119 VPWR VGND sg13cmos5l_decap_8
XFILLER_30_196 VPWR VGND sg13cmos5l_decap_8
XFILLER_7_84 VPWR VGND sg13cmos5l_decap_8
XFILLER_38_252 VPWR VGND sg13cmos5l_decap_8
XFILLER_26_49 VPWR VGND sg13cmos5l_decap_8
XFILLER_13_119 VPWR VGND sg13cmos5l_decap_8
XFILLER_21_196 VPWR VGND sg13cmos5l_decap_8
XFILLER_5_329 VPWR VGND sg13cmos5l_decap_8
XFILLER_29_252 VPWR VGND sg13cmos5l_decap_8
XFILLER_44_266 VPWR VGND sg13cmos5l_decap_8
XFILLER_32_70 VPWR VGND sg13cmos5l_decap_8
XFILLER_8_123 VPWR VGND sg13cmos5l_decap_8
XFILLER_12_196 VPWR VGND sg13cmos5l_decap_8
XFILLER_41_203 VPWR VGND sg13cmos5l_decap_8
XFILLER_26_266 VPWR VGND sg13cmos5l_decap_8
XFILLER_5_126 VPWR VGND sg13cmos5l_decap_8
XFILLER_1_343 VPWR VGND sg13cmos5l_decap_8
XFILLER_49_336 VPWR VGND sg13cmos5l_decap_8
XFILLER_27_70 VPWR VGND sg13cmos5l_decap_8
XFILLER_43_91 VPWR VGND sg13cmos5l_decap_8
XFILLER_40_280 VPWR VGND sg13cmos5l_decap_4
XFILLER_32_203 VPWR VGND sg13cmos5l_decap_8
XFILLER_17_266 VPWR VGND sg13cmos5l_decap_8
XFILLER_4_63 VPWR VGND sg13cmos5l_decap_8
XFILLER_23_203 VPWR VGND sg13cmos5l_decap_8
XFILLER_31_291 VPWR VGND sg13cmos5l_decap_8
XFILLER_23_28 VPWR VGND sg13cmos5l_decap_8
XFILLER_48_25 VPWR VGND sg13cmos5l_decap_8
XFILLER_14_214 VPWR VGND sg13cmos5l_decap_8
XFILLER_49_133 VPWR VGND sg13cmos5l_decap_8
XFILLER_1_140 VPWR VGND sg13cmos5l_decap_8
XFILLER_45_350 VPWR VGND sg13cmos5l_decap_8
XFILLER_38_91 VPWR VGND sg13cmos5l_decap_8
XFILLER_9_273 VPWR VGND sg13cmos5l_decap_8
XFILLER_13_280 VPWR VGND sg13cmos5l_decap_8
XFILLER_20_228 VPWR VGND sg13cmos5l_decap_8
XFILLER_18_28 VPWR VGND sg13cmos5l_decap_8
XFILLER_34_49 VPWR VGND sg13cmos5l_decap_8
XFILLER_11_217 VPWR VGND sg13cmos5l_decap_8
XFILLER_46_147 VPWR VGND sg13cmos5l_decap_8
XFILLER_42_331 VPWR VGND sg13cmos5l_decap_8
XFILLER_27_350 VPWR VGND sg13cmos5l_decap_8
XFILLER_6_210 VPWR VGND sg13cmos5l_decap_8
XFILLER_41_7 VPWR VGND sg13cmos5l_decap_8
XFILLER_40_70 VPWR VGND sg13cmos5l_decap_8
XFILLER_6_287 VPWR VGND sg13cmos5l_decap_8
XFILLER_10_294 VPWR VGND sg13cmos5l_decap_8
XFILLER_1_42 VPWR VGND sg13cmos5l_decap_8
XFILLER_37_158 VPWR VGND sg13cmos5l_decap_8
XFILLER_20_18 VPWR VGND sg13cmos5l_decap_8
Xhold38 _073_/B _080_/Q VPWR VGND sg13cmos5l_dlygate4sd3_1
XFILLER_29_49 VPWR VGND sg13cmos5l_decap_8
XFILLER_28_147 VPWR VGND sg13cmos5l_decap_8
XFILLER_3_224 VPWR VGND sg13cmos5l_decap_8
Xclkbuf_regs_0_clk clkbuf_regs_0_clk/X clk VPWR VGND sg13cmos5l_buf_8
XFILLER_10_84 VPWR VGND sg13cmos5l_decap_8
XFILLER_19_147 VPWR VGND sg13cmos5l_decap_8
XFILLER_42_161 VPWR VGND sg13cmos5l_decap_8
XFILLER_35_70 VPWR VGND sg13cmos5l_decap_8
XFILLER_15_353 VPWR VGND sg13cmos5l_decap_4
XFILLER_33_161 VPWR VGND sg13cmos5l_decap_8
XFILLER_31_39 VPWR VGND sg13cmos5l_decap_8
XFILLER_0_238 VPWR VGND sg13cmos5l_decap_8
XFILLER_31_109 VPWR VGND sg13cmos5l_decap_8
XFILLER_12_301 VPWR VGND sg13cmos5l_decap_8
XFILLER_24_161 VPWR VGND sg13cmos5l_decap_8
XFILLER_8_305 VPWR VGND sg13cmos5l_decap_8
XFILLER_47_231 VPWR VGND sg13cmos5l_decap_8
XFILLER_46_91 VPWR VGND sg13cmos5l_decap_8
XFILLER_15_161 VPWR VGND sg13cmos5l_decap_8
XFILLER_30_175 VPWR VGND sg13cmos5l_decap_8
XFILLER_7_63 VPWR VGND sg13cmos5l_decap_8
XFILLER_30_0 VPWR VGND sg13cmos5l_decap_8
XFILLER_38_231 VPWR VGND sg13cmos5l_decap_8
XFILLER_26_28 VPWR VGND sg13cmos5l_decap_8
XFILLER_42_49 VPWR VGND sg13cmos5l_decap_8
XFILLER_5_308 VPWR VGND sg13cmos5l_decap_8
XFILLER_21_175 VPWR VGND sg13cmos5l_decap_8
XFILLER_29_231 VPWR VGND sg13cmos5l_decap_8
XFILLER_44_245 VPWR VGND sg13cmos5l_decap_8
XFILLER_8_102 VPWR VGND sg13cmos5l_decap_8
X_088__30 _088__30/L_HI VPWR VGND sg13cmos5l_tiehi
XFILLER_8_179 VPWR VGND sg13cmos5l_decap_8
XFILLER_12_175 VPWR VGND sg13cmos5l_decap_8
XFILLER_35_289 VPWR VGND sg13cmos5l_decap_8
XFILLER_41_259 VPWR VGND sg13cmos5l_decap_8
XFILLER_26_245 VPWR VGND sg13cmos5l_decap_8
XFILLER_5_105 VPWR VGND sg13cmos5l_decap_8
XFILLER_49_315 VPWR VGND sg13cmos5l_decap_8
XFILLER_1_322 VPWR VGND sg13cmos5l_decap_8
XFILLER_17_245 VPWR VGND sg13cmos5l_decap_8
XFILLER_43_70 VPWR VGND sg13cmos5l_decap_8
XFILLER_32_259 VPWR VGND sg13cmos5l_decap_8
XFILLER_4_182 VPWR VGND sg13cmos5l_decap_8
XFILLER_4_42 VPWR VGND sg13cmos5l_decap_8
XFILLER_23_259 VPWR VGND sg13cmos5l_decap_8
XFILLER_31_270 VPWR VGND sg13cmos5l_decap_8
XFILLER_46_329 VPWR VGND sg13cmos5l_decap_8
XFILLER_22_270 VPWR VGND sg13cmos5l_fill_1
XFILLER_13_84 VPWR VGND sg13cmos5l_decap_8
XFILLER_49_189 VPWR VGND sg13cmos5l_decap_8
XFILLER_49_112 VPWR VGND sg13cmos5l_decap_8
XFILLER_38_70 VPWR VGND sg13cmos5l_decap_8
XFILLER_1_196 VPWR VGND sg13cmos5l_decap_8
XFILLER_9_252 VPWR VGND sg13cmos5l_decap_8
XFILLER_20_207 VPWR VGND sg13cmos5l_decap_8
XFILLER_34_28 VPWR VGND sg13cmos5l_decap_8
XFILLER_1_7 VPWR VGND sg13cmos5l_decap_8
XFILLER_46_126 VPWR VGND sg13cmos5l_decap_8
XFILLER_42_354 VPWR VGND sg13cmos5l_fill_1
XFILLER_42_310 VPWR VGND sg13cmos5l_decap_8
XFILLER_10_273 VPWR VGND sg13cmos5l_decap_8
XFILLER_34_7 VPWR VGND sg13cmos5l_decap_8
XFILLER_6_266 VPWR VGND sg13cmos5l_decap_8
XFILLER_49_91 VPWR VGND sg13cmos5l_decap_8
XFILLER_37_137 VPWR VGND sg13cmos5l_decap_8
XFILLER_1_21 VPWR VGND sg13cmos5l_decap_8
XFILLER_1_98 VPWR VGND sg13cmos5l_decap_8
XFILLER_33_343 VPWR VGND sg13cmos5l_decap_8
Xhold39 _055_/B _081_/Q VPWR VGND sg13cmos5l_dlygate4sd3_1
XFILLER_29_28 VPWR VGND sg13cmos5l_decap_8
XFILLER_45_49 VPWR VGND sg13cmos5l_decap_8
XFILLER_24_332 VPWR VGND sg13cmos5l_decap_8
XFILLER_28_126 VPWR VGND sg13cmos5l_decap_8
XFILLER_3_203 VPWR VGND sg13cmos5l_decap_8
XFILLER_10_63 VPWR VGND sg13cmos5l_decap_8
Xrtl_buf_rst output12/A _073_/A VPWR VGND sg13cmos5l_buf_1
XFILLER_19_126 VPWR VGND sg13cmos5l_decap_8
XFILLER_42_140 VPWR VGND sg13cmos5l_decap_8
XFILLER_15_332 VPWR VGND sg13cmos5l_decap_8
XFILLER_30_357 VPWR VGND sg13cmos5l_fill_2
XFILLER_2_291 VPWR VGND sg13cmos5l_decap_8
X_079_ _079_/Q _085_/CLK _079_/D _079__15/L_HI VPWR VGND sg13cmos5l_dfrbpq_1
XFILLER_33_140 VPWR VGND sg13cmos5l_decap_8
XFILLER_31_18 VPWR VGND sg13cmos5l_decap_8
XFILLER_0_217 VPWR VGND sg13cmos5l_decap_8
XFILLER_24_140 VPWR VGND sg13cmos5l_decap_8
XFILLER_12_357 VPWR VGND sg13cmos5l_fill_2
XFILLER_21_84 VPWR VGND sg13cmos5l_decap_8
XFILLER_47_287 VPWR VGND sg13cmos5l_decap_8
XFILLER_47_210 VPWR VGND sg13cmos5l_decap_8
XFILLER_46_70 VPWR VGND sg13cmos5l_decap_8
XFILLER_30_154 VPWR VGND sg13cmos5l_decap_8
XFILLER_15_140 VPWR VGND sg13cmos5l_decap_8
XFILLER_7_42 VPWR VGND sg13cmos5l_decap_8
XFILLER_7_350 VPWR VGND sg13cmos5l_decap_8
XFILLER_38_210 VPWR VGND sg13cmos5l_decap_8
XFILLER_23_0 VPWR VGND sg13cmos5l_decap_8
XFILLER_38_287 VPWR VGND sg13cmos5l_decap_8
XFILLER_42_28 VPWR VGND sg13cmos5l_decap_8
XFILLER_21_154 VPWR VGND sg13cmos5l_decap_8
XFILLER_44_224 VPWR VGND sg13cmos5l_decap_8
XFILLER_29_298 VPWR VGND sg13cmos5l_decap_8
XFILLER_29_210 VPWR VGND sg13cmos5l_decap_8
XFILLER_12_154 VPWR VGND sg13cmos5l_decap_8
XFILLER_16_84 VPWR VGND sg13cmos5l_decap_8
XFILLER_8_158 VPWR VGND sg13cmos5l_decap_8
XFILLER_35_268 VPWR VGND sg13cmos5l_decap_8
XFILLER_35_235 VPWR VGND sg13cmos5l_fill_2
XFILLER_35_224 VPWR VGND sg13cmos5l_decap_8
XFILLER_37_39 VPWR VGND sg13cmos5l_decap_8
XFILLER_26_224 VPWR VGND sg13cmos5l_decap_8
XFILLER_41_238 VPWR VGND sg13cmos5l_decap_8
XFILLER_34_290 VPWR VGND sg13cmos5l_fill_1
XFILLER_1_301 VPWR VGND sg13cmos5l_decap_8
XFILLER_32_238 VPWR VGND sg13cmos5l_decap_8
XFILLER_17_224 VPWR VGND sg13cmos5l_decap_8
XFILLER_4_161 VPWR VGND sg13cmos5l_decap_8
XFILLER_4_21 VPWR VGND sg13cmos5l_decap_8
XFILLER_4_98 VPWR VGND sg13cmos5l_decap_8
XFILLER_23_238 VPWR VGND sg13cmos5l_decap_8
XFILLER_2_109 VPWR VGND sg13cmos5l_decap_8
XFILLER_46_308 VPWR VGND sg13cmos5l_decap_8
XFILLER_13_63 VPWR VGND sg13cmos5l_decap_8
XFILLER_14_249 VPWR VGND sg13cmos5l_decap_8
XFILLER_49_168 VPWR VGND sg13cmos5l_decap_8
XFILLER_37_319 VPWR VGND sg13cmos5l_decap_8
XFILLER_1_175 VPWR VGND sg13cmos5l_decap_8
XFILLER_9_231 VPWR VGND sg13cmos5l_decap_8
XFILLER_28_319 VPWR VGND sg13cmos5l_decap_8
XFILLER_46_105 VPWR VGND sg13cmos5l_decap_8
XFILLER_27_330 VPWR VGND sg13cmos5l_decap_8
XFILLER_6_245 VPWR VGND sg13cmos5l_decap_8
XFILLER_10_252 VPWR VGND sg13cmos5l_decap_8
XFILLER_24_84 VPWR VGND sg13cmos5l_decap_8
XFILLER_49_70 VPWR VGND sg13cmos5l_decap_8
XFILLER_27_7 VPWR VGND sg13cmos5l_decap_8
XFILLER_37_116 VPWR VGND sg13cmos5l_decap_8
XFILLER_1_77 VPWR VGND sg13cmos5l_decap_8
XFILLER_45_182 VPWR VGND sg13cmos5l_decap_8
XFILLER_33_322 VPWR VGND sg13cmos5l_decap_8
XFILLER_28_105 VPWR VGND sg13cmos5l_decap_8
XFILLER_45_28 VPWR VGND sg13cmos5l_decap_8
XFILLER_43_119 VPWR VGND sg13cmos5l_decap_8
XFILLER_36_182 VPWR VGND sg13cmos5l_decap_8
XFILLER_3_259 VPWR VGND sg13cmos5l_decap_8
XFILLER_10_42 VPWR VGND sg13cmos5l_decap_8
XFILLER_34_119 VPWR VGND sg13cmos5l_decap_8
XFILLER_19_105 VPWR VGND sg13cmos5l_decap_8
XFILLER_19_84 VPWR VGND sg13cmos5l_decap_8
XFILLER_42_196 VPWR VGND sg13cmos5l_decap_8
XFILLER_30_336 VPWR VGND sg13cmos5l_decap_8
XFILLER_27_182 VPWR VGND sg13cmos5l_decap_8
X_078_ _078_/Q _089_/CLK _078_/D _078__24/L_HI VPWR VGND sg13cmos5l_dfrbpq_1
XFILLER_2_270 VPWR VGND sg13cmos5l_decap_8
XFILLER_25_4 VPWR VGND sg13cmos5l_decap_8
XFILLER_18_182 VPWR VGND sg13cmos5l_decap_8
XFILLER_33_196 VPWR VGND sg13cmos5l_decap_8
XFILLER_16_119 VPWR VGND sg13cmos5l_decap_8
XFILLER_12_336 VPWR VGND sg13cmos5l_decap_8
XFILLER_24_196 VPWR VGND sg13cmos5l_decap_8
XFILLER_21_63 VPWR VGND sg13cmos5l_decap_8
XFILLER_47_266 VPWR VGND sg13cmos5l_decap_8
XFILLER_30_133 VPWR VGND sg13cmos5l_decap_8
XFILLER_7_21 VPWR VGND sg13cmos5l_decap_8
XFILLER_15_196 VPWR VGND sg13cmos5l_decap_8
XFILLER_7_98 VPWR VGND sg13cmos5l_decap_8
XFILLER_38_266 VPWR VGND sg13cmos5l_decap_8
XFILLER_16_0 VPWR VGND sg13cmos5l_decap_8
XFILLER_21_133 VPWR VGND sg13cmos5l_decap_8
XFILLER_44_203 VPWR VGND sg13cmos5l_decap_8
XFILLER_8_137 VPWR VGND sg13cmos5l_decap_8
XFILLER_12_133 VPWR VGND sg13cmos5l_decap_8
XFILLER_16_63 VPWR VGND sg13cmos5l_decap_8
XFILLER_32_84 VPWR VGND sg13cmos5l_decap_8
XFILLER_4_343 VPWR VGND sg13cmos5l_decap_8
XFILLER_35_203 VPWR VGND sg13cmos5l_decap_8
XFILLER_43_280 VPWR VGND sg13cmos5l_decap_8
XFILLER_37_18 VPWR VGND sg13cmos5l_decap_8
XFILLER_26_203 VPWR VGND sg13cmos5l_decap_8
XFILLER_41_217 VPWR VGND sg13cmos5l_decap_8
XFILLER_1_357 VPWR VGND sg13cmos5l_fill_2
XFILLER_17_203 VPWR VGND sg13cmos5l_decap_8
XFILLER_32_217 VPWR VGND sg13cmos5l_decap_8
XFILLER_25_291 VPWR VGND sg13cmos5l_decap_4
XFILLER_27_84 VPWR VGND sg13cmos5l_decap_8
XFILLER_4_140 VPWR VGND sg13cmos5l_decap_8
XFILLER_4_77 VPWR VGND sg13cmos5l_decap_8
XFILLER_16_280 VPWR VGND sg13cmos5l_decap_8
XFILLER_23_217 VPWR VGND sg13cmos5l_decap_8
XFILLER_48_39 VPWR VGND sg13cmos5l_decap_8
XFILLER_39_350 VPWR VGND sg13cmos5l_decap_8
XFILLER_14_228 VPWR VGND sg13cmos5l_decap_8
XFILLER_13_42 VPWR VGND sg13cmos5l_decap_8
XFILLER_1_154 VPWR VGND sg13cmos5l_decap_8
XFILLER_49_147 VPWR VGND sg13cmos5l_decap_8
XFILLER_9_210 VPWR VGND sg13cmos5l_decap_8
XFILLER_13_294 VPWR VGND sg13cmos5l_decap_8
XFILLER_9_287 VPWR VGND sg13cmos5l_decap_8
XFILLER_36_353 VPWR VGND sg13cmos5l_decap_4
XFILLER_42_345 VPWR VGND sg13cmos5l_decap_8
XFILLER_24_63 VPWR VGND sg13cmos5l_decap_8
XFILLER_40_84 VPWR VGND sg13cmos5l_decap_8
XFILLER_6_224 VPWR VGND sg13cmos5l_decap_8
XFILLER_10_231 VPWR VGND sg13cmos5l_decap_8
XFILLER_45_161 VPWR VGND sg13cmos5l_decap_8
XFILLER_33_301 VPWR VGND sg13cmos5l_decap_8
XFILLER_1_56 VPWR VGND sg13cmos5l_decap_8
XFILLER_46_0 VPWR VGND sg13cmos5l_decap_8
XFILLER_36_161 VPWR VGND sg13cmos5l_decap_8
XFILLER_24_345 VPWR VGND sg13cmos5l_decap_8
XFILLER_10_21 VPWR VGND sg13cmos5l_decap_8
Xook_digital_system in_tieoff VPWR VGND sg13cmos5l_tielo
XFILLER_3_238 VPWR VGND sg13cmos5l_decap_8
XFILLER_10_98 VPWR VGND sg13cmos5l_decap_8
XFILLER_15_301 VPWR VGND sg13cmos5l_decap_8
XFILLER_19_63 VPWR VGND sg13cmos5l_decap_8
XFILLER_27_161 VPWR VGND sg13cmos5l_decap_8
XFILLER_42_175 VPWR VGND sg13cmos5l_decap_8
XFILLER_35_84 VPWR VGND sg13cmos5l_decap_8
XFILLER_30_315 VPWR VGND sg13cmos5l_decap_8
X_077_ _077_/Q _077_/CLK _077_/D _077__26/L_HI VPWR VGND sg13cmos5l_dfrbpq_1
XFILLER_33_175 VPWR VGND sg13cmos5l_decap_8
XFILLER_18_161 VPWR VGND sg13cmos5l_decap_8
XFILLER_21_304 VPWR VGND sg13cmos5l_fill_1
XFILLER_25_109 VPWR VGND sg13cmos5l_decap_8
XFILLER_8_319 VPWR VGND sg13cmos5l_decap_8
XFILLER_12_315 VPWR VGND sg13cmos5l_decap_8
XFILLER_24_175 VPWR VGND sg13cmos5l_decap_8
XFILLER_21_42 VPWR VGND sg13cmos5l_decap_8
XFILLER_47_245 VPWR VGND sg13cmos5l_decap_8
XFILLER_30_112 VPWR VGND sg13cmos5l_decap_8
XFILLER_15_175 VPWR VGND sg13cmos5l_decap_8
XFILLER_30_189 VPWR VGND sg13cmos5l_decap_8
XFILLER_7_77 VPWR VGND sg13cmos5l_decap_8
XFILLER_38_245 VPWR VGND sg13cmos5l_decap_8
XFILLER_21_112 VPWR VGND sg13cmos5l_decap_8
XFILLER_21_189 VPWR VGND sg13cmos5l_decap_8
XFILLER_29_245 VPWR VGND sg13cmos5l_decap_8
XFILLER_44_259 VPWR VGND sg13cmos5l_decap_8
XFILLER_16_42 VPWR VGND sg13cmos5l_decap_8
XFILLER_32_63 VPWR VGND sg13cmos5l_decap_8
XFILLER_8_116 VPWR VGND sg13cmos5l_decap_8
XFILLER_12_112 VPWR VGND sg13cmos5l_decap_8
XFILLER_12_189 VPWR VGND sg13cmos5l_decap_8
XFILLER_4_322 VPWR VGND sg13cmos5l_decap_8
XFILLER_7_182 VPWR VGND sg13cmos5l_decap_8
XFILLER_26_259 VPWR VGND sg13cmos5l_decap_8
XFILLER_5_119 VPWR VGND sg13cmos5l_decap_8
XFILLER_1_336 VPWR VGND sg13cmos5l_decap_8
XFILLER_49_329 VPWR VGND sg13cmos5l_decap_8
XFILLER_27_63 VPWR VGND sg13cmos5l_decap_8
XFILLER_17_259 VPWR VGND sg13cmos5l_decap_8
XFILLER_25_270 VPWR VGND sg13cmos5l_decap_8
XFILLER_43_84 VPWR VGND sg13cmos5l_decap_8
XFILLER_40_284 VPWR VGND sg13cmos5l_fill_1
XFILLER_40_273 VPWR VGND sg13cmos5l_decap_8
XFILLER_4_196 VPWR VGND sg13cmos5l_decap_8
XFILLER_4_56 VPWR VGND sg13cmos5l_decap_8
XFILLER_48_340 VPWR VGND sg13cmos5l_decap_8
XFILLER_31_284 VPWR VGND sg13cmos5l_decap_8
XFILLER_48_18 VPWR VGND sg13cmos5l_decap_8
XFILLER_14_207 VPWR VGND sg13cmos5l_decap_8
XFILLER_13_21 VPWR VGND sg13cmos5l_decap_8
XFILLER_13_98 VPWR VGND sg13cmos5l_decap_8
XFILLER_49_126 VPWR VGND sg13cmos5l_decap_8
XFILLER_1_133 VPWR VGND sg13cmos5l_decap_8
XFILLER_45_343 VPWR VGND sg13cmos5l_decap_8
XFILLER_38_84 VPWR VGND sg13cmos5l_decap_8
XFILLER_9_266 VPWR VGND sg13cmos5l_decap_8
XFILLER_13_273 VPWR VGND sg13cmos5l_decap_8
XFILLER_48_4 VPWR VGND sg13cmos5l_decap_8
XFILLER_36_332 VPWR VGND sg13cmos5l_decap_8
XFILLER_42_324 VPWR VGND sg13cmos5l_decap_8
XFILLER_10_210 VPWR VGND sg13cmos5l_decap_8
XFILLER_24_42 VPWR VGND sg13cmos5l_decap_8
XFILLER_40_63 VPWR VGND sg13cmos5l_decap_8
XFILLER_6_203 VPWR VGND sg13cmos5l_decap_8
XFILLER_6_0 VPWR VGND sg13cmos5l_decap_8
XFILLER_10_287 VPWR VGND sg13cmos5l_decap_8
XFILLER_1_35 VPWR VGND sg13cmos5l_decap_8
XFILLER_45_140 VPWR VGND sg13cmos5l_decap_8
XFILLER_33_357 VPWR VGND sg13cmos5l_fill_2
XFILLER_18_332 VPWR VGND sg13cmos5l_decap_8
XFILLER_39_0 VPWR VGND sg13cmos5l_decap_8
XFILLER_5_280 VPWR VGND sg13cmos5l_decap_8
Xinput1 _072_/B data_in_tx VPWR VGND sg13cmos5l_buf_1
XFILLER_36_140 VPWR VGND sg13cmos5l_decap_8
XFILLER_3_217 VPWR VGND sg13cmos5l_decap_8
XFILLER_10_77 VPWR VGND sg13cmos5l_decap_8
XFILLER_19_42 VPWR VGND sg13cmos5l_decap_8
XFILLER_42_154 VPWR VGND sg13cmos5l_decap_8
XFILLER_35_63 VPWR VGND sg13cmos5l_decap_8
XFILLER_15_346 VPWR VGND sg13cmos5l_decap_8
XFILLER_15_357 VPWR VGND sg13cmos5l_fill_2
XFILLER_27_140 VPWR VGND sg13cmos5l_decap_8
XFILLER_32_7 VPWR VGND sg13cmos5l_decap_8
X_076_ _076_/Q _077_/CLK _076_/D _076__28/L_HI VPWR VGND sg13cmos5l_dfrbpq_1
XFILLER_18_140 VPWR VGND sg13cmos5l_decap_8
XFILLER_33_154 VPWR VGND sg13cmos5l_decap_8
XFILLER_21_21 VPWR VGND sg13cmos5l_decap_8
XFILLER_24_154 VPWR VGND sg13cmos5l_decap_8
XFILLER_21_98 VPWR VGND sg13cmos5l_decap_8
XFILLER_47_224 VPWR VGND sg13cmos5l_decap_8
XFILLER_46_84 VPWR VGND sg13cmos5l_decap_8
XFILLER_15_154 VPWR VGND sg13cmos5l_decap_8
XFILLER_30_168 VPWR VGND sg13cmos5l_decap_8
XFILLER_7_56 VPWR VGND sg13cmos5l_decap_8
X_059_ _059_/Y _057_/A _063_/C _059_/C VPWR VGND sg13cmos5l_nand3b_1
XFILLER_38_224 VPWR VGND sg13cmos5l_decap_8
XFILLER_21_168 VPWR VGND sg13cmos5l_decap_8
XFILLER_29_279 VPWR VGND sg13cmos5l_decap_4
XFILLER_29_224 VPWR VGND sg13cmos5l_decap_8
XFILLER_44_238 VPWR VGND sg13cmos5l_decap_8
XFILLER_16_21 VPWR VGND sg13cmos5l_decap_8
XFILLER_16_98 VPWR VGND sg13cmos5l_decap_8
XFILLER_32_42 VPWR VGND sg13cmos5l_decap_8
XFILLER_4_301 VPWR VGND sg13cmos5l_decap_8
XFILLER_12_168 VPWR VGND sg13cmos5l_decap_8
XFILLER_7_161 VPWR VGND sg13cmos5l_decap_8
XFILLER_21_0 VPWR VGND sg13cmos5l_decap_8
XFILLER_26_238 VPWR VGND sg13cmos5l_decap_8
XFILLER_49_308 VPWR VGND sg13cmos5l_decap_8
XFILLER_1_315 VPWR VGND sg13cmos5l_decap_8
XFILLER_17_238 VPWR VGND sg13cmos5l_decap_8
XFILLER_27_42 VPWR VGND sg13cmos5l_decap_8
XFILLER_43_63 VPWR VGND sg13cmos5l_decap_8
XFILLER_40_252 VPWR VGND sg13cmos5l_decap_8
XFILLER_4_175 VPWR VGND sg13cmos5l_decap_8
XFILLER_4_35 VPWR VGND sg13cmos5l_decap_8
XFILLER_31_263 VPWR VGND sg13cmos5l_decap_8
XFILLER_22_252 VPWR VGND sg13cmos5l_decap_8
XFILLER_13_77 VPWR VGND sg13cmos5l_decap_8
XFILLER_49_105 VPWR VGND sg13cmos5l_decap_8
XFILLER_38_63 VPWR VGND sg13cmos5l_decap_8
XFILLER_1_112 VPWR VGND sg13cmos5l_decap_8
XFILLER_1_189 VPWR VGND sg13cmos5l_decap_8
XFILLER_8_4 VPWR VGND sg13cmos5l_decap_8
XFILLER_45_322 VPWR VGND sg13cmos5l_decap_8
XFILLER_9_245 VPWR VGND sg13cmos5l_decap_8
XFILLER_13_252 VPWR VGND sg13cmos5l_decap_8
XFILLER_48_193 VPWR VGND sg13cmos5l_decap_8
XFILLER_36_311 VPWR VGND sg13cmos5l_decap_8
XFILLER_46_119 VPWR VGND sg13cmos5l_decap_8
XFILLER_42_303 VPWR VGND sg13cmos5l_decap_8
XFILLER_39_182 VPWR VGND sg13cmos5l_decap_8
XFILLER_10_266 VPWR VGND sg13cmos5l_decap_8
Xrtl_buf_clk output7/A rtl_buf_clk/A VPWR VGND sg13cmos5l_buf_1
XFILLER_24_21 VPWR VGND sg13cmos5l_decap_8
XFILLER_24_98 VPWR VGND sg13cmos5l_decap_8
XFILLER_40_42 VPWR VGND sg13cmos5l_decap_8
XFILLER_6_259 VPWR VGND sg13cmos5l_decap_8
XFILLER_49_84 VPWR VGND sg13cmos5l_decap_8
XFILLER_1_14 VPWR VGND sg13cmos5l_decap_8
XFILLER_45_196 VPWR VGND sg13cmos5l_decap_8
XFILLER_33_336 VPWR VGND sg13cmos5l_decap_8
XFILLER_36_196 VPWR VGND sg13cmos5l_decap_8
Xinput2 _088_/D q0 VPWR VGND sg13cmos5l_buf_1
XFILLER_28_119 VPWR VGND sg13cmos5l_decap_8
XFILLER_10_56 VPWR VGND sg13cmos5l_decap_8
XFILLER_19_21 VPWR VGND sg13cmos5l_decap_8
XFILLER_19_98 VPWR VGND sg13cmos5l_decap_8
XFILLER_19_119 VPWR VGND sg13cmos5l_decap_8
XFILLER_42_133 VPWR VGND sg13cmos5l_decap_8
XFILLER_35_42 VPWR VGND sg13cmos5l_decap_8
XFILLER_27_196 VPWR VGND sg13cmos5l_decap_8
X_075_ _075_/Q _077_/CLK _075_/D _075__29/L_HI VPWR VGND sg13cmos5l_dfrbpq_1
XFILLER_2_284 VPWR VGND sg13cmos5l_decap_8
XFILLER_33_133 VPWR VGND sg13cmos5l_decap_8
XFILLER_18_196 VPWR VGND sg13cmos5l_decap_8
XFILLER_21_339 VPWR VGND sg13cmos5l_fill_2
XFILLER_24_133 VPWR VGND sg13cmos5l_decap_8
XFILLER_21_77 VPWR VGND sg13cmos5l_decap_8
XFILLER_47_203 VPWR VGND sg13cmos5l_decap_8
XFILLER_46_63 VPWR VGND sg13cmos5l_decap_8
XFILLER_30_147 VPWR VGND sg13cmos5l_decap_8
XFILLER_11_350 VPWR VGND sg13cmos5l_decap_8
XFILLER_15_133 VPWR VGND sg13cmos5l_decap_8
XFILLER_7_35 VPWR VGND sg13cmos5l_decap_8
XFILLER_7_343 VPWR VGND sg13cmos5l_decap_8
X_058_ _075_/D _073_/A _058_/B VPWR VGND sg13cmos5l_and2_1
XFILLER_38_203 VPWR VGND sg13cmos5l_decap_8
XFILLER_46_280 VPWR VGND sg13cmos5l_decap_8
XFILLER_21_147 VPWR VGND sg13cmos5l_decap_8
XFILLER_44_217 VPWR VGND sg13cmos5l_decap_8
XFILLER_29_203 VPWR VGND sg13cmos5l_decap_8
XFILLER_37_291 VPWR VGND sg13cmos5l_decap_8
XFILLER_32_21 VPWR VGND sg13cmos5l_decap_8
XFILLER_12_147 VPWR VGND sg13cmos5l_decap_8
XFILLER_16_77 VPWR VGND sg13cmos5l_decap_8
XFILLER_32_98 VPWR VGND sg13cmos5l_decap_8
XFILLER_4_357 VPWR VGND sg13cmos5l_fill_2
XFILLER_35_217 VPWR VGND sg13cmos5l_decap_8
XFILLER_28_280 VPWR VGND sg13cmos5l_decap_8
XFILLER_43_294 VPWR VGND sg13cmos5l_decap_8
XFILLER_7_140 VPWR VGND sg13cmos5l_decap_8
XFILLER_26_217 VPWR VGND sg13cmos5l_decap_8
XFILLER_17_217 VPWR VGND sg13cmos5l_decap_8
XFILLER_27_21 VPWR VGND sg13cmos5l_decap_8
XFILLER_27_98 VPWR VGND sg13cmos5l_decap_8
XFILLER_43_42 VPWR VGND sg13cmos5l_decap_8
XFILLER_40_231 VPWR VGND sg13cmos5l_decap_8
XFILLER_4_154 VPWR VGND sg13cmos5l_decap_8
XFILLER_4_14 VPWR VGND sg13cmos5l_decap_8
XFILLER_31_242 VPWR VGND sg13cmos5l_decap_8
XFILLER_16_294 VPWR VGND sg13cmos5l_decap_8
XFILLER_13_56 VPWR VGND sg13cmos5l_decap_8
XFILLER_22_231 VPWR VGND sg13cmos5l_decap_8
XFILLER_45_301 VPWR VGND sg13cmos5l_decap_8
XFILLER_38_42 VPWR VGND sg13cmos5l_decap_8
XFILLER_1_168 VPWR VGND sg13cmos5l_decap_8
XFILLER_13_231 VPWR VGND sg13cmos5l_decap_8
XFILLER_9_224 VPWR VGND sg13cmos5l_decap_8
XFILLER_48_172 VPWR VGND sg13cmos5l_decap_8
XFILLER_39_161 VPWR VGND sg13cmos5l_decap_8
XFILLER_27_301 VPWR VGND sg13cmos5l_fill_2
XFILLER_40_21 VPWR VGND sg13cmos5l_decap_8
XFILLER_6_238 VPWR VGND sg13cmos5l_decap_8
XFILLER_10_245 VPWR VGND sg13cmos5l_decap_8
XFILLER_24_77 VPWR VGND sg13cmos5l_decap_8
XFILLER_49_63 VPWR VGND sg13cmos5l_decap_8
XFILLER_40_98 VPWR VGND sg13cmos5l_decap_8
XFILLER_37_109 VPWR VGND sg13cmos5l_decap_8
XFILLER_45_175 VPWR VGND sg13cmos5l_decap_8
XFILLER_33_315 VPWR VGND sg13cmos5l_decap_8
XFILLER_36_175 VPWR VGND sg13cmos5l_decap_8
Xinput3 _086_/D q1 VPWR VGND sg13cmos5l_buf_1
XFILLER_10_35 VPWR VGND sg13cmos5l_decap_8
XFILLER_19_77 VPWR VGND sg13cmos5l_decap_8
XFILLER_42_189 VPWR VGND sg13cmos5l_decap_8
XFILLER_42_112 VPWR VGND sg13cmos5l_decap_8
XFILLER_35_98 VPWR VGND sg13cmos5l_decap_8
XFILLER_35_21 VPWR VGND sg13cmos5l_decap_8
XFILLER_30_329 VPWR VGND sg13cmos5l_decap_8
XFILLER_15_315 VPWR VGND sg13cmos5l_decap_4
XFILLER_27_175 VPWR VGND sg13cmos5l_decap_8
X_074_ _074_/Q _077_/CLK _074_/D _074__22/L_HI VPWR VGND sg13cmos5l_dfrbpq_1
XFILLER_2_263 VPWR VGND sg13cmos5l_decap_8
XFILLER_33_112 VPWR VGND sg13cmos5l_decap_8
XFILLER_18_7 VPWR VGND sg13cmos5l_decap_8
XFILLER_18_175 VPWR VGND sg13cmos5l_decap_8
XFILLER_33_189 VPWR VGND sg13cmos5l_decap_8
XFILLER_44_0 VPWR VGND sg13cmos5l_decap_8
XFILLER_12_329 VPWR VGND sg13cmos5l_decap_8
XFILLER_24_112 VPWR VGND sg13cmos5l_decap_8
XFILLER_24_189 VPWR VGND sg13cmos5l_decap_8
XFILLER_21_56 VPWR VGND sg13cmos5l_decap_8
XFILLER_47_259 VPWR VGND sg13cmos5l_decap_8
XFILLER_46_42 VPWR VGND sg13cmos5l_decap_8
XFILLER_15_112 VPWR VGND sg13cmos5l_decap_8
XFILLER_30_126 VPWR VGND sg13cmos5l_decap_8
XFILLER_7_14 VPWR VGND sg13cmos5l_decap_8
XFILLER_7_322 VPWR VGND sg13cmos5l_decap_8
XFILLER_15_189 VPWR VGND sg13cmos5l_decap_8
X_057_ _058_/B _057_/A _063_/C VPWR VGND sg13cmos5l_nor2b_1
XFILLER_38_259 VPWR VGND sg13cmos5l_decap_8
XFILLER_21_126 VPWR VGND sg13cmos5l_decap_8
XFILLER_37_270 VPWR VGND sg13cmos5l_decap_8
XFILLER_29_259 VPWR VGND sg13cmos5l_decap_4
XFILLER_12_126 VPWR VGND sg13cmos5l_decap_8
XFILLER_16_56 VPWR VGND sg13cmos5l_decap_8
XFILLER_32_77 VPWR VGND sg13cmos5l_decap_8
XFILLER_4_336 VPWR VGND sg13cmos5l_decap_8
XFILLER_43_273 VPWR VGND sg13cmos5l_decap_8
XFILLER_7_196 VPWR VGND sg13cmos5l_decap_8
XFILLER_19_270 VPWR VGND sg13cmos5l_fill_2
XFILLER_43_21 VPWR VGND sg13cmos5l_decap_8
XFILLER_40_210 VPWR VGND sg13cmos5l_decap_8
XFILLER_25_284 VPWR VGND sg13cmos5l_decap_8
XFILLER_27_77 VPWR VGND sg13cmos5l_decap_8
XFILLER_43_98 VPWR VGND sg13cmos5l_decap_8
X_076__28 _076__28/L_HI VPWR VGND sg13cmos5l_tiehi
XFILLER_25_295 VPWR VGND sg13cmos5l_fill_2
XFILLER_4_133 VPWR VGND sg13cmos5l_decap_8
XFILLER_48_354 VPWR VGND sg13cmos5l_fill_1
XFILLER_0_350 VPWR VGND sg13cmos5l_decap_8
XFILLER_31_221 VPWR VGND sg13cmos5l_decap_8
XFILLER_16_273 VPWR VGND sg13cmos5l_decap_8
XFILLER_31_298 VPWR VGND sg13cmos5l_decap_8
XFILLER_39_343 VPWR VGND sg13cmos5l_decap_8
XFILLER_22_210 VPWR VGND sg13cmos5l_decap_8
XFILLER_13_35 VPWR VGND sg13cmos5l_decap_8
XFILLER_1_147 VPWR VGND sg13cmos5l_decap_8
XFILLER_38_98 VPWR VGND sg13cmos5l_decap_8
XFILLER_38_21 VPWR VGND sg13cmos5l_decap_8
XFILLER_45_357 VPWR VGND sg13cmos5l_fill_2
XFILLER_9_203 VPWR VGND sg13cmos5l_decap_8
XFILLER_13_210 VPWR VGND sg13cmos5l_decap_8
XFILLER_13_287 VPWR VGND sg13cmos5l_decap_8
XFILLER_48_151 VPWR VGND sg13cmos5l_decap_8
XFILLER_36_357 VPWR VGND sg13cmos5l_fill_2
XFILLER_36_346 VPWR VGND sg13cmos5l_decap_8
XFILLER_5_91 VPWR VGND sg13cmos5l_decap_8
XFILLER_8_291 VPWR VGND sg13cmos5l_decap_8
XFILLER_39_140 VPWR VGND sg13cmos5l_decap_8
XFILLER_42_338 VPWR VGND sg13cmos5l_decap_8
XFILLER_24_56 VPWR VGND sg13cmos5l_decap_8
XFILLER_27_357 VPWR VGND sg13cmos5l_fill_2
XFILLER_40_77 VPWR VGND sg13cmos5l_decap_8
XFILLER_6_217 VPWR VGND sg13cmos5l_decap_8
XFILLER_10_224 VPWR VGND sg13cmos5l_decap_8
XFILLER_49_42 VPWR VGND sg13cmos5l_decap_8
XFILLER_45_154 VPWR VGND sg13cmos5l_decap_8
XFILLER_1_49 VPWR VGND sg13cmos5l_decap_8
XFILLER_18_346 VPWR VGND sg13cmos5l_fill_2
XFILLER_18_357 VPWR VGND sg13cmos5l_fill_2
XFILLER_5_294 VPWR VGND sg13cmos5l_decap_8
Xinput4 _084_/D q2 VPWR VGND sg13cmos5l_buf_1
XFILLER_36_154 VPWR VGND sg13cmos5l_decap_8
XFILLER_10_14 VPWR VGND sg13cmos5l_decap_8
XFILLER_19_56 VPWR VGND sg13cmos5l_decap_8
XFILLER_27_154 VPWR VGND sg13cmos5l_decap_8
XFILLER_42_168 VPWR VGND sg13cmos5l_decap_8
XFILLER_35_77 VPWR VGND sg13cmos5l_decap_8
Xclkbuf_2_3__f_clk_regs _089_/CLK clkbuf_0_clk_regs/X VPWR VGND sg13cmos5l_buf_8
XFILLER_4_0 VPWR VGND sg13cmos5l_decap_8
X_073_ _081_/D _073_/A _073_/B VPWR VGND sg13cmos5l_and2_1
XFILLER_2_242 VPWR VGND sg13cmos5l_decap_8
XFILLER_33_168 VPWR VGND sg13cmos5l_decap_8
XFILLER_18_154 VPWR VGND sg13cmos5l_decap_8
XFILLER_2_81 VPWR VGND sg13cmos5l_decap_8
XFILLER_12_308 VPWR VGND sg13cmos5l_decap_8
XFILLER_24_168 VPWR VGND sg13cmos5l_decap_8
XFILLER_21_35 VPWR VGND sg13cmos5l_decap_8
XFILLER_47_238 VPWR VGND sg13cmos5l_decap_8
XFILLER_46_98 VPWR VGND sg13cmos5l_decap_8
XFILLER_46_21 VPWR VGND sg13cmos5l_decap_8
XFILLER_15_168 VPWR VGND sg13cmos5l_decap_8
XFILLER_30_105 VPWR VGND sg13cmos5l_decap_8
XFILLER_7_301 VPWR VGND sg13cmos5l_decap_8
XFILLER_30_7 VPWR VGND sg13cmos5l_decap_8
X_056_ _063_/C _075_/Q _056_/B VPWR VGND sg13cmos5l_nand2b_1
XFILLER_38_238 VPWR VGND sg13cmos5l_decap_8
XFILLER_21_105 VPWR VGND sg13cmos5l_decap_8
XFILLER_16_35 VPWR VGND sg13cmos5l_decap_8
XFILLER_29_238 VPWR VGND sg13cmos5l_decap_8
XFILLER_32_56 VPWR VGND sg13cmos5l_decap_8
XFILLER_8_109 VPWR VGND sg13cmos5l_decap_8
XFILLER_12_105 VPWR VGND sg13cmos5l_decap_8
XFILLER_20_193 VPWR VGND sg13cmos5l_decap_8
XFILLER_4_315 VPWR VGND sg13cmos5l_decap_8
XFILLER_43_252 VPWR VGND sg13cmos5l_decap_8
XFILLER_7_175 VPWR VGND sg13cmos5l_decap_8
XFILLER_11_182 VPWR VGND sg13cmos5l_decap_8
X_079__15 _079__15/L_HI VPWR VGND sg13cmos5l_tiehi
XFILLER_34_252 VPWR VGND sg13cmos5l_fill_2
XFILLER_1_329 VPWR VGND sg13cmos5l_decap_8
XFILLER_25_263 VPWR VGND sg13cmos5l_decap_8
XFILLER_27_56 VPWR VGND sg13cmos5l_decap_8
XFILLER_43_77 VPWR VGND sg13cmos5l_decap_8
XFILLER_40_266 VPWR VGND sg13cmos5l_decap_8
XFILLER_4_112 VPWR VGND sg13cmos5l_decap_8
XFILLER_4_189 VPWR VGND sg13cmos5l_decap_8
XFILLER_4_49 VPWR VGND sg13cmos5l_decap_8
XFILLER_48_333 VPWR VGND sg13cmos5l_decap_8
XFILLER_31_277 VPWR VGND sg13cmos5l_decap_8
XFILLER_31_200 VPWR VGND sg13cmos5l_decap_8
XFILLER_16_252 VPWR VGND sg13cmos5l_decap_8
XFILLER_39_322 VPWR VGND sg13cmos5l_decap_8
XFILLER_13_14 VPWR VGND sg13cmos5l_decap_8
XFILLER_22_266 VPWR VGND sg13cmos5l_decap_4
XFILLER_49_119 VPWR VGND sg13cmos5l_decap_8
XFILLER_1_126 VPWR VGND sg13cmos5l_decap_8
XFILLER_45_336 VPWR VGND sg13cmos5l_decap_8
XFILLER_38_77 VPWR VGND sg13cmos5l_decap_8
XFILLER_9_259 VPWR VGND sg13cmos5l_decap_8
XFILLER_13_266 VPWR VGND sg13cmos5l_decap_8
XFILLER_48_130 VPWR VGND sg13cmos5l_decap_8
XFILLER_36_325 VPWR VGND sg13cmos5l_decap_8
XFILLER_8_270 VPWR VGND sg13cmos5l_decap_8
XFILLER_5_70 VPWR VGND sg13cmos5l_decap_8
XFILLER_39_196 VPWR VGND sg13cmos5l_decap_8
XFILLER_42_317 VPWR VGND sg13cmos5l_decap_8
Xclkbuf_2_2__f_clk_regs _086_/CLK clkbuf_0_clk_regs/X VPWR VGND sg13cmos5l_buf_8
XFILLER_10_203 VPWR VGND sg13cmos5l_decap_8
XFILLER_24_35 VPWR VGND sg13cmos5l_decap_8
XFILLER_40_56 VPWR VGND sg13cmos5l_decap_8
XFILLER_49_98 VPWR VGND sg13cmos5l_decap_8
XFILLER_49_21 VPWR VGND sg13cmos5l_decap_8
XFILLER_1_28 VPWR VGND sg13cmos5l_decap_8
XFILLER_45_133 VPWR VGND sg13cmos5l_decap_8
XFILLER_18_303 VPWR VGND sg13cmos5l_fill_2
XFILLER_5_273 VPWR VGND sg13cmos5l_decap_8
Xinput5 _082_/D q3 VPWR VGND sg13cmos5l_buf_1
XFILLER_36_133 VPWR VGND sg13cmos5l_decap_8
XFILLER_32_350 VPWR VGND sg13cmos5l_decap_8
XFILLER_24_339 VPWR VGND sg13cmos5l_fill_2
XFILLER_19_35 VPWR VGND sg13cmos5l_decap_8
XFILLER_35_56 VPWR VGND sg13cmos5l_decap_8
XFILLER_15_339 VPWR VGND sg13cmos5l_decap_8
XFILLER_27_133 VPWR VGND sg13cmos5l_decap_8
XFILLER_42_147 VPWR VGND sg13cmos5l_decap_8
X_072_ _080_/D _073_/A _072_/B VPWR VGND sg13cmos5l_and2_1
XFILLER_2_221 VPWR VGND sg13cmos5l_decap_8
XFILLER_2_298 VPWR VGND sg13cmos5l_decap_8
XFILLER_18_133 VPWR VGND sg13cmos5l_decap_8
XFILLER_33_147 VPWR VGND sg13cmos5l_decap_8
XFILLER_49_280 VPWR VGND sg13cmos5l_decap_8
XFILLER_2_60 VPWR VGND sg13cmos5l_decap_8
XFILLER_24_147 VPWR VGND sg13cmos5l_decap_8
XFILLER_21_14 VPWR VGND sg13cmos5l_decap_8
XFILLER_47_217 VPWR VGND sg13cmos5l_decap_8
XFILLER_46_77 VPWR VGND sg13cmos5l_decap_8
XFILLER_15_147 VPWR VGND sg13cmos5l_decap_8
XFILLER_7_49 VPWR VGND sg13cmos5l_decap_8
XFILLER_7_357 VPWR VGND sg13cmos5l_fill_2
X_055_ _056_/B _074_/Q _055_/B VPWR VGND sg13cmos5l_xnor2_1
XFILLER_11_91 VPWR VGND sg13cmos5l_decap_8
XFILLER_23_7 VPWR VGND sg13cmos5l_decap_8
XFILLER_46_294 VPWR VGND sg13cmos5l_decap_8
XFILLER_38_217 VPWR VGND sg13cmos5l_decap_8
XFILLER_29_217 VPWR VGND sg13cmos5l_decap_8
XFILLER_16_14 VPWR VGND sg13cmos5l_decap_8
XFILLER_32_35 VPWR VGND sg13cmos5l_decap_8
XFILLER_20_172 VPWR VGND sg13cmos5l_decap_8
XFILLER_43_231 VPWR VGND sg13cmos5l_decap_8
XFILLER_28_294 VPWR VGND sg13cmos5l_decap_8
XFILLER_7_154 VPWR VGND sg13cmos5l_decap_8
XFILLER_11_161 VPWR VGND sg13cmos5l_decap_8
XFILLER_34_231 VPWR VGND sg13cmos5l_decap_8
XFILLER_34_286 VPWR VGND sg13cmos5l_decap_4
XFILLER_8_81 VPWR VGND sg13cmos5l_decap_8
X_085__19 _085__19/L_HI VPWR VGND sg13cmos5l_tiehi
XFILLER_1_308 VPWR VGND sg13cmos5l_decap_8
XFILLER_27_35 VPWR VGND sg13cmos5l_decap_8
XFILLER_43_56 VPWR VGND sg13cmos5l_decap_8
XFILLER_40_245 VPWR VGND sg13cmos5l_decap_8
XFILLER_25_242 VPWR VGND sg13cmos5l_decap_8
XFILLER_48_312 VPWR VGND sg13cmos5l_decap_8
XFILLER_4_168 VPWR VGND sg13cmos5l_decap_8
XFILLER_4_28 VPWR VGND sg13cmos5l_decap_8
XFILLER_16_231 VPWR VGND sg13cmos5l_decap_8
XFILLER_31_256 VPWR VGND sg13cmos5l_decap_8
XFILLER_39_301 VPWR VGND sg13cmos5l_decap_8
XFILLER_12_0 VPWR VGND sg13cmos5l_decap_8
XFILLER_22_245 VPWR VGND sg13cmos5l_decap_8
Xclkbuf_2_1__f_clk_regs _077_/CLK clkbuf_0_clk_regs/X VPWR VGND sg13cmos5l_buf_8
XFILLER_1_105 VPWR VGND sg13cmos5l_decap_8
XFILLER_45_315 VPWR VGND sg13cmos5l_decap_8
XFILLER_38_56 VPWR VGND sg13cmos5l_decap_8
XFILLER_9_238 VPWR VGND sg13cmos5l_decap_8
XFILLER_13_245 VPWR VGND sg13cmos5l_decap_8
XFILLER_48_186 VPWR VGND sg13cmos5l_decap_8
XFILLER_36_304 VPWR VGND sg13cmos5l_decap_8
XFILLER_0_182 VPWR VGND sg13cmos5l_decap_8
XFILLER_39_175 VPWR VGND sg13cmos5l_decap_8
XFILLER_27_337 VPWR VGND sg13cmos5l_decap_4
XFILLER_10_259 VPWR VGND sg13cmos5l_decap_8
XFILLER_24_14 VPWR VGND sg13cmos5l_decap_8
XFILLER_40_35 VPWR VGND sg13cmos5l_decap_8
XFILLER_49_77 VPWR VGND sg13cmos5l_decap_8
XFILLER_45_189 VPWR VGND sg13cmos5l_decap_8
XFILLER_45_112 VPWR VGND sg13cmos5l_decap_8
XFILLER_33_329 VPWR VGND sg13cmos5l_decap_8
XFILLER_5_252 VPWR VGND sg13cmos5l_decap_8
Xinput6 _073_/A rst_n_in VPWR VGND sg13cmos5l_buf_1
XFILLER_36_112 VPWR VGND sg13cmos5l_decap_8
XFILLER_36_189 VPWR VGND sg13cmos5l_decap_8
XFILLER_10_49 VPWR VGND sg13cmos5l_decap_8
XFILLER_19_14 VPWR VGND sg13cmos5l_decap_8
XFILLER_42_126 VPWR VGND sg13cmos5l_decap_8
XFILLER_35_35 VPWR VGND sg13cmos5l_decap_8
XFILLER_27_112 VPWR VGND sg13cmos5l_decap_8
XFILLER_27_189 VPWR VGND sg13cmos5l_decap_8
X_071_ _071_/Y _044_/A _068_/B _070_/X VPWR VGND sg13cmos5l_a21oi_1
XFILLER_2_277 VPWR VGND sg13cmos5l_decap_8
XFILLER_2_200 VPWR VGND sg13cmos5l_decap_8
XFILLER_18_112 VPWR VGND sg13cmos5l_decap_8
XFILLER_33_126 VPWR VGND sg13cmos5l_decap_8
XFILLER_14_340 VPWR VGND sg13cmos5l_decap_8
XFILLER_18_189 VPWR VGND sg13cmos5l_decap_8
XFILLER_24_126 VPWR VGND sg13cmos5l_decap_8
XFILLER_20_332 VPWR VGND sg13cmos5l_decap_8
XFILLER_46_56 VPWR VGND sg13cmos5l_decap_8
XFILLER_15_126 VPWR VGND sg13cmos5l_decap_8
XFILLER_7_28 VPWR VGND sg13cmos5l_decap_8
XFILLER_7_336 VPWR VGND sg13cmos5l_decap_8
XFILLER_11_343 VPWR VGND sg13cmos5l_decap_8
X_054_ _054_/Y _047_/Y _057_/A _053_/Y VPWR VGND sg13cmos5l_a21oi_1
XFILLER_11_70 VPWR VGND sg13cmos5l_decap_8
XFILLER_46_273 VPWR VGND sg13cmos5l_decap_8
XFILLER_16_7 VPWR VGND sg13cmos5l_decap_8
XFILLER_42_0 VPWR VGND sg13cmos5l_decap_8
XFILLER_32_14 VPWR VGND sg13cmos5l_decap_8
XFILLER_20_151 VPWR VGND sg13cmos5l_decap_8
XFILLER_43_210 VPWR VGND sg13cmos5l_decap_8
XFILLER_28_273 VPWR VGND sg13cmos5l_decap_8
XFILLER_43_287 VPWR VGND sg13cmos5l_decap_8
XFILLER_11_140 VPWR VGND sg13cmos5l_decap_8
XFILLER_3_350 VPWR VGND sg13cmos5l_decap_4
XFILLER_7_133 VPWR VGND sg13cmos5l_decap_8
XFILLER_22_91 VPWR VGND sg13cmos5l_decap_8
XFILLER_14_4 VPWR VGND sg13cmos5l_decap_8
XFILLER_34_254 VPWR VGND sg13cmos5l_fill_1
XFILLER_34_210 VPWR VGND sg13cmos5l_decap_8
Xclkbuf_2_0__f_clk_regs _085_/CLK clkbuf_0_clk_regs/X VPWR VGND sg13cmos5l_buf_8
XFILLER_8_60 VPWR VGND sg13cmos5l_decap_8
XFILLER_25_221 VPWR VGND sg13cmos5l_decap_8
XFILLER_27_14 VPWR VGND sg13cmos5l_decap_8
XFILLER_43_35 VPWR VGND sg13cmos5l_decap_8
XFILLER_40_224 VPWR VGND sg13cmos5l_decap_8
XFILLER_4_147 VPWR VGND sg13cmos5l_decap_8
XFILLER_31_235 VPWR VGND sg13cmos5l_decap_8
XFILLER_16_210 VPWR VGND sg13cmos5l_decap_8
XFILLER_16_287 VPWR VGND sg13cmos5l_decap_8
XFILLER_17_91 VPWR VGND sg13cmos5l_decap_8
XFILLER_39_357 VPWR VGND sg13cmos5l_fill_2
XFILLER_22_224 VPWR VGND sg13cmos5l_decap_8
XFILLER_13_49 VPWR VGND sg13cmos5l_decap_8
XFILLER_38_35 VPWR VGND sg13cmos5l_decap_8
XFILLER_13_224 VPWR VGND sg13cmos5l_decap_8
XFILLER_9_217 VPWR VGND sg13cmos5l_decap_8
XFILLER_48_165 VPWR VGND sg13cmos5l_decap_8
XFILLER_0_161 VPWR VGND sg13cmos5l_decap_8
XFILLER_39_154 VPWR VGND sg13cmos5l_decap_8
XFILLER_40_14 VPWR VGND sg13cmos5l_decap_8
XFILLER_10_238 VPWR VGND sg13cmos5l_decap_8
XFILLER_49_56 VPWR VGND sg13cmos5l_decap_8
XFILLER_45_168 VPWR VGND sg13cmos5l_decap_8
XFILLER_33_308 VPWR VGND sg13cmos5l_decap_8
XFILLER_5_231 VPWR VGND sg13cmos5l_decap_8
XFILLER_14_81 VPWR VGND sg13cmos5l_decap_8
XFILLER_46_7 VPWR VGND sg13cmos5l_decap_8
XFILLER_30_91 VPWR VGND sg13cmos5l_decap_8
XFILLER_36_168 VPWR VGND sg13cmos5l_decap_8
XFILLER_24_319 VPWR VGND sg13cmos5l_fill_1
XFILLER_10_28 VPWR VGND sg13cmos5l_decap_8
XFILLER_42_105 VPWR VGND sg13cmos5l_decap_8
XFILLER_35_14 VPWR VGND sg13cmos5l_decap_8
XFILLER_15_308 VPWR VGND sg13cmos5l_decap_8
XFILLER_23_330 VPWR VGND sg13cmos5l_decap_8
XFILLER_27_168 VPWR VGND sg13cmos5l_decap_8
X_070_ _070_/X _052_/A _066_/Y _068_/A VPWR VGND sg13cmos5l_a21o_1
XFILLER_2_256 VPWR VGND sg13cmos5l_decap_8
XFILLER_33_105 VPWR VGND sg13cmos5l_decap_8
XFILLER_18_168 VPWR VGND sg13cmos5l_decap_8
XFILLER_41_182 VPWR VGND sg13cmos5l_decap_8
XFILLER_2_95 VPWR VGND sg13cmos5l_decap_8
XFILLER_24_105 VPWR VGND sg13cmos5l_decap_8
XFILLER_32_182 VPWR VGND sg13cmos5l_decap_8
XFILLER_21_49 VPWR VGND sg13cmos5l_decap_8
XFILLER_46_35 VPWR VGND sg13cmos5l_decap_8
XFILLER_15_105 VPWR VGND sg13cmos5l_decap_8
XFILLER_30_119 VPWR VGND sg13cmos5l_decap_8
XFILLER_7_315 VPWR VGND sg13cmos5l_decap_8
XFILLER_11_322 VPWR VGND sg13cmos5l_decap_8
XFILLER_23_182 VPWR VGND sg13cmos5l_decap_8
X_053_ _053_/Y _074_/Q _057_/A _073_/A VPWR VGND sg13cmos5l_o21ai_1
XFILLER_46_252 VPWR VGND sg13cmos5l_decap_8
XFILLER_14_193 VPWR VGND sg13cmos5l_decap_8
XFILLER_21_119 VPWR VGND sg13cmos5l_decap_8
XFILLER_35_0 VPWR VGND sg13cmos5l_decap_8
XFILLER_37_263 VPWR VGND sg13cmos5l_decap_8
XFILLER_12_119 VPWR VGND sg13cmos5l_decap_8
XFILLER_16_49 VPWR VGND sg13cmos5l_decap_8
XFILLER_20_130 VPWR VGND sg13cmos5l_decap_8
XFILLER_4_329 VPWR VGND sg13cmos5l_decap_8
XFILLER_43_266 VPWR VGND sg13cmos5l_decap_8
XFILLER_28_252 VPWR VGND sg13cmos5l_decap_8
XFILLER_7_112 VPWR VGND sg13cmos5l_decap_8
XFILLER_11_196 VPWR VGND sg13cmos5l_decap_8
XFILLER_22_70 VPWR VGND sg13cmos5l_decap_8
XFILLER_7_189 VPWR VGND sg13cmos5l_decap_8
XFILLER_19_252 VPWR VGND sg13cmos5l_decap_8
XFILLER_43_14 VPWR VGND sg13cmos5l_decap_8
XFILLER_25_200 VPWR VGND sg13cmos5l_decap_8
XFILLER_40_203 VPWR VGND sg13cmos5l_decap_8
XFILLER_25_277 VPWR VGND sg13cmos5l_decap_8
XFILLER_4_126 VPWR VGND sg13cmos5l_decap_8
XFILLER_48_347 VPWR VGND sg13cmos5l_decap_8
XFILLER_0_343 VPWR VGND sg13cmos5l_decap_8
XFILLER_31_214 VPWR VGND sg13cmos5l_decap_8
XFILLER_16_266 VPWR VGND sg13cmos5l_decap_8
XFILLER_17_70 VPWR VGND sg13cmos5l_decap_8
XFILLER_33_91 VPWR VGND sg13cmos5l_decap_8
XFILLER_39_336 VPWR VGND sg13cmos5l_decap_8
XFILLER_30_280 VPWR VGND sg13cmos5l_decap_4
XFILLER_13_28 VPWR VGND sg13cmos5l_decap_8
XFILLER_22_203 VPWR VGND sg13cmos5l_decap_8
XFILLER_38_14 VPWR VGND sg13cmos5l_decap_8
XFILLER_13_203 VPWR VGND sg13cmos5l_decap_8
XFILLER_21_280 VPWR VGND sg13cmos5l_fill_2
XFILLER_0_140 VPWR VGND sg13cmos5l_decap_8
XFILLER_48_144 VPWR VGND sg13cmos5l_decap_8
XFILLER_44_350 VPWR VGND sg13cmos5l_decap_8
XFILLER_36_339 VPWR VGND sg13cmos5l_decap_8
XFILLER_28_91 VPWR VGND sg13cmos5l_decap_8
XFILLER_12_280 VPWR VGND sg13cmos5l_decap_8
XFILLER_8_284 VPWR VGND sg13cmos5l_decap_8
XFILLER_39_133 VPWR VGND sg13cmos5l_decap_8
XFILLER_5_84 VPWR VGND sg13cmos5l_decap_8
XFILLER_24_49 VPWR VGND sg13cmos5l_decap_8
XFILLER_10_217 VPWR VGND sg13cmos5l_decap_8
XFILLER_49_35 VPWR VGND sg13cmos5l_decap_8
XFILLER_6_7 VPWR VGND sg13cmos5l_decap_8
XFILLER_45_147 VPWR VGND sg13cmos5l_decap_8
XFILLER_18_339 VPWR VGND sg13cmos5l_decap_8
XFILLER_41_353 VPWR VGND sg13cmos5l_decap_4
XFILLER_14_60 VPWR VGND sg13cmos5l_decap_8
XFILLER_30_70 VPWR VGND sg13cmos5l_decap_8
XFILLER_5_287 VPWR VGND sg13cmos5l_decap_8
XFILLER_5_210 VPWR VGND sg13cmos5l_decap_8
XFILLER_39_7 VPWR VGND sg13cmos5l_decap_8
XFILLER_36_147 VPWR VGND sg13cmos5l_decap_8
XFILLER_19_49 VPWR VGND sg13cmos5l_decap_8
XFILLER_27_147 VPWR VGND sg13cmos5l_decap_8
XFILLER_23_320 VPWR VGND sg13cmos5l_fill_1
XFILLER_2_235 VPWR VGND sg13cmos5l_decap_8
XFILLER_18_147 VPWR VGND sg13cmos5l_decap_8
XFILLER_41_161 VPWR VGND sg13cmos5l_decap_8
XFILLER_25_81 VPWR VGND sg13cmos5l_decap_8
XFILLER_41_91 VPWR VGND sg13cmos5l_decap_8
XFILLER_37_4 VPWR VGND sg13cmos5l_decap_8
XFILLER_49_294 VPWR VGND sg13cmos5l_decap_8
XFILLER_2_74 VPWR VGND sg13cmos5l_decap_8
XFILLER_32_161 VPWR VGND sg13cmos5l_decap_8
XFILLER_21_28 VPWR VGND sg13cmos5l_decap_8
XFILLER_46_14 VPWR VGND sg13cmos5l_decap_8
XFILLER_11_301 VPWR VGND sg13cmos5l_decap_8
XFILLER_23_161 VPWR VGND sg13cmos5l_decap_8
X_052_ _057_/A _052_/A _066_/A _062_/A _052_/D VPWR VGND sg13cmos5l_nor4_1
XFILLER_46_231 VPWR VGND sg13cmos5l_decap_8
XFILLER_36_91 VPWR VGND sg13cmos5l_decap_8
XFILLER_14_172 VPWR VGND sg13cmos5l_decap_8
Xclkbuf_1_0__f_clk rtl_buf_clk/A clkbuf_0_clk/X VPWR VGND sg13cmos5l_buf_8
XFILLER_28_0 VPWR VGND sg13cmos5l_decap_8
XFILLER_37_242 VPWR VGND sg13cmos5l_decap_8
XFILLER_16_28 VPWR VGND sg13cmos5l_decap_8
XFILLER_32_49 VPWR VGND sg13cmos5l_decap_8
XFILLER_4_308 VPWR VGND sg13cmos5l_decap_8
XFILLER_20_186 VPWR VGND sg13cmos5l_decap_8
XFILLER_28_231 VPWR VGND sg13cmos5l_decap_8
XFILLER_43_245 VPWR VGND sg13cmos5l_decap_8
XFILLER_7_168 VPWR VGND sg13cmos5l_decap_8
XFILLER_11_175 VPWR VGND sg13cmos5l_decap_8
XFILLER_19_231 VPWR VGND sg13cmos5l_decap_8
XFILLER_21_7 VPWR VGND sg13cmos5l_decap_8
XFILLER_34_245 VPWR VGND sg13cmos5l_decap_8
XFILLER_8_95 VPWR VGND sg13cmos5l_decap_8
XFILLER_25_256 VPWR VGND sg13cmos5l_decap_8
XFILLER_27_49 VPWR VGND sg13cmos5l_decap_8
XFILLER_40_259 VPWR VGND sg13cmos5l_decap_8
XFILLER_4_105 VPWR VGND sg13cmos5l_decap_8
XFILLER_0_322 VPWR VGND sg13cmos5l_decap_8
XFILLER_48_326 VPWR VGND sg13cmos5l_decap_8
XFILLER_33_70 VPWR VGND sg13cmos5l_decap_8
XFILLER_16_245 VPWR VGND sg13cmos5l_decap_8
XFILLER_39_315 VPWR VGND sg13cmos5l_decap_8
XFILLER_3_182 VPWR VGND sg13cmos5l_decap_8
XFILLER_22_259 VPWR VGND sg13cmos5l_decap_8
XFILLER_1_119 VPWR VGND sg13cmos5l_decap_8
XFILLER_45_329 VPWR VGND sg13cmos5l_decap_8
XFILLER_13_259 VPWR VGND sg13cmos5l_decap_8
XFILLER_48_123 VPWR VGND sg13cmos5l_decap_8
XFILLER_0_196 VPWR VGND sg13cmos5l_decap_8
XFILLER_36_318 VPWR VGND sg13cmos5l_decap_8
XFILLER_28_70 VPWR VGND sg13cmos5l_decap_8
XFILLER_44_91 VPWR VGND sg13cmos5l_decap_8
XFILLER_8_263 VPWR VGND sg13cmos5l_decap_8
XFILLER_5_63 VPWR VGND sg13cmos5l_decap_8
XFILLER_39_189 VPWR VGND sg13cmos5l_decap_8
XFILLER_39_112 VPWR VGND sg13cmos5l_decap_8
XFILLER_10_0 VPWR VGND sg13cmos5l_decap_8
XFILLER_24_28 VPWR VGND sg13cmos5l_decap_8
XFILLER_40_49 VPWR VGND sg13cmos5l_decap_8
XFILLER_49_14 VPWR VGND sg13cmos5l_decap_8
XFILLER_45_126 VPWR VGND sg13cmos5l_decap_8
XFILLER_41_332 VPWR VGND sg13cmos5l_decap_8
XFILLER_5_266 VPWR VGND sg13cmos5l_decap_8
XFILLER_39_91 VPWR VGND sg13cmos5l_decap_8
XFILLER_36_126 VPWR VGND sg13cmos5l_decap_8
XFILLER_32_343 VPWR VGND sg13cmos5l_decap_8
XFILLER_19_28 VPWR VGND sg13cmos5l_decap_8
XFILLER_35_49 VPWR VGND sg13cmos5l_decap_8
XFILLER_27_126 VPWR VGND sg13cmos5l_decap_8
XFILLER_2_214 VPWR VGND sg13cmos5l_decap_8
XFILLER_41_140 VPWR VGND sg13cmos5l_decap_8
XFILLER_14_354 VPWR VGND sg13cmos5l_decap_4
XFILLER_18_126 VPWR VGND sg13cmos5l_decap_8
XFILLER_25_60 VPWR VGND sg13cmos5l_decap_8
XFILLER_41_70 VPWR VGND sg13cmos5l_decap_8
XFILLER_49_273 VPWR VGND sg13cmos5l_decap_8
XFILLER_2_53 VPWR VGND sg13cmos5l_decap_8
XFILLER_1_280 VPWR VGND sg13cmos5l_decap_8
XFILLER_32_140 VPWR VGND sg13cmos5l_decap_8
XFILLER_23_140 VPWR VGND sg13cmos5l_decap_8
XFILLER_11_357 VPWR VGND sg13cmos5l_fill_2
X_051_ _052_/D _076_/Q _075_/Q VPWR VGND sg13cmos5l_nand2_1
XFILLER_11_84 VPWR VGND sg13cmos5l_decap_8
XFILLER_46_210 VPWR VGND sg13cmos5l_decap_8
XFILLER_46_287 VPWR VGND sg13cmos5l_decap_8
XFILLER_36_70 VPWR VGND sg13cmos5l_decap_8
XFILLER_14_151 VPWR VGND sg13cmos5l_decap_8
XFILLER_6_350 VPWR VGND sg13cmos5l_decap_8
XFILLER_37_298 VPWR VGND sg13cmos5l_decap_8
XFILLER_37_221 VPWR VGND sg13cmos5l_decap_8
XFILLER_32_28 VPWR VGND sg13cmos5l_decap_8
XFILLER_20_165 VPWR VGND sg13cmos5l_decap_8
XFILLER_28_210 VPWR VGND sg13cmos5l_decap_8
XFILLER_43_224 VPWR VGND sg13cmos5l_decap_8
XFILLER_28_287 VPWR VGND sg13cmos5l_decap_8
XFILLER_7_147 VPWR VGND sg13cmos5l_decap_8
XFILLER_11_154 VPWR VGND sg13cmos5l_decap_8
XFILLER_47_91 VPWR VGND sg13cmos5l_decap_8
XFILLER_34_224 VPWR VGND sg13cmos5l_decap_8
XFILLER_19_210 VPWR VGND sg13cmos5l_decap_8
XFILLER_8_74 VPWR VGND sg13cmos5l_decap_8
XFILLER_40_0 VPWR VGND sg13cmos5l_decap_8
XFILLER_27_28 VPWR VGND sg13cmos5l_decap_8
XFILLER_43_49 VPWR VGND sg13cmos5l_decap_8
XFILLER_40_238 VPWR VGND sg13cmos5l_decap_8
XFILLER_25_235 VPWR VGND sg13cmos5l_decap_8
XFILLER_48_305 VPWR VGND sg13cmos5l_decap_8
XFILLER_0_301 VPWR VGND sg13cmos5l_decap_8
XFILLER_16_224 VPWR VGND sg13cmos5l_decap_8
XFILLER_31_249 VPWR VGND sg13cmos5l_decap_8
XFILLER_24_290 VPWR VGND sg13cmos5l_fill_2
XFILLER_3_161 VPWR VGND sg13cmos5l_decap_8
XFILLER_22_238 VPWR VGND sg13cmos5l_decap_8
XFILLER_45_308 VPWR VGND sg13cmos5l_decap_8
XFILLER_38_49 VPWR VGND sg13cmos5l_decap_8
XFILLER_13_238 VPWR VGND sg13cmos5l_decap_8
XFILLER_21_260 VPWR VGND sg13cmos5l_fill_1
XFILLER_48_102 VPWR VGND sg13cmos5l_decap_8
XFILLER_0_175 VPWR VGND sg13cmos5l_decap_8
XFILLER_48_179 VPWR VGND sg13cmos5l_decap_8
XFILLER_44_70 VPWR VGND sg13cmos5l_decap_8
XFILLER_8_242 VPWR VGND sg13cmos5l_decap_8
XFILLER_5_42 VPWR VGND sg13cmos5l_decap_8
XFILLER_39_168 VPWR VGND sg13cmos5l_decap_8
XFILLER_35_352 VPWR VGND sg13cmos5l_fill_2
XFILLER_40_28 VPWR VGND sg13cmos5l_decap_8
XFILLER_45_105 VPWR VGND sg13cmos5l_decap_8
XFILLER_41_311 VPWR VGND sg13cmos5l_decap_8
XFILLER_14_95 VPWR VGND sg13cmos5l_decap_8
XFILLER_5_245 VPWR VGND sg13cmos5l_decap_8
XFILLER_39_70 VPWR VGND sg13cmos5l_decap_8
XFILLER_36_105 VPWR VGND sg13cmos5l_decap_8
XFILLER_44_182 VPWR VGND sg13cmos5l_decap_8
XFILLER_32_322 VPWR VGND sg13cmos5l_decap_8
XFILLER_17_341 VPWR VGND sg13cmos5l_fill_1
XFILLER_42_119 VPWR VGND sg13cmos5l_decap_8
XFILLER_35_182 VPWR VGND sg13cmos5l_decap_8
XFILLER_35_28 VPWR VGND sg13cmos5l_decap_8
XFILLER_27_105 VPWR VGND sg13cmos5l_decap_8
XFILLER_23_355 VPWR VGND sg13cmos5l_decap_4
XFILLER_18_105 VPWR VGND sg13cmos5l_decap_8
XFILLER_33_119 VPWR VGND sg13cmos5l_decap_8
XFILLER_14_333 VPWR VGND sg13cmos5l_decap_8
XFILLER_26_182 VPWR VGND sg13cmos5l_decap_8
XFILLER_41_196 VPWR VGND sg13cmos5l_decap_8
XFILLER_44_7 VPWR VGND sg13cmos5l_decap_8
XFILLER_2_32 VPWR VGND sg13cmos5l_decap_8
XFILLER_49_252 VPWR VGND sg13cmos5l_decap_8
XFILLER_17_182 VPWR VGND sg13cmos5l_decap_8
XFILLER_24_119 VPWR VGND sg13cmos5l_decap_8
XFILLER_32_196 VPWR VGND sg13cmos5l_decap_8
XFILLER_46_49 VPWR VGND sg13cmos5l_decap_8
XFILLER_15_119 VPWR VGND sg13cmos5l_decap_8
XFILLER_7_329 VPWR VGND sg13cmos5l_decap_8
XFILLER_11_336 VPWR VGND sg13cmos5l_decap_8
X_050_ _050_/Y _074_/Q _075_/Q VPWR VGND sg13cmos5l_nor2_1
XFILLER_23_196 VPWR VGND sg13cmos5l_decap_8
XFILLER_11_63 VPWR VGND sg13cmos5l_decap_8
XFILLER_46_266 VPWR VGND sg13cmos5l_decap_8
XFILLER_14_130 VPWR VGND sg13cmos5l_decap_8
XFILLER_37_200 VPWR VGND sg13cmos5l_decap_8
XFILLER_37_277 VPWR VGND sg13cmos5l_fill_1
XFILLER_20_144 VPWR VGND sg13cmos5l_decap_8
XFILLER_43_203 VPWR VGND sg13cmos5l_decap_8
XFILLER_28_266 VPWR VGND sg13cmos5l_decap_8
XFILLER_11_133 VPWR VGND sg13cmos5l_decap_8
X_087__21 _087__21/L_HI VPWR VGND sg13cmos5l_tiehi
XFILLER_3_354 VPWR VGND sg13cmos5l_fill_1
XFILLER_3_343 VPWR VGND sg13cmos5l_decap_8
XFILLER_7_126 VPWR VGND sg13cmos5l_decap_8
XFILLER_22_84 VPWR VGND sg13cmos5l_decap_8
XFILLER_0_0 VPWR VGND sg13cmos5l_decap_8
XFILLER_47_70 VPWR VGND sg13cmos5l_decap_8
XFILLER_34_203 VPWR VGND sg13cmos5l_decap_8
XFILLER_19_266 VPWR VGND sg13cmos5l_decap_4
XFILLER_8_53 VPWR VGND sg13cmos5l_decap_8
XFILLER_33_0 VPWR VGND sg13cmos5l_decap_8
XFILLER_25_214 VPWR VGND sg13cmos5l_decap_8
XFILLER_43_28 VPWR VGND sg13cmos5l_decap_8
XFILLER_40_217 VPWR VGND sg13cmos5l_decap_8
XFILLER_0_357 VPWR VGND sg13cmos5l_fill_2
XFILLER_16_203 VPWR VGND sg13cmos5l_decap_8
XFILLER_17_84 VPWR VGND sg13cmos5l_decap_8
XFILLER_31_228 VPWR VGND sg13cmos5l_decap_8
XFILLER_3_140 VPWR VGND sg13cmos5l_decap_8
XFILLER_47_350 VPWR VGND sg13cmos5l_decap_8
XFILLER_15_280 VPWR VGND sg13cmos5l_decap_8
XFILLER_22_217 VPWR VGND sg13cmos5l_decap_8
XFILLER_38_28 VPWR VGND sg13cmos5l_decap_8
X_081__27 _081__27/L_HI VPWR VGND sg13cmos5l_tiehi
XFILLER_38_350 VPWR VGND sg13cmos5l_decap_8
XFILLER_13_217 VPWR VGND sg13cmos5l_decap_8
XFILLER_48_158 VPWR VGND sg13cmos5l_decap_8
XFILLER_0_154 VPWR VGND sg13cmos5l_decap_8
XFILLER_5_21 VPWR VGND sg13cmos5l_decap_8
XFILLER_8_221 VPWR VGND sg13cmos5l_decap_8
XFILLER_8_298 VPWR VGND sg13cmos5l_decap_8
XFILLER_12_294 VPWR VGND sg13cmos5l_decap_8
XFILLER_5_98 VPWR VGND sg13cmos5l_decap_8
XFILLER_39_147 VPWR VGND sg13cmos5l_decap_8
XFILLER_35_331 VPWR VGND sg13cmos5l_decap_8
XFILLER_49_49 VPWR VGND sg13cmos5l_decap_8
XFILLER_41_301 VPWR VGND sg13cmos5l_fill_1
XFILLER_26_353 VPWR VGND sg13cmos5l_decap_4
XFILLER_5_224 VPWR VGND sg13cmos5l_decap_8
XFILLER_14_74 VPWR VGND sg13cmos5l_decap_8
XFILLER_30_84 VPWR VGND sg13cmos5l_decap_8
XFILLER_44_161 VPWR VGND sg13cmos5l_decap_8
XFILLER_32_301 VPWR VGND sg13cmos5l_decap_8
XFILLER_35_161 VPWR VGND sg13cmos5l_decap_8
XFILLER_4_7 VPWR VGND sg13cmos5l_decap_8
XFILLER_2_249 VPWR VGND sg13cmos5l_decap_8
XFILLER_41_175 VPWR VGND sg13cmos5l_decap_8
XFILLER_14_312 VPWR VGND sg13cmos5l_decap_8
XFILLER_25_95 VPWR VGND sg13cmos5l_decap_8
XFILLER_26_161 VPWR VGND sg13cmos5l_decap_8
XFILLER_49_231 VPWR VGND sg13cmos5l_decap_8
XFILLER_2_11 VPWR VGND sg13cmos5l_decap_8
XFILLER_2_88 VPWR VGND sg13cmos5l_decap_8
XFILLER_17_161 VPWR VGND sg13cmos5l_decap_8
XFILLER_32_175 VPWR VGND sg13cmos5l_decap_8
XFILLER_46_28 VPWR VGND sg13cmos5l_decap_8
XFILLER_11_315 VPWR VGND sg13cmos5l_decap_8
XFILLER_23_175 VPWR VGND sg13cmos5l_decap_8
XFILLER_7_308 VPWR VGND sg13cmos5l_decap_8
XFILLER_11_42 VPWR VGND sg13cmos5l_decap_8
XFILLER_2_4 VPWR VGND sg13cmos5l_decap_8
XFILLER_46_245 VPWR VGND sg13cmos5l_decap_8
XFILLER_14_186 VPWR VGND sg13cmos5l_decap_8
XFILLER_37_256 VPWR VGND sg13cmos5l_decap_8
XFILLER_20_123 VPWR VGND sg13cmos5l_decap_8
XFILLER_43_259 VPWR VGND sg13cmos5l_decap_8
XFILLER_28_245 VPWR VGND sg13cmos5l_decap_8
XFILLER_7_105 VPWR VGND sg13cmos5l_decap_8
XFILLER_11_112 VPWR VGND sg13cmos5l_decap_8
XFILLER_11_189 VPWR VGND sg13cmos5l_decap_8
XFILLER_3_322 VPWR VGND sg13cmos5l_decap_8
XFILLER_22_63 VPWR VGND sg13cmos5l_decap_8
XFILLER_19_245 VPWR VGND sg13cmos5l_decap_8
XFILLER_42_270 VPWR VGND sg13cmos5l_fill_1
XFILLER_8_32 VPWR VGND sg13cmos5l_decap_8
XFILLER_6_182 VPWR VGND sg13cmos5l_decap_8
XFILLER_26_0 VPWR VGND sg13cmos5l_decap_8
XFILLER_4_119 VPWR VGND sg13cmos5l_decap_8
XFILLER_0_336 VPWR VGND sg13cmos5l_decap_8
XFILLER_31_207 VPWR VGND sg13cmos5l_decap_8
XFILLER_16_259 VPWR VGND sg13cmos5l_decap_8
XFILLER_17_63 VPWR VGND sg13cmos5l_decap_8
XFILLER_33_84 VPWR VGND sg13cmos5l_decap_8
XFILLER_3_196 VPWR VGND sg13cmos5l_decap_8
XFILLER_39_329 VPWR VGND sg13cmos5l_decap_8
XFILLER_30_273 VPWR VGND sg13cmos5l_decap_8
XFILLER_30_284 VPWR VGND sg13cmos5l_fill_1
XFILLER_0_133 VPWR VGND sg13cmos5l_decap_8
XFILLER_48_137 VPWR VGND sg13cmos5l_decap_8
XFILLER_29_340 VPWR VGND sg13cmos5l_decap_8
XFILLER_28_84 VPWR VGND sg13cmos5l_decap_8
XFILLER_44_343 VPWR VGND sg13cmos5l_decap_8
XFILLER_8_200 VPWR VGND sg13cmos5l_decap_8
XFILLER_8_277 VPWR VGND sg13cmos5l_decap_8
XFILLER_12_273 VPWR VGND sg13cmos5l_decap_8
XFILLER_39_126 VPWR VGND sg13cmos5l_decap_8
XFILLER_5_77 VPWR VGND sg13cmos5l_decap_8
XFILLER_35_354 VPWR VGND sg13cmos5l_fill_1
XFILLER_35_310 VPWR VGND sg13cmos5l_decap_8
XFILLER_49_28 VPWR VGND sg13cmos5l_decap_8
XFILLER_41_357 VPWR VGND sg13cmos5l_fill_2
XFILLER_41_346 VPWR VGND sg13cmos5l_decap_8
XFILLER_14_53 VPWR VGND sg13cmos5l_decap_8
XFILLER_26_332 VPWR VGND sg13cmos5l_decap_8
XFILLER_30_63 VPWR VGND sg13cmos5l_decap_8
XFILLER_5_203 VPWR VGND sg13cmos5l_decap_8
XFILLER_44_140 VPWR VGND sg13cmos5l_decap_8
XFILLER_32_357 VPWR VGND sg13cmos5l_fill_2
XFILLER_4_280 VPWR VGND sg13cmos5l_decap_8
XFILLER_35_140 VPWR VGND sg13cmos5l_decap_8
Xclkbuf_0_clk_regs clkbuf_0_clk_regs/X clkbuf_regs_0_clk/X VPWR VGND sg13cmos5l_buf_8
XFILLER_2_228 VPWR VGND sg13cmos5l_decap_8
XFILLER_26_140 VPWR VGND sg13cmos5l_decap_8
XFILLER_41_154 VPWR VGND sg13cmos5l_decap_8
XFILLER_25_74 VPWR VGND sg13cmos5l_decap_8
XFILLER_41_84 VPWR VGND sg13cmos5l_decap_8
XFILLER_49_287 VPWR VGND sg13cmos5l_decap_8
XFILLER_49_210 VPWR VGND sg13cmos5l_decap_8
XFILLER_2_67 VPWR VGND sg13cmos5l_decap_8
XFILLER_1_294 VPWR VGND sg13cmos5l_decap_8
XFILLER_32_154 VPWR VGND sg13cmos5l_decap_8
XFILLER_17_140 VPWR VGND sg13cmos5l_decap_8
XFILLER_9_350 VPWR VGND sg13cmos5l_decap_4
XFILLER_23_154 VPWR VGND sg13cmos5l_decap_8
XFILLER_11_21 VPWR VGND sg13cmos5l_decap_8
XFILLER_11_98 VPWR VGND sg13cmos5l_decap_8
XFILLER_46_224 VPWR VGND sg13cmos5l_decap_8
XFILLER_36_84 VPWR VGND sg13cmos5l_decap_8
XFILLER_14_165 VPWR VGND sg13cmos5l_decap_8
XFILLER_37_235 VPWR VGND sg13cmos5l_decap_8
XFILLER_20_102 VPWR VGND sg13cmos5l_decap_8
XFILLER_20_179 VPWR VGND sg13cmos5l_decap_8
XFILLER_43_238 VPWR VGND sg13cmos5l_decap_8
XFILLER_36_290 VPWR VGND sg13cmos5l_decap_8
XFILLER_28_224 VPWR VGND sg13cmos5l_decap_8
XFILLER_11_168 VPWR VGND sg13cmos5l_decap_8
XFILLER_22_42 VPWR VGND sg13cmos5l_decap_8
XFILLER_3_301 VPWR VGND sg13cmos5l_decap_8
XFILLER_19_224 VPWR VGND sg13cmos5l_decap_8
XFILLER_42_282 VPWR VGND sg13cmos5l_decap_8
XFILLER_34_238 VPWR VGND sg13cmos5l_decap_8
XFILLER_8_11 VPWR VGND sg13cmos5l_decap_8
XFILLER_6_161 VPWR VGND sg13cmos5l_decap_8
XFILLER_8_88 VPWR VGND sg13cmos5l_decap_8
XFILLER_19_0 VPWR VGND sg13cmos5l_decap_8
XFILLER_25_249 VPWR VGND sg13cmos5l_decap_8
XFILLER_0_315 VPWR VGND sg13cmos5l_decap_8
XFILLER_48_319 VPWR VGND sg13cmos5l_decap_8
XFILLER_16_238 VPWR VGND sg13cmos5l_decap_8
XFILLER_17_42 VPWR VGND sg13cmos5l_decap_8
XFILLER_33_63 VPWR VGND sg13cmos5l_decap_8
XFILLER_39_308 VPWR VGND sg13cmos5l_decap_8
XFILLER_3_175 VPWR VGND sg13cmos5l_decap_8
XFILLER_12_7 VPWR VGND sg13cmos5l_decap_8
XFILLER_30_252 VPWR VGND sg13cmos5l_decap_8
XFILLER_48_116 VPWR VGND sg13cmos5l_decap_8
XFILLER_0_112 VPWR VGND sg13cmos5l_decap_8
XFILLER_44_322 VPWR VGND sg13cmos5l_decap_8
XFILLER_0_189 VPWR VGND sg13cmos5l_decap_8
XFILLER_28_63 VPWR VGND sg13cmos5l_decap_8
XFILLER_44_84 VPWR VGND sg13cmos5l_decap_8
XFILLER_12_252 VPWR VGND sg13cmos5l_decap_8
XFILLER_5_56 VPWR VGND sg13cmos5l_decap_8
XFILLER_8_256 VPWR VGND sg13cmos5l_decap_8
XFILLER_39_105 VPWR VGND sg13cmos5l_decap_8
XFILLER_47_182 VPWR VGND sg13cmos5l_decap_8
XFILLER_45_119 VPWR VGND sg13cmos5l_decap_8
XFILLER_38_182 VPWR VGND sg13cmos5l_decap_8
XFILLER_41_325 VPWR VGND sg13cmos5l_decap_8
XFILLER_14_32 VPWR VGND sg13cmos5l_decap_8
XFILLER_30_42 VPWR VGND sg13cmos5l_decap_8
XFILLER_5_259 VPWR VGND sg13cmos5l_decap_8
XFILLER_39_84 VPWR VGND sg13cmos5l_decap_8
XFILLER_44_196 VPWR VGND sg13cmos5l_decap_8
XFILLER_36_119 VPWR VGND sg13cmos5l_decap_8
XFILLER_32_336 VPWR VGND sg13cmos5l_decap_8
XFILLER_29_182 VPWR VGND sg13cmos5l_decap_8
XFILLER_27_119 VPWR VGND sg13cmos5l_decap_8
XFILLER_35_196 VPWR VGND sg13cmos5l_decap_8
XFILLER_2_207 VPWR VGND sg13cmos5l_decap_8
XFILLER_14_347 VPWR VGND sg13cmos5l_decap_8
XFILLER_18_119 VPWR VGND sg13cmos5l_decap_8
XFILLER_25_53 VPWR VGND sg13cmos5l_decap_8
XFILLER_26_196 VPWR VGND sg13cmos5l_decap_8
XFILLER_41_133 VPWR VGND sg13cmos5l_decap_8
XFILLER_41_63 VPWR VGND sg13cmos5l_decap_8
XFILLER_14_358 VPWR VGND sg13cmos5l_fill_1
XFILLER_49_266 VPWR VGND sg13cmos5l_decap_8
XFILLER_2_46 VPWR VGND sg13cmos5l_decap_8
XFILLER_1_273 VPWR VGND sg13cmos5l_decap_8
XFILLER_32_133 VPWR VGND sg13cmos5l_decap_8
XFILLER_17_196 VPWR VGND sg13cmos5l_decap_8
XFILLER_20_339 VPWR VGND sg13cmos5l_fill_2
XFILLER_49_0 VPWR VGND sg13cmos5l_decap_8
XFILLER_23_133 VPWR VGND sg13cmos5l_decap_8
XFILLER_11_77 VPWR VGND sg13cmos5l_decap_8
XFILLER_46_203 VPWR VGND sg13cmos5l_decap_8
XFILLER_36_63 VPWR VGND sg13cmos5l_decap_8
XFILLER_14_144 VPWR VGND sg13cmos5l_decap_8
XFILLER_6_343 VPWR VGND sg13cmos5l_decap_8
XFILLER_10_350 VPWR VGND sg13cmos5l_decap_8
XFILLER_42_7 VPWR VGND sg13cmos5l_decap_8
XFILLER_45_280 VPWR VGND sg13cmos5l_decap_8
XFILLER_37_214 VPWR VGND sg13cmos5l_decap_8
XFILLER_20_158 VPWR VGND sg13cmos5l_decap_8
XFILLER_28_203 VPWR VGND sg13cmos5l_decap_8
XFILLER_43_217 VPWR VGND sg13cmos5l_decap_8
XFILLER_11_147 VPWR VGND sg13cmos5l_decap_8
XFILLER_22_21 VPWR VGND sg13cmos5l_decap_8
XFILLER_22_98 VPWR VGND sg13cmos5l_decap_8
XFILLER_47_84 VPWR VGND sg13cmos5l_decap_8
XFILLER_34_217 VPWR VGND sg13cmos5l_decap_8
XFILLER_19_203 VPWR VGND sg13cmos5l_decap_8
XFILLER_27_280 VPWR VGND sg13cmos5l_decap_8
XFILLER_8_67 VPWR VGND sg13cmos5l_decap_8
XFILLER_6_140 VPWR VGND sg13cmos5l_decap_8
X_078__24 _078__24/L_HI VPWR VGND sg13cmos5l_tiehi
XFILLER_18_280 VPWR VGND sg13cmos5l_decap_8
XFILLER_25_228 VPWR VGND sg13cmos5l_decap_8
XFILLER_16_217 VPWR VGND sg13cmos5l_decap_8
XFILLER_17_21 VPWR VGND sg13cmos5l_decap_8
XFILLER_33_42 VPWR VGND sg13cmos5l_decap_8
XFILLER_17_98 VPWR VGND sg13cmos5l_decap_8
XFILLER_3_154 VPWR VGND sg13cmos5l_decap_8
XFILLER_30_231 VPWR VGND sg13cmos5l_decap_8
XFILLER_15_294 VPWR VGND sg13cmos5l_decap_8
XFILLER_21_231 VPWR VGND sg13cmos5l_decap_8
XFILLER_21_253 VPWR VGND sg13cmos5l_decap_8
XFILLER_0_168 VPWR VGND sg13cmos5l_decap_8
XFILLER_44_301 VPWR VGND sg13cmos5l_decap_8
XFILLER_28_42 VPWR VGND sg13cmos5l_decap_8
XFILLER_44_63 VPWR VGND sg13cmos5l_decap_8
XFILLER_8_235 VPWR VGND sg13cmos5l_decap_8
XFILLER_12_231 VPWR VGND sg13cmos5l_decap_8
XFILLER_5_35 VPWR VGND sg13cmos5l_decap_8
XFILLER_47_161 VPWR VGND sg13cmos5l_decap_8
XFILLER_35_345 VPWR VGND sg13cmos5l_decap_8
XFILLER_38_161 VPWR VGND sg13cmos5l_decap_8
XFILLER_26_301 VPWR VGND sg13cmos5l_decap_4
XFILLER_14_11 VPWR VGND sg13cmos5l_decap_8
XFILLER_14_88 VPWR VGND sg13cmos5l_decap_8
XFILLER_30_98 VPWR VGND sg13cmos5l_decap_8
XFILLER_30_21 VPWR VGND sg13cmos5l_decap_8
XFILLER_5_238 VPWR VGND sg13cmos5l_decap_8
XFILLER_39_63 VPWR VGND sg13cmos5l_decap_8
XFILLER_29_161 VPWR VGND sg13cmos5l_decap_8
XFILLER_44_175 VPWR VGND sg13cmos5l_decap_8
XFILLER_32_315 VPWR VGND sg13cmos5l_decap_8
XFILLER_17_334 VPWR VGND sg13cmos5l_decap_8
XFILLER_35_175 VPWR VGND sg13cmos5l_decap_8
XFILLER_23_337 VPWR VGND sg13cmos5l_decap_4
XFILLER_41_112 VPWR VGND sg13cmos5l_decap_8
XFILLER_14_326 VPWR VGND sg13cmos5l_decap_8
XFILLER_25_32 VPWR VGND sg13cmos5l_decap_8
XFILLER_26_175 VPWR VGND sg13cmos5l_decap_8
XFILLER_41_189 VPWR VGND sg13cmos5l_decap_8
XFILLER_41_42 VPWR VGND sg13cmos5l_decap_8
XFILLER_2_25 VPWR VGND sg13cmos5l_decap_8
XFILLER_1_252 VPWR VGND sg13cmos5l_decap_8
XFILLER_9_0 VPWR VGND sg13cmos5l_decap_8
XFILLER_49_245 VPWR VGND sg13cmos5l_decap_8
XFILLER_32_189 VPWR VGND sg13cmos5l_decap_8
XFILLER_32_112 VPWR VGND sg13cmos5l_decap_8
XFILLER_17_175 VPWR VGND sg13cmos5l_decap_8
XFILLER_23_112 VPWR VGND sg13cmos5l_decap_8
XFILLER_11_329 VPWR VGND sg13cmos5l_decap_8
XFILLER_23_189 VPWR VGND sg13cmos5l_decap_8
XFILLER_11_56 VPWR VGND sg13cmos5l_decap_8
XFILLER_46_259 VPWR VGND sg13cmos5l_decap_8
XFILLER_36_42 VPWR VGND sg13cmos5l_decap_8
XFILLER_14_123 VPWR VGND sg13cmos5l_decap_8
XFILLER_6_322 VPWR VGND sg13cmos5l_decap_8
XFILLER_35_7 VPWR VGND sg13cmos5l_decap_8
XFILLER_9_182 VPWR VGND sg13cmos5l_decap_8
XFILLER_20_137 VPWR VGND sg13cmos5l_decap_8
XFILLER_28_259 VPWR VGND sg13cmos5l_decap_8
XFILLER_11_126 VPWR VGND sg13cmos5l_decap_8
XFILLER_7_119 VPWR VGND sg13cmos5l_decap_8
XFILLER_3_336 VPWR VGND sg13cmos5l_decap_8
XFILLER_22_77 VPWR VGND sg13cmos5l_decap_8
XFILLER_47_63 VPWR VGND sg13cmos5l_decap_8
XFILLER_19_259 VPWR VGND sg13cmos5l_decap_8
XFILLER_8_46 VPWR VGND sg13cmos5l_decap_8
XFILLER_6_196 VPWR VGND sg13cmos5l_decap_8
X_089_ _089_/Q _089_/CLK _089_/D _089__16/L_HI VPWR VGND sg13cmos5l_dfrbpq_1
XFILLER_33_273 VPWR VGND sg13cmos5l_fill_1
XFILLER_25_207 VPWR VGND sg13cmos5l_decap_8
XFILLER_17_77 VPWR VGND sg13cmos5l_decap_8
XFILLER_33_98 VPWR VGND sg13cmos5l_decap_8
XFILLER_33_21 VPWR VGND sg13cmos5l_decap_8
XFILLER_24_273 VPWR VGND sg13cmos5l_decap_8
XFILLER_24_284 VPWR VGND sg13cmos5l_fill_1
XFILLER_3_133 VPWR VGND sg13cmos5l_decap_8
XFILLER_47_343 VPWR VGND sg13cmos5l_decap_8
XFILLER_30_210 VPWR VGND sg13cmos5l_decap_8
XFILLER_15_273 VPWR VGND sg13cmos5l_decap_8
XFILLER_30_298 VPWR VGND sg13cmos5l_decap_4
XFILLER_24_0 VPWR VGND sg13cmos5l_decap_8
XFILLER_38_343 VPWR VGND sg13cmos5l_decap_8
XFILLER_0_91 VPWR VGND sg13cmos5l_decap_8
XFILLER_21_210 VPWR VGND sg13cmos5l_decap_8
XFILLER_29_354 VPWR VGND sg13cmos5l_fill_1
XFILLER_0_147 VPWR VGND sg13cmos5l_decap_8
XFILLER_28_21 VPWR VGND sg13cmos5l_decap_8
XFILLER_44_357 VPWR VGND sg13cmos5l_fill_2
XFILLER_44_42 VPWR VGND sg13cmos5l_decap_8
XFILLER_12_210 VPWR VGND sg13cmos5l_decap_8
XFILLER_28_98 VPWR VGND sg13cmos5l_decap_8
XFILLER_8_214 VPWR VGND sg13cmos5l_decap_8
XFILLER_12_287 VPWR VGND sg13cmos5l_decap_8
XFILLER_5_14 VPWR VGND sg13cmos5l_decap_8
XFILLER_47_140 VPWR VGND sg13cmos5l_decap_8
XFILLER_35_324 VPWR VGND sg13cmos5l_decap_8
XFILLER_7_280 VPWR VGND sg13cmos5l_decap_8
XFILLER_38_140 VPWR VGND sg13cmos5l_decap_8
XFILLER_26_346 VPWR VGND sg13cmos5l_decap_8
XFILLER_26_357 VPWR VGND sg13cmos5l_fill_2
XFILLER_5_217 VPWR VGND sg13cmos5l_decap_8
XFILLER_14_67 VPWR VGND sg13cmos5l_decap_8
XFILLER_39_42 VPWR VGND sg13cmos5l_decap_8
XFILLER_30_77 VPWR VGND sg13cmos5l_decap_8
XFILLER_29_140 VPWR VGND sg13cmos5l_decap_8
XFILLER_44_154 VPWR VGND sg13cmos5l_decap_8
XFILLER_4_294 VPWR VGND sg13cmos5l_decap_8
XFILLER_35_154 VPWR VGND sg13cmos5l_decap_8
XFILLER_41_168 VPWR VGND sg13cmos5l_decap_8
XFILLER_14_305 VPWR VGND sg13cmos5l_decap_8
XFILLER_25_11 VPWR VGND sg13cmos5l_decap_8
XFILLER_25_88 VPWR VGND sg13cmos5l_decap_8
XFILLER_26_154 VPWR VGND sg13cmos5l_decap_8
XFILLER_41_98 VPWR VGND sg13cmos5l_decap_8
XFILLER_41_21 VPWR VGND sg13cmos5l_decap_8
XFILLER_49_224 VPWR VGND sg13cmos5l_decap_8
XFILLER_1_231 VPWR VGND sg13cmos5l_decap_8
XFILLER_17_154 VPWR VGND sg13cmos5l_decap_8
XFILLER_32_168 VPWR VGND sg13cmos5l_decap_8
XFILLER_11_308 VPWR VGND sg13cmos5l_decap_8
XFILLER_23_168 VPWR VGND sg13cmos5l_decap_8
XFILLER_11_35 VPWR VGND sg13cmos5l_decap_8
XFILLER_46_238 VPWR VGND sg13cmos5l_decap_8
XFILLER_36_21 VPWR VGND sg13cmos5l_decap_8
XFILLER_14_102 VPWR VGND sg13cmos5l_decap_8
XFILLER_36_98 VPWR VGND sg13cmos5l_decap_8
XFILLER_6_301 VPWR VGND sg13cmos5l_decap_8
XFILLER_14_179 VPWR VGND sg13cmos5l_decap_8
XFILLER_28_7 VPWR VGND sg13cmos5l_decap_8
XFILLER_37_249 VPWR VGND sg13cmos5l_decap_8
XFILLER_9_161 VPWR VGND sg13cmos5l_decap_8
XFILLER_20_116 VPWR VGND sg13cmos5l_decap_8
XFILLER_3_91 VPWR VGND sg13cmos5l_decap_8
XFILLER_28_238 VPWR VGND sg13cmos5l_decap_8
XFILLER_11_105 VPWR VGND sg13cmos5l_decap_8
XFILLER_3_315 VPWR VGND sg13cmos5l_decap_8
XFILLER_22_56 VPWR VGND sg13cmos5l_decap_8
XFILLER_47_42 VPWR VGND sg13cmos5l_decap_8
XFILLER_19_238 VPWR VGND sg13cmos5l_decap_8
XFILLER_42_252 VPWR VGND sg13cmos5l_decap_8
XFILLER_42_296 VPWR VGND sg13cmos5l_decap_8
XFILLER_8_25 VPWR VGND sg13cmos5l_decap_8
XFILLER_10_182 VPWR VGND sg13cmos5l_decap_8
XFILLER_6_175 VPWR VGND sg13cmos5l_decap_8
X_088_ _088_/Q _089_/CLK _088_/D _088__30/L_HI VPWR VGND sg13cmos5l_dfrbpq_1
XFILLER_33_252 VPWR VGND sg13cmos5l_decap_8
X_084__18 _084__18/L_HI VPWR VGND sg13cmos5l_tiehi
XFILLER_0_329 VPWR VGND sg13cmos5l_decap_8
XFILLER_17_56 VPWR VGND sg13cmos5l_decap_8
XFILLER_24_252 VPWR VGND sg13cmos5l_decap_8
XFILLER_33_77 VPWR VGND sg13cmos5l_decap_8
XFILLER_3_189 VPWR VGND sg13cmos5l_decap_8
XFILLER_3_112 VPWR VGND sg13cmos5l_decap_8
X_075__29 _075__29/L_HI VPWR VGND sg13cmos5l_tiehi
XFILLER_47_322 VPWR VGND sg13cmos5l_decap_8
XFILLER_15_252 VPWR VGND sg13cmos5l_decap_8
XFILLER_30_266 VPWR VGND sg13cmos5l_decap_8
XFILLER_38_322 VPWR VGND sg13cmos5l_decap_8
XFILLER_0_70 VPWR VGND sg13cmos5l_decap_8
XFILLER_17_0 VPWR VGND sg13cmos5l_decap_8
XFILLER_21_266 VPWR VGND sg13cmos5l_fill_1
XFILLER_0_126 VPWR VGND sg13cmos5l_decap_8
XFILLER_29_333 VPWR VGND sg13cmos5l_decap_8
XFILLER_28_77 VPWR VGND sg13cmos5l_decap_8
XFILLER_44_336 VPWR VGND sg13cmos5l_decap_8
XFILLER_44_98 VPWR VGND sg13cmos5l_decap_8
XFILLER_44_21 VPWR VGND sg13cmos5l_decap_8
XFILLER_12_266 VPWR VGND sg13cmos5l_decap_8
XFILLER_39_119 VPWR VGND sg13cmos5l_decap_8
XFILLER_47_196 VPWR VGND sg13cmos5l_decap_8
XFILLER_35_303 VPWR VGND sg13cmos5l_decap_8
XFILLER_10_7 VPWR VGND sg13cmos5l_decap_8
XFILLER_41_339 VPWR VGND sg13cmos5l_decap_8
XFILLER_38_196 VPWR VGND sg13cmos5l_decap_8
XFILLER_30_56 VPWR VGND sg13cmos5l_decap_8
XFILLER_14_46 VPWR VGND sg13cmos5l_decap_8
XFILLER_39_21 VPWR VGND sg13cmos5l_decap_8
XFILLER_44_133 VPWR VGND sg13cmos5l_decap_8
XFILLER_39_98 VPWR VGND sg13cmos5l_decap_8
XFILLER_29_196 VPWR VGND sg13cmos5l_decap_8
XFILLER_4_273 VPWR VGND sg13cmos5l_decap_8
XFILLER_35_133 VPWR VGND sg13cmos5l_decap_8
XFILLER_6_91 VPWR VGND sg13cmos5l_decap_8
XFILLER_26_133 VPWR VGND sg13cmos5l_decap_8
XFILLER_41_147 VPWR VGND sg13cmos5l_decap_8
XFILLER_25_67 VPWR VGND sg13cmos5l_decap_8
XFILLER_41_77 VPWR VGND sg13cmos5l_decap_8
XFILLER_1_210 VPWR VGND sg13cmos5l_decap_8
XFILLER_49_203 VPWR VGND sg13cmos5l_decap_8
XFILLER_1_287 VPWR VGND sg13cmos5l_decap_8
XFILLER_32_147 VPWR VGND sg13cmos5l_decap_8
XFILLER_17_133 VPWR VGND sg13cmos5l_decap_8
XFILLER_9_343 VPWR VGND sg13cmos5l_decap_8
XFILLER_9_354 VPWR VGND sg13cmos5l_fill_1
XFILLER_13_350 VPWR VGND sg13cmos5l_decap_8
XFILLER_48_291 VPWR VGND sg13cmos5l_decap_8
XFILLER_23_147 VPWR VGND sg13cmos5l_decap_8
XFILLER_11_14 VPWR VGND sg13cmos5l_decap_8
XFILLER_46_217 VPWR VGND sg13cmos5l_decap_8
XFILLER_39_280 VPWR VGND sg13cmos5l_decap_8
XFILLER_36_77 VPWR VGND sg13cmos5l_decap_8
XFILLER_14_158 VPWR VGND sg13cmos5l_decap_8
XFILLER_6_357 VPWR VGND sg13cmos5l_fill_2
XFILLER_37_228 VPWR VGND sg13cmos5l_decap_8
XFILLER_45_294 VPWR VGND sg13cmos5l_decap_8
XFILLER_9_140 VPWR VGND sg13cmos5l_decap_8
XFILLER_47_0 VPWR VGND sg13cmos5l_decap_8
XFILLER_3_70 VPWR VGND sg13cmos5l_decap_8
XFILLER_36_283 VPWR VGND sg13cmos5l_decap_8
XFILLER_28_217 VPWR VGND sg13cmos5l_decap_8
XFILLER_22_35 VPWR VGND sg13cmos5l_decap_8
XFILLER_47_98 VPWR VGND sg13cmos5l_decap_8
XFILLER_47_21 VPWR VGND sg13cmos5l_decap_8
XFILLER_19_217 VPWR VGND sg13cmos5l_decap_8
XFILLER_42_275 VPWR VGND sg13cmos5l_decap_8
XFILLER_42_231 VPWR VGND sg13cmos5l_decap_8
XFILLER_27_294 VPWR VGND sg13cmos5l_decap_8
X_087_ _087_/Q _089_/CLK _087_/D _087__21/L_HI VPWR VGND sg13cmos5l_dfrbpq_1
XFILLER_6_154 VPWR VGND sg13cmos5l_decap_8
XFILLER_10_161 VPWR VGND sg13cmos5l_decap_8
XFILLER_40_7 VPWR VGND sg13cmos5l_decap_8
XFILLER_33_231 VPWR VGND sg13cmos5l_decap_8
XFILLER_0_308 VPWR VGND sg13cmos5l_decap_8
XFILLER_17_35 VPWR VGND sg13cmos5l_decap_8
XFILLER_24_231 VPWR VGND sg13cmos5l_decap_8
XFILLER_33_56 VPWR VGND sg13cmos5l_decap_8
XFILLER_3_168 VPWR VGND sg13cmos5l_decap_8
XFILLER_47_301 VPWR VGND sg13cmos5l_decap_8
XFILLER_30_245 VPWR VGND sg13cmos5l_decap_8
XFILLER_15_231 VPWR VGND sg13cmos5l_decap_8
XFILLER_38_301 VPWR VGND sg13cmos5l_decap_8
XFILLER_9_91 VPWR VGND sg13cmos5l_decap_8
XFILLER_21_245 VPWR VGND sg13cmos5l_decap_4
XFILLER_0_105 VPWR VGND sg13cmos5l_decap_8
XFILLER_48_109 VPWR VGND sg13cmos5l_decap_8
XFILLER_44_315 VPWR VGND sg13cmos5l_decap_8
XFILLER_29_312 VPWR VGND sg13cmos5l_decap_8
XFILLER_28_56 VPWR VGND sg13cmos5l_decap_8
XFILLER_44_77 VPWR VGND sg13cmos5l_decap_8
XFILLER_12_245 VPWR VGND sg13cmos5l_decap_8
XFILLER_5_49 VPWR VGND sg13cmos5l_decap_8
XFILLER_8_249 VPWR VGND sg13cmos5l_decap_8
XFILLER_47_175 VPWR VGND sg13cmos5l_decap_8
XFILLER_38_175 VPWR VGND sg13cmos5l_decap_8
XFILLER_41_318 VPWR VGND sg13cmos5l_decap_8
XFILLER_14_25 VPWR VGND sg13cmos5l_decap_8
XFILLER_30_35 VPWR VGND sg13cmos5l_decap_8
XFILLER_39_77 VPWR VGND sg13cmos5l_decap_8
XFILLER_44_189 VPWR VGND sg13cmos5l_decap_8
XFILLER_44_112 VPWR VGND sg13cmos5l_decap_8
XFILLER_32_329 VPWR VGND sg13cmos5l_decap_8
XFILLER_29_175 VPWR VGND sg13cmos5l_decap_8
XFILLER_40_340 VPWR VGND sg13cmos5l_decap_8
XFILLER_4_252 VPWR VGND sg13cmos5l_decap_8
XFILLER_35_112 VPWR VGND sg13cmos5l_decap_8
XFILLER_35_189 VPWR VGND sg13cmos5l_decap_8
XFILLER_31_340 VPWR VGND sg13cmos5l_decap_8
XFILLER_6_70 VPWR VGND sg13cmos5l_decap_8
XFILLER_26_112 VPWR VGND sg13cmos5l_decap_8
XFILLER_26_189 VPWR VGND sg13cmos5l_decap_8
XFILLER_41_126 VPWR VGND sg13cmos5l_decap_8
XFILLER_41_56 VPWR VGND sg13cmos5l_decap_8
XFILLER_22_340 VPWR VGND sg13cmos5l_fill_1
XFILLER_25_46 VPWR VGND sg13cmos5l_decap_8
XFILLER_49_259 VPWR VGND sg13cmos5l_decap_8
XFILLER_2_39 VPWR VGND sg13cmos5l_decap_8
XFILLER_1_266 VPWR VGND sg13cmos5l_decap_8
XFILLER_17_112 VPWR VGND sg13cmos5l_decap_8
XFILLER_32_126 VPWR VGND sg13cmos5l_decap_8
XFILLER_17_189 VPWR VGND sg13cmos5l_decap_8
XFILLER_9_322 VPWR VGND sg13cmos5l_decap_8
XFILLER_48_270 VPWR VGND sg13cmos5l_decap_8
XFILLER_23_126 VPWR VGND sg13cmos5l_decap_8
XFILLER_36_56 VPWR VGND sg13cmos5l_decap_8
XFILLER_14_137 VPWR VGND sg13cmos5l_decap_8
XFILLER_6_336 VPWR VGND sg13cmos5l_decap_8
XFILLER_10_343 VPWR VGND sg13cmos5l_decap_8
XFILLER_7_0 VPWR VGND sg13cmos5l_decap_8
XFILLER_37_207 VPWR VGND sg13cmos5l_decap_8
XFILLER_45_273 VPWR VGND sg13cmos5l_decap_8
XFILLER_9_196 VPWR VGND sg13cmos5l_decap_8
XFILLER_36_262 VPWR VGND sg13cmos5l_decap_8
XFILLER_22_14 VPWR VGND sg13cmos5l_decap_8
XFILLER_0_7 VPWR VGND sg13cmos5l_decap_8
XFILLER_47_77 VPWR VGND sg13cmos5l_decap_8
XFILLER_42_210 VPWR VGND sg13cmos5l_decap_8
XFILLER_27_273 VPWR VGND sg13cmos5l_decap_8
X_086_ _086_/Q _086_/CLK _086_/D _086__20/L_HI VPWR VGND sg13cmos5l_dfrbpq_1
XFILLER_6_133 VPWR VGND sg13cmos5l_decap_8
XFILLER_10_140 VPWR VGND sg13cmos5l_decap_8
XFILLER_12_91 VPWR VGND sg13cmos5l_decap_8
XFILLER_33_7 VPWR VGND sg13cmos5l_decap_8
XFILLER_33_210 VPWR VGND sg13cmos5l_decap_8
XFILLER_18_273 VPWR VGND sg13cmos5l_decap_8
XFILLER_17_14 VPWR VGND sg13cmos5l_decap_8
XFILLER_33_35 VPWR VGND sg13cmos5l_decap_8
XFILLER_24_210 VPWR VGND sg13cmos5l_decap_8
XFILLER_3_147 VPWR VGND sg13cmos5l_decap_8
XFILLER_47_357 VPWR VGND sg13cmos5l_fill_2
XFILLER_15_210 VPWR VGND sg13cmos5l_decap_8
XFILLER_30_224 VPWR VGND sg13cmos5l_decap_8
XFILLER_15_287 VPWR VGND sg13cmos5l_decap_8
X_069_ _069_/Y _045_/Y _063_/Y _068_/X VPWR VGND sg13cmos5l_a21oi_1
XFILLER_38_357 VPWR VGND sg13cmos5l_fill_2
XFILLER_31_4 VPWR VGND sg13cmos5l_decap_8
XFILLER_21_224 VPWR VGND sg13cmos5l_decap_8
XFILLER_9_70 VPWR VGND sg13cmos5l_decap_8
XFILLER_28_35 VPWR VGND sg13cmos5l_decap_8
XFILLER_44_56 VPWR VGND sg13cmos5l_decap_8
XFILLER_8_228 VPWR VGND sg13cmos5l_decap_8
XFILLER_12_224 VPWR VGND sg13cmos5l_decap_8
XFILLER_5_28 VPWR VGND sg13cmos5l_decap_8
XFILLER_47_154 VPWR VGND sg13cmos5l_decap_8
XFILLER_35_338 VPWR VGND sg13cmos5l_decap_8
XFILLER_7_294 VPWR VGND sg13cmos5l_decap_8
XFILLER_22_0 VPWR VGND sg13cmos5l_decap_8
XFILLER_38_154 VPWR VGND sg13cmos5l_decap_8
XFILLER_30_14 VPWR VGND sg13cmos5l_decap_8
XFILLER_39_56 VPWR VGND sg13cmos5l_decap_8
XFILLER_29_154 VPWR VGND sg13cmos5l_decap_8
XFILLER_44_168 VPWR VGND sg13cmos5l_decap_8
XFILLER_32_308 VPWR VGND sg13cmos5l_decap_8
XFILLER_17_327 VPWR VGND sg13cmos5l_decap_8
XFILLER_4_231 VPWR VGND sg13cmos5l_decap_8
XFILLER_35_168 VPWR VGND sg13cmos5l_decap_8
XFILLER_41_105 VPWR VGND sg13cmos5l_decap_8
XFILLER_14_319 VPWR VGND sg13cmos5l_decap_8
XFILLER_25_25 VPWR VGND sg13cmos5l_decap_8
XFILLER_26_168 VPWR VGND sg13cmos5l_decap_8
XFILLER_41_35 VPWR VGND sg13cmos5l_decap_8
XFILLER_1_245 VPWR VGND sg13cmos5l_decap_8
XFILLER_49_238 VPWR VGND sg13cmos5l_decap_8
XFILLER_2_18 VPWR VGND sg13cmos5l_decap_8
XFILLER_32_105 VPWR VGND sg13cmos5l_decap_8
XFILLER_9_301 VPWR VGND sg13cmos5l_decap_8
XFILLER_15_91 VPWR VGND sg13cmos5l_decap_8
XFILLER_17_168 VPWR VGND sg13cmos5l_decap_8
XFILLER_40_182 VPWR VGND sg13cmos5l_decap_8
XFILLER_23_105 VPWR VGND sg13cmos5l_decap_8
XFILLER_31_193 VPWR VGND sg13cmos5l_decap_8
XFILLER_11_49 VPWR VGND sg13cmos5l_decap_8
XFILLER_36_35 VPWR VGND sg13cmos5l_decap_8
XFILLER_14_116 VPWR VGND sg13cmos5l_decap_8
XFILLER_6_315 VPWR VGND sg13cmos5l_decap_8
XFILLER_10_322 VPWR VGND sg13cmos5l_decap_8
XFILLER_22_182 VPWR VGND sg13cmos5l_decap_8
XFILLER_45_252 VPWR VGND sg13cmos5l_decap_8
XFILLER_9_175 VPWR VGND sg13cmos5l_decap_8
XFILLER_13_182 VPWR VGND sg13cmos5l_decap_8
XFILLER_36_241 VPWR VGND sg13cmos5l_decap_8
XFILLER_11_119 VPWR VGND sg13cmos5l_decap_8
XFILLER_3_329 VPWR VGND sg13cmos5l_decap_8
XFILLER_47_56 VPWR VGND sg13cmos5l_decap_8
XFILLER_27_252 VPWR VGND sg13cmos5l_decap_8
XFILLER_42_266 VPWR VGND sg13cmos5l_decap_4
XFILLER_8_39 VPWR VGND sg13cmos5l_decap_8
XFILLER_6_189 VPWR VGND sg13cmos5l_decap_8
XFILLER_6_112 VPWR VGND sg13cmos5l_decap_8
XFILLER_2_340 VPWR VGND sg13cmos5l_decap_8
XFILLER_10_196 VPWR VGND sg13cmos5l_decap_8
XFILLER_12_70 VPWR VGND sg13cmos5l_decap_8
X_085_ _085_/Q _085_/CLK _085_/D _085__19/L_HI VPWR VGND sg13cmos5l_dfrbpq_1
XFILLER_26_7 VPWR VGND sg13cmos5l_decap_8
XFILLER_33_266 VPWR VGND sg13cmos5l_decap_8
XFILLER_18_252 VPWR VGND sg13cmos5l_decap_8
XFILLER_33_14 VPWR VGND sg13cmos5l_decap_8
XFILLER_24_266 VPWR VGND sg13cmos5l_decap_8
XFILLER_3_126 VPWR VGND sg13cmos5l_decap_8
XFILLER_47_336 VPWR VGND sg13cmos5l_decap_8
XFILLER_30_203 VPWR VGND sg13cmos5l_decap_8
XFILLER_15_266 VPWR VGND sg13cmos5l_decap_8
XFILLER_23_91 VPWR VGND sg13cmos5l_decap_8
X_068_ _068_/X _068_/A _068_/B VPWR VGND sg13cmos5l_or2_1
XFILLER_38_336 VPWR VGND sg13cmos5l_decap_8
XFILLER_0_84 VPWR VGND sg13cmos5l_decap_8
XFILLER_21_203 VPWR VGND sg13cmos5l_decap_8
XFILLER_28_14 VPWR VGND sg13cmos5l_decap_8
XFILLER_44_35 VPWR VGND sg13cmos5l_decap_8
XFILLER_29_347 VPWR VGND sg13cmos5l_decap_8
XFILLER_12_203 VPWR VGND sg13cmos5l_decap_8
XFILLER_8_207 VPWR VGND sg13cmos5l_decap_8
XFILLER_47_133 VPWR VGND sg13cmos5l_decap_8
XFILLER_35_317 VPWR VGND sg13cmos5l_decap_8
XFILLER_43_350 VPWR VGND sg13cmos5l_decap_8
XFILLER_18_91 VPWR VGND sg13cmos5l_decap_8
XFILLER_7_273 VPWR VGND sg13cmos5l_decap_8
XFILLER_11_280 VPWR VGND sg13cmos5l_decap_8
XFILLER_38_133 VPWR VGND sg13cmos5l_decap_8
XFILLER_15_0 VPWR VGND sg13cmos5l_decap_8
XFILLER_26_339 VPWR VGND sg13cmos5l_decap_8
XFILLER_39_35 VPWR VGND sg13cmos5l_decap_8
XFILLER_29_133 VPWR VGND sg13cmos5l_decap_8
XFILLER_44_147 VPWR VGND sg13cmos5l_decap_8
XFILLER_4_210 VPWR VGND sg13cmos5l_decap_8
XFILLER_4_287 VPWR VGND sg13cmos5l_decap_8
XFILLER_20_81 VPWR VGND sg13cmos5l_decap_8
XFILLER_35_147 VPWR VGND sg13cmos5l_decap_8
XFILLER_16_350 VPWR VGND sg13cmos5l_decap_4
XFILLER_26_147 VPWR VGND sg13cmos5l_decap_8
XFILLER_41_14 VPWR VGND sg13cmos5l_decap_8
XFILLER_49_217 VPWR VGND sg13cmos5l_decap_8
XFILLER_1_224 VPWR VGND sg13cmos5l_decap_8
XFILLER_17_147 VPWR VGND sg13cmos5l_decap_8
XFILLER_40_161 VPWR VGND sg13cmos5l_decap_8
XFILLER_15_70 VPWR VGND sg13cmos5l_decap_8
XFILLER_31_172 VPWR VGND sg13cmos5l_decap_8
XFILLER_11_28 VPWR VGND sg13cmos5l_decap_8
XFILLER_39_294 VPWR VGND sg13cmos5l_decap_8
XFILLER_36_14 VPWR VGND sg13cmos5l_decap_8
XFILLER_10_301 VPWR VGND sg13cmos5l_decap_8
XFILLER_22_161 VPWR VGND sg13cmos5l_decap_8
XFILLER_45_231 VPWR VGND sg13cmos5l_decap_8
XFILLER_26_91 VPWR VGND sg13cmos5l_decap_8
XFILLER_9_154 VPWR VGND sg13cmos5l_decap_8
XFILLER_13_161 VPWR VGND sg13cmos5l_decap_8
XFILLER_20_109 VPWR VGND sg13cmos5l_decap_8
XFILLER_3_84 VPWR VGND sg13cmos5l_decap_8
XFILLER_36_297 VPWR VGND sg13cmos5l_decap_8
XFILLER_3_308 VPWR VGND sg13cmos5l_decap_8
XFILLER_22_49 VPWR VGND sg13cmos5l_decap_8
XFILLER_47_35 VPWR VGND sg13cmos5l_decap_8
XFILLER_42_245 VPWR VGND sg13cmos5l_decap_8
XFILLER_27_231 VPWR VGND sg13cmos5l_decap_8
XFILLER_42_289 VPWR VGND sg13cmos5l_decap_8
XFILLER_8_18 VPWR VGND sg13cmos5l_decap_8
XFILLER_10_175 VPWR VGND sg13cmos5l_decap_8
XFILLER_6_168 VPWR VGND sg13cmos5l_decap_8
X_084_ _084_/Q _085_/CLK _084_/D _084__18/L_HI VPWR VGND sg13cmos5l_dfrbpq_1
XFILLER_19_7 VPWR VGND sg13cmos5l_decap_8
XFILLER_18_231 VPWR VGND sg13cmos5l_decap_8
XFILLER_33_245 VPWR VGND sg13cmos5l_decap_8
XFILLER_45_0 VPWR VGND sg13cmos5l_decap_8
XFILLER_17_49 VPWR VGND sg13cmos5l_decap_8
XFILLER_24_245 VPWR VGND sg13cmos5l_decap_8
XFILLER_3_105 VPWR VGND sg13cmos5l_decap_8
XFILLER_47_315 VPWR VGND sg13cmos5l_decap_8
XFILLER_15_245 VPWR VGND sg13cmos5l_decap_8
XFILLER_30_259 VPWR VGND sg13cmos5l_decap_8
XFILLER_23_70 VPWR VGND sg13cmos5l_decap_8
XFILLER_2_193 VPWR VGND sg13cmos5l_decap_8
X_074__22 _074__22/L_HI VPWR VGND sg13cmos5l_tiehi
X_067_ _068_/B _075_/Q _056_/B _066_/Y VPWR VGND sg13cmos5l_o21ai_1
XFILLER_38_315 VPWR VGND sg13cmos5l_decap_8
XFILLER_0_63 VPWR VGND sg13cmos5l_decap_8
X_080__25 _080__25/L_HI VPWR VGND sg13cmos5l_tiehi
XFILLER_29_326 VPWR VGND sg13cmos5l_decap_8
XFILLER_0_119 VPWR VGND sg13cmos5l_decap_8
XFILLER_44_329 VPWR VGND sg13cmos5l_decap_8
XFILLER_44_14 VPWR VGND sg13cmos5l_decap_8
XFILLER_12_259 VPWR VGND sg13cmos5l_decap_8
XFILLER_47_189 VPWR VGND sg13cmos5l_decap_8
XFILLER_47_112 VPWR VGND sg13cmos5l_decap_8
XFILLER_18_70 VPWR VGND sg13cmos5l_decap_8
XFILLER_34_91 VPWR VGND sg13cmos5l_decap_8
XFILLER_7_252 VPWR VGND sg13cmos5l_decap_8
XFILLER_38_112 VPWR VGND sg13cmos5l_decap_8
XFILLER_38_189 VPWR VGND sg13cmos5l_decap_8
XFILLER_14_39 VPWR VGND sg13cmos5l_decap_8
XFILLER_39_14 VPWR VGND sg13cmos5l_decap_8
XFILLER_30_49 VPWR VGND sg13cmos5l_decap_8
XFILLER_44_126 VPWR VGND sg13cmos5l_decap_8
XFILLER_29_112 VPWR VGND sg13cmos5l_decap_8
XFILLER_29_189 VPWR VGND sg13cmos5l_decap_8
XFILLER_40_354 VPWR VGND sg13cmos5l_decap_4
XFILLER_4_266 VPWR VGND sg13cmos5l_decap_8
XFILLER_20_60 VPWR VGND sg13cmos5l_decap_8
XFILLER_35_126 VPWR VGND sg13cmos5l_decap_8
XFILLER_29_91 VPWR VGND sg13cmos5l_decap_8
XFILLER_31_354 VPWR VGND sg13cmos5l_decap_4
XFILLER_6_84 VPWR VGND sg13cmos5l_decap_8
XFILLER_26_126 VPWR VGND sg13cmos5l_decap_8
XFILLER_22_332 VPWR VGND sg13cmos5l_fill_2
XFILLER_1_203 VPWR VGND sg13cmos5l_decap_8
XFILLER_17_126 VPWR VGND sg13cmos5l_decap_8
XFILLER_40_140 VPWR VGND sg13cmos5l_decap_8
XFILLER_9_336 VPWR VGND sg13cmos5l_decap_8
XFILLER_13_343 VPWR VGND sg13cmos5l_decap_8
XFILLER_49_7 VPWR VGND sg13cmos5l_decap_8
XFILLER_31_81 VPWR VGND sg13cmos5l_decap_8
XFILLER_48_284 VPWR VGND sg13cmos5l_decap_8
XFILLER_0_280 VPWR VGND sg13cmos5l_decap_8
XFILLER_31_151 VPWR VGND sg13cmos5l_decap_8
XFILLER_39_273 VPWR VGND sg13cmos5l_decap_8
XFILLER_10_357 VPWR VGND sg13cmos5l_fill_2
XFILLER_22_140 VPWR VGND sg13cmos5l_decap_8
XFILLER_45_210 VPWR VGND sg13cmos5l_decap_8
XFILLER_45_287 VPWR VGND sg13cmos5l_decap_8
XFILLER_13_140 VPWR VGND sg13cmos5l_decap_8
XFILLER_26_70 VPWR VGND sg13cmos5l_decap_8
XFILLER_42_91 VPWR VGND sg13cmos5l_decap_8
XFILLER_9_133 VPWR VGND sg13cmos5l_decap_8
XFILLER_5_350 VPWR VGND sg13cmos5l_decap_8
XFILLER_3_63 VPWR VGND sg13cmos5l_decap_8
XFILLER_36_276 VPWR VGND sg13cmos5l_decap_8
XFILLER_36_210 VPWR VGND sg13cmos5l_decap_8
XFILLER_22_28 VPWR VGND sg13cmos5l_decap_8
XFILLER_47_14 VPWR VGND sg13cmos5l_decap_8
XFILLER_27_210 VPWR VGND sg13cmos5l_decap_8
XFILLER_42_224 VPWR VGND sg13cmos5l_decap_8
XFILLER_27_287 VPWR VGND sg13cmos5l_decap_8
X_083_ _083_/Q _086_/CLK _083_/D _083__17/L_HI VPWR VGND sg13cmos5l_dfrbpq_1
X_086__20 _086__20/L_HI VPWR VGND sg13cmos5l_tiehi
XFILLER_6_147 VPWR VGND sg13cmos5l_decap_8
XFILLER_10_154 VPWR VGND sg13cmos5l_decap_8
XFILLER_5_0 VPWR VGND sg13cmos5l_decap_8
XFILLER_18_210 VPWR VGND sg13cmos5l_decap_8
XFILLER_33_224 VPWR VGND sg13cmos5l_decap_8
XFILLER_18_287 VPWR VGND sg13cmos5l_fill_2
XFILLER_38_0 VPWR VGND sg13cmos5l_decap_8
XFILLER_17_28 VPWR VGND sg13cmos5l_decap_8
XFILLER_24_224 VPWR VGND sg13cmos5l_decap_8
XFILLER_33_49 VPWR VGND sg13cmos5l_decap_8
XFILLER_30_238 VPWR VGND sg13cmos5l_decap_8
XFILLER_15_224 VPWR VGND sg13cmos5l_decap_8
XFILLER_23_290 VPWR VGND sg13cmos5l_fill_2
X_066_ _066_/Y _066_/A _077_/Q _076_/Q _075_/Q VPWR VGND sg13cmos5l_nand4_1
XFILLER_2_172 VPWR VGND sg13cmos5l_decap_8
XFILLER_0_42 VPWR VGND sg13cmos5l_decap_8
XFILLER_9_84 VPWR VGND sg13cmos5l_decap_8
XFILLER_21_238 VPWR VGND sg13cmos5l_decap_8
XFILLER_44_308 VPWR VGND sg13cmos5l_decap_8
XFILLER_29_305 VPWR VGND sg13cmos5l_decap_8
XFILLER_28_49 VPWR VGND sg13cmos5l_decap_8
XFILLER_12_238 VPWR VGND sg13cmos5l_decap_8
XFILLER_47_168 VPWR VGND sg13cmos5l_decap_8
XFILLER_34_70 VPWR VGND sg13cmos5l_decap_8
XFILLER_7_231 VPWR VGND sg13cmos5l_decap_8
X_049_ _049_/Y _075_/Q _074_/Q VPWR VGND sg13cmos5l_nor2b_1
XFILLER_38_168 VPWR VGND sg13cmos5l_decap_8
XFILLER_14_18 VPWR VGND sg13cmos5l_decap_8
XFILLER_30_28 VPWR VGND sg13cmos5l_decap_8
XFILLER_44_105 VPWR VGND sg13cmos5l_decap_8
XFILLER_29_168 VPWR VGND sg13cmos5l_decap_8
XFILLER_40_333 VPWR VGND sg13cmos5l_decap_8
XFILLER_4_245 VPWR VGND sg13cmos5l_decap_8
XFILLER_29_70 VPWR VGND sg13cmos5l_decap_8
XFILLER_45_91 VPWR VGND sg13cmos5l_decap_8
XFILLER_43_182 VPWR VGND sg13cmos5l_decap_8
XFILLER_35_105 VPWR VGND sg13cmos5l_decap_8
XFILLER_31_333 VPWR VGND sg13cmos5l_decap_8
XFILLER_6_63 VPWR VGND sg13cmos5l_decap_8
XFILLER_26_105 VPWR VGND sg13cmos5l_decap_8
XFILLER_41_119 VPWR VGND sg13cmos5l_decap_8
XFILLER_34_182 VPWR VGND sg13cmos5l_decap_8
XFILLER_25_39 VPWR VGND sg13cmos5l_decap_8
XFILLER_41_49 VPWR VGND sg13cmos5l_decap_8
XFILLER_9_7 VPWR VGND sg13cmos5l_decap_8
XFILLER_1_259 VPWR VGND sg13cmos5l_decap_8
XFILLER_32_119 VPWR VGND sg13cmos5l_decap_8
XFILLER_13_322 VPWR VGND sg13cmos5l_decap_8
XFILLER_17_105 VPWR VGND sg13cmos5l_decap_8
XFILLER_25_193 VPWR VGND sg13cmos5l_decap_8
XFILLER_40_196 VPWR VGND sg13cmos5l_decap_8
XFILLER_31_60 VPWR VGND sg13cmos5l_decap_8
XFILLER_9_315 VPWR VGND sg13cmos5l_decap_8
XFILLER_48_263 VPWR VGND sg13cmos5l_decap_8
XFILLER_31_130 VPWR VGND sg13cmos5l_decap_8
XFILLER_16_182 VPWR VGND sg13cmos5l_decap_8
XFILLER_23_119 VPWR VGND sg13cmos5l_decap_8
XFILLER_39_252 VPWR VGND sg13cmos5l_decap_8
XFILLER_36_49 VPWR VGND sg13cmos5l_decap_8
XFILLER_6_329 VPWR VGND sg13cmos5l_decap_8
XFILLER_10_336 VPWR VGND sg13cmos5l_decap_8
XFILLER_22_196 VPWR VGND sg13cmos5l_decap_8
XFILLER_45_266 VPWR VGND sg13cmos5l_decap_8
XFILLER_9_112 VPWR VGND sg13cmos5l_decap_8
XFILLER_42_70 VPWR VGND sg13cmos5l_decap_8
XFILLER_9_189 VPWR VGND sg13cmos5l_decap_8
XFILLER_13_196 VPWR VGND sg13cmos5l_decap_8
XFILLER_3_42 VPWR VGND sg13cmos5l_decap_8
XFILLER_36_255 VPWR VGND sg13cmos5l_decap_8
XFILLER_36_233 VPWR VGND sg13cmos5l_decap_4
XFILLER_42_203 VPWR VGND sg13cmos5l_decap_8
XFILLER_27_266 VPWR VGND sg13cmos5l_decap_8
X_082_ _082_/Q _086_/CLK _082_/D _082__23/L_HI VPWR VGND sg13cmos5l_dfrbpq_1
XFILLER_6_126 VPWR VGND sg13cmos5l_decap_8
XFILLER_10_133 VPWR VGND sg13cmos5l_decap_8
XFILLER_12_84 VPWR VGND sg13cmos5l_decap_8
XFILLER_2_354 VPWR VGND sg13cmos5l_decap_4
XFILLER_37_81 VPWR VGND sg13cmos5l_decap_8
XFILLER_33_203 VPWR VGND sg13cmos5l_decap_8
XFILLER_18_266 VPWR VGND sg13cmos5l_decap_8
XFILLER_33_28 VPWR VGND sg13cmos5l_decap_8
XFILLER_24_203 VPWR VGND sg13cmos5l_decap_8
XFILLER_32_280 VPWR VGND sg13cmos5l_decap_8
XFILLER_15_203 VPWR VGND sg13cmos5l_decap_8
XFILLER_30_217 VPWR VGND sg13cmos5l_decap_8
X_065_ _065_/Y _046_/Y _059_/Y _062_/X _058_/B _064_/Y VPWR VGND sg13cmos5l_a221oi_1
XFILLER_2_151 VPWR VGND sg13cmos5l_decap_8
XFILLER_24_7 VPWR VGND sg13cmos5l_decap_8
XFILLER_46_350 VPWR VGND sg13cmos5l_decap_8
XFILLER_0_21 VPWR VGND sg13cmos5l_decap_8
XFILLER_0_98 VPWR VGND sg13cmos5l_decap_8
XFILLER_21_217 VPWR VGND sg13cmos5l_decap_8
XFILLER_9_63 VPWR VGND sg13cmos5l_decap_8
XFILLER_14_291 VPWR VGND sg13cmos5l_decap_8
XFILLER_28_28 VPWR VGND sg13cmos5l_decap_8
XFILLER_44_49 VPWR VGND sg13cmos5l_decap_8
XFILLER_12_217 VPWR VGND sg13cmos5l_decap_8
XFILLER_47_147 VPWR VGND sg13cmos5l_decap_8
XFILLER_7_210 VPWR VGND sg13cmos5l_decap_8
XFILLER_11_294 VPWR VGND sg13cmos5l_decap_8
XFILLER_7_287 VPWR VGND sg13cmos5l_decap_8
X_048_ _068_/A _073_/A VPWR VGND sg13cmos5l_inv_1
XFILLER_38_147 VPWR VGND sg13cmos5l_decap_8
XFILLER_34_342 VPWR VGND sg13cmos5l_decap_8
XFILLER_39_49 VPWR VGND sg13cmos5l_decap_8
XFILLER_25_342 VPWR VGND sg13cmos5l_decap_8
XFILLER_29_147 VPWR VGND sg13cmos5l_decap_8
XFILLER_40_312 VPWR VGND sg13cmos5l_decap_8
XFILLER_4_224 VPWR VGND sg13cmos5l_decap_8
XFILLER_20_95 VPWR VGND sg13cmos5l_decap_8
XFILLER_45_70 VPWR VGND sg13cmos5l_decap_8
XFILLER_43_161 VPWR VGND sg13cmos5l_decap_8
XFILLER_31_312 VPWR VGND sg13cmos5l_decap_8
XFILLER_6_42 VPWR VGND sg13cmos5l_decap_8
XFILLER_34_161 VPWR VGND sg13cmos5l_decap_8
XFILLER_13_0 VPWR VGND sg13cmos5l_decap_8
XFILLER_25_18 VPWR VGND sg13cmos5l_decap_8
XFILLER_41_28 VPWR VGND sg13cmos5l_decap_8
XFILLER_22_334 VPWR VGND sg13cmos5l_fill_1
XFILLER_1_238 VPWR VGND sg13cmos5l_decap_8
XFILLER_13_301 VPWR VGND sg13cmos5l_decap_8
XFILLER_15_84 VPWR VGND sg13cmos5l_decap_8
XFILLER_25_172 VPWR VGND sg13cmos5l_decap_8
XFILLER_40_175 VPWR VGND sg13cmos5l_decap_8
XFILLER_48_242 VPWR VGND sg13cmos5l_decap_8
XFILLER_31_186 VPWR VGND sg13cmos5l_decap_8
XFILLER_16_161 VPWR VGND sg13cmos5l_decap_8
XFILLER_39_231 VPWR VGND sg13cmos5l_decap_8
XFILLER_36_28 VPWR VGND sg13cmos5l_decap_8
XFILLER_14_109 VPWR VGND sg13cmos5l_decap_8
XFILLER_6_308 VPWR VGND sg13cmos5l_decap_8
XFILLER_10_315 VPWR VGND sg13cmos5l_decap_8
XFILLER_22_175 VPWR VGND sg13cmos5l_decap_8
XFILLER_45_245 VPWR VGND sg13cmos5l_decap_8
XFILLER_13_175 VPWR VGND sg13cmos5l_decap_8
XFILLER_9_168 VPWR VGND sg13cmos5l_decap_8
XFILLER_3_98 VPWR VGND sg13cmos5l_decap_8
XFILLER_3_21 VPWR VGND sg13cmos5l_decap_8
XFILLER_47_49 VPWR VGND sg13cmos5l_decap_8
XFILLER_27_245 VPWR VGND sg13cmos5l_decap_8
XFILLER_42_259 VPWR VGND sg13cmos5l_decap_8
XFILLER_10_112 VPWR VGND sg13cmos5l_decap_8
XFILLER_6_105 VPWR VGND sg13cmos5l_decap_8
XFILLER_10_189 VPWR VGND sg13cmos5l_decap_8
XFILLER_12_63 VPWR VGND sg13cmos5l_decap_8
X_081_ _081_/Q _085_/CLK _081_/D _081__27/L_HI VPWR VGND sg13cmos5l_dfrbpq_1
XFILLER_2_333 VPWR VGND sg13cmos5l_decap_8
XFILLER_37_60 VPWR VGND sg13cmos5l_decap_8
XFILLER_33_259 VPWR VGND sg13cmos5l_decap_8
XFILLER_18_245 VPWR VGND sg13cmos5l_decap_8
XFILLER_18_289 VPWR VGND sg13cmos5l_fill_1
XFILLER_5_182 VPWR VGND sg13cmos5l_decap_8
XFILLER_24_259 VPWR VGND sg13cmos5l_decap_8
XFILLER_3_119 VPWR VGND sg13cmos5l_decap_8
XFILLER_47_329 VPWR VGND sg13cmos5l_decap_8
XFILLER_15_259 VPWR VGND sg13cmos5l_decap_8
XFILLER_23_84 VPWR VGND sg13cmos5l_decap_8
XFILLER_2_130 VPWR VGND sg13cmos5l_decap_8
X_064_ _064_/Y _075_/Q _056_/B _073_/A VPWR VGND sg13cmos5l_o21ai_1
XFILLER_48_81 VPWR VGND sg13cmos5l_decap_8
XFILLER_38_329 VPWR VGND sg13cmos5l_decap_8
XFILLER_17_7 VPWR VGND sg13cmos5l_decap_8
XFILLER_0_77 VPWR VGND sg13cmos5l_decap_8
XFILLER_9_42 VPWR VGND sg13cmos5l_decap_8
XFILLER_14_270 VPWR VGND sg13cmos5l_decap_8
XFILLER_43_0 VPWR VGND sg13cmos5l_decap_8
XFILLER_44_28 VPWR VGND sg13cmos5l_decap_8
XFILLER_37_340 VPWR VGND sg13cmos5l_decap_8
XFILLER_47_126 VPWR VGND sg13cmos5l_decap_8
XFILLER_43_343 VPWR VGND sg13cmos5l_decap_8
XFILLER_18_84 VPWR VGND sg13cmos5l_decap_8
XFILLER_7_266 VPWR VGND sg13cmos5l_decap_8
XFILLER_11_273 VPWR VGND sg13cmos5l_decap_8
X_047_ _047_/Y _055_/B VPWR VGND sg13cmos5l_inv_1
XFILLER_38_126 VPWR VGND sg13cmos5l_decap_8
XFILLER_34_321 VPWR VGND sg13cmos5l_decap_8
XFILLER_19_351 VPWR VGND sg13cmos5l_decap_8
XFILLER_39_28 VPWR VGND sg13cmos5l_decap_8
XFILLER_29_126 VPWR VGND sg13cmos5l_decap_8
XFILLER_4_203 VPWR VGND sg13cmos5l_decap_8
XFILLER_20_74 VPWR VGND sg13cmos5l_decap_8
XFILLER_43_140 VPWR VGND sg13cmos5l_decap_8
XFILLER_16_343 VPWR VGND sg13cmos5l_decap_8
XFILLER_16_354 VPWR VGND sg13cmos5l_fill_1
XFILLER_6_98 VPWR VGND sg13cmos5l_decap_8
XFILLER_6_21 VPWR VGND sg13cmos5l_decap_8
XFILLER_3_280 VPWR VGND sg13cmos5l_decap_8
XFILLER_34_140 VPWR VGND sg13cmos5l_decap_8
XFILLER_1_217 VPWR VGND sg13cmos5l_decap_8
XFILLER_40_154 VPWR VGND sg13cmos5l_decap_8
XFILLER_13_357 VPWR VGND sg13cmos5l_fill_2
XFILLER_15_63 VPWR VGND sg13cmos5l_decap_8
XFILLER_25_151 VPWR VGND sg13cmos5l_decap_8
XFILLER_31_95 VPWR VGND sg13cmos5l_decap_8
XFILLER_48_221 VPWR VGND sg13cmos5l_decap_8
XFILLER_0_294 VPWR VGND sg13cmos5l_decap_8
XFILLER_48_298 VPWR VGND sg13cmos5l_decap_8
XFILLER_16_140 VPWR VGND sg13cmos5l_decap_8
XFILLER_31_165 VPWR VGND sg13cmos5l_decap_8
XFILLER_39_287 VPWR VGND sg13cmos5l_decap_8
XFILLER_39_210 VPWR VGND sg13cmos5l_decap_8
XFILLER_22_154 VPWR VGND sg13cmos5l_decap_8
XFILLER_45_224 VPWR VGND sg13cmos5l_decap_8
XFILLER_26_84 VPWR VGND sg13cmos5l_decap_8
XFILLER_9_147 VPWR VGND sg13cmos5l_decap_8
XFILLER_13_154 VPWR VGND sg13cmos5l_decap_8
XFILLER_47_7 VPWR VGND sg13cmos5l_decap_8
XFILLER_3_77 VPWR VGND sg13cmos5l_decap_8
XFILLER_47_28 VPWR VGND sg13cmos5l_decap_8
XFILLER_27_224 VPWR VGND sg13cmos5l_decap_8
XFILLER_42_238 VPWR VGND sg13cmos5l_decap_8
X_080_ _080_/Q _086_/CLK _080_/D _080__25/L_HI VPWR VGND sg13cmos5l_dfrbpq_1
XFILLER_10_168 VPWR VGND sg13cmos5l_decap_8
XFILLER_2_312 VPWR VGND sg13cmos5l_decap_8
XFILLER_12_42 VPWR VGND sg13cmos5l_decap_8
XFILLER_18_224 VPWR VGND sg13cmos5l_decap_8
XFILLER_33_238 VPWR VGND sg13cmos5l_decap_8
XFILLER_5_161 VPWR VGND sg13cmos5l_decap_8
XFILLER_24_238 VPWR VGND sg13cmos5l_decap_8
XFILLER_47_308 VPWR VGND sg13cmos5l_decap_8
XFILLER_15_238 VPWR VGND sg13cmos5l_decap_8
XFILLER_23_63 VPWR VGND sg13cmos5l_decap_8
X_063_ _063_/Y _077_/Q _076_/Q _063_/C VPWR VGND sg13cmos5l_nand3_1
XFILLER_3_0 VPWR VGND sg13cmos5l_decap_8
XFILLER_2_186 VPWR VGND sg13cmos5l_decap_8
XFILLER_48_60 VPWR VGND sg13cmos5l_decap_8
XFILLER_38_308 VPWR VGND sg13cmos5l_decap_8
XFILLER_0_56 VPWR VGND sg13cmos5l_decap_8
XFILLER_9_21 VPWR VGND sg13cmos5l_decap_8
XFILLER_9_98 VPWR VGND sg13cmos5l_decap_8
XFILLER_36_0 VPWR VGND sg13cmos5l_decap_8
XFILLER_29_319 VPWR VGND sg13cmos5l_decap_8
XFILLER_47_105 VPWR VGND sg13cmos5l_decap_8
XFILLER_28_352 VPWR VGND sg13cmos5l_decap_8
XFILLER_18_63 VPWR VGND sg13cmos5l_decap_8
XFILLER_43_322 VPWR VGND sg13cmos5l_decap_8
XFILLER_34_84 VPWR VGND sg13cmos5l_decap_8
XFILLER_7_245 VPWR VGND sg13cmos5l_decap_8
XFILLER_11_252 VPWR VGND sg13cmos5l_decap_8
X_046_ _046_/Y _062_/A VPWR VGND sg13cmos5l_inv_1
XFILLER_38_105 VPWR VGND sg13cmos5l_decap_8
XFILLER_46_182 VPWR VGND sg13cmos5l_decap_8
XFILLER_34_300 VPWR VGND sg13cmos5l_decap_8
XFILLER_19_330 VPWR VGND sg13cmos5l_decap_8
XFILLER_44_119 VPWR VGND sg13cmos5l_decap_8
XFILLER_29_105 VPWR VGND sg13cmos5l_decap_8
XFILLER_40_358 VPWR VGND sg13cmos5l_fill_1
XFILLER_40_347 VPWR VGND sg13cmos5l_decap_8
XFILLER_37_193 VPWR VGND sg13cmos5l_decap_8
XFILLER_25_311 VPWR VGND sg13cmos5l_fill_1
XFILLER_4_259 VPWR VGND sg13cmos5l_decap_8
Xhold40 _074_/D _054_/Y VPWR VGND sg13cmos5l_dlygate4sd3_1
XFILLER_20_53 VPWR VGND sg13cmos5l_decap_8
XFILLER_35_119 VPWR VGND sg13cmos5l_decap_8
XFILLER_16_322 VPWR VGND sg13cmos5l_decap_8
XFILLER_29_84 VPWR VGND sg13cmos5l_decap_8
XFILLER_28_182 VPWR VGND sg13cmos5l_decap_8
XFILLER_43_196 VPWR VGND sg13cmos5l_decap_8
XFILLER_31_358 VPWR VGND sg13cmos5l_fill_1
XFILLER_31_347 VPWR VGND sg13cmos5l_decap_8
XFILLER_6_77 VPWR VGND sg13cmos5l_decap_8
XFILLER_26_119 VPWR VGND sg13cmos5l_decap_8
XFILLER_34_196 VPWR VGND sg13cmos5l_decap_8
XFILLER_19_182 VPWR VGND sg13cmos5l_decap_8
XFILLER_17_119 VPWR VGND sg13cmos5l_decap_8
XFILLER_25_130 VPWR VGND sg13cmos5l_decap_8
XFILLER_40_133 VPWR VGND sg13cmos5l_decap_8
XFILLER_9_329 VPWR VGND sg13cmos5l_decap_8
XFILLER_13_336 VPWR VGND sg13cmos5l_decap_8
XFILLER_15_42 VPWR VGND sg13cmos5l_decap_8
XFILLER_31_74 VPWR VGND sg13cmos5l_decap_8
XFILLER_48_277 VPWR VGND sg13cmos5l_decap_8
XFILLER_48_200 VPWR VGND sg13cmos5l_decap_8
XFILLER_0_273 VPWR VGND sg13cmos5l_decap_8
XFILLER_16_196 VPWR VGND sg13cmos5l_decap_8
XFILLER_31_144 VPWR VGND sg13cmos5l_decap_8
XFILLER_8_340 VPWR VGND sg13cmos5l_decap_8
.ends
